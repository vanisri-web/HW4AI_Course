* NGSPICE file created from synth_top.ext - technology: sky130A

* Black-box entry subcircuit for sky130_fd_sc_hd__fill_1 abstract view
.subckt sky130_fd_sc_hd__fill_1 VGND VNB VPB VPWR
.ends

* Black-box entry subcircuit for sky130_fd_sc_hd__nand2_1 abstract view
.subckt sky130_fd_sc_hd__nand2_1 A B VGND VNB VPB VPWR Y
.ends

* Black-box entry subcircuit for sky130_ef_sc_hd__decap_12 abstract view
.subckt sky130_ef_sc_hd__decap_12 VPWR VGND VPB VNB
.ends

* Black-box entry subcircuit for sky130_fd_sc_hd__and4_1 abstract view
.subckt sky130_fd_sc_hd__and4_1 A B C D VGND VNB VPB VPWR X
.ends

* Black-box entry subcircuit for sky130_fd_sc_hd__decap_4 abstract view
.subckt sky130_fd_sc_hd__decap_4 VGND VNB VPB VPWR
.ends

* Black-box entry subcircuit for sky130_fd_sc_hd__or4_1 abstract view
.subckt sky130_fd_sc_hd__or4_1 A B C D VGND VNB VPB VPWR X
.ends

* Black-box entry subcircuit for sky130_fd_sc_hd__decap_3 abstract view
.subckt sky130_fd_sc_hd__decap_3 VGND VNB VPB VPWR
.ends

* Black-box entry subcircuit for sky130_fd_sc_hd__nor2_1 abstract view
.subckt sky130_fd_sc_hd__nor2_1 A B VGND VNB VPB VPWR Y
.ends

* Black-box entry subcircuit for sky130_fd_sc_hd__nand2b_1 abstract view
.subckt sky130_fd_sc_hd__nand2b_1 A_N B VGND VNB VPB VPWR Y
.ends

* Black-box entry subcircuit for sky130_fd_sc_hd__tapvpwrvgnd_1 abstract view
.subckt sky130_fd_sc_hd__tapvpwrvgnd_1 VGND VPWR
.ends

* Black-box entry subcircuit for sky130_fd_sc_hd__decap_8 abstract view
.subckt sky130_fd_sc_hd__decap_8 VGND VNB VPB VPWR
.ends

* Black-box entry subcircuit for sky130_fd_sc_hd__a22o_1 abstract view
.subckt sky130_fd_sc_hd__a22o_1 A1 A2 B1 B2 VGND VNB VPB VPWR X
.ends

* Black-box entry subcircuit for sky130_fd_sc_hd__or3_1 abstract view
.subckt sky130_fd_sc_hd__or3_1 A B C VGND VNB VPB VPWR X
.ends

* Black-box entry subcircuit for sky130_fd_sc_hd__a21oi_1 abstract view
.subckt sky130_fd_sc_hd__a21oi_1 A1 A2 B1 VGND VNB VPB VPWR Y
.ends

* Black-box entry subcircuit for sky130_fd_sc_hd__xnor2_1 abstract view
.subckt sky130_fd_sc_hd__xnor2_1 A B VGND VNB VPB VPWR Y
.ends

* Black-box entry subcircuit for sky130_fd_sc_hd__fill_2 abstract view
.subckt sky130_fd_sc_hd__fill_2 VGND VNB VPB VPWR
.ends

* Black-box entry subcircuit for sky130_fd_sc_hd__o21a_1 abstract view
.subckt sky130_fd_sc_hd__o21a_1 A1 A2 B1 VGND VNB VPB VPWR X
.ends

* Black-box entry subcircuit for sky130_fd_sc_hd__nor3_1 abstract view
.subckt sky130_fd_sc_hd__nor3_1 A B C VGND VNB VPB VPWR Y
.ends

* Black-box entry subcircuit for sky130_fd_sc_hd__and3_1 abstract view
.subckt sky130_fd_sc_hd__and3_1 A B C VGND VNB VPB VPWR X
.ends

* Black-box entry subcircuit for sky130_fd_sc_hd__o211a_1 abstract view
.subckt sky130_fd_sc_hd__o211a_1 A1 A2 B1 C1 VGND VNB VPB VPWR X
.ends

* Black-box entry subcircuit for sky130_fd_sc_hd__a21o_1 abstract view
.subckt sky130_fd_sc_hd__a21o_1 A1 A2 B1 VGND VNB VPB VPWR X
.ends

* Black-box entry subcircuit for sky130_fd_sc_hd__a211oi_1 abstract view
.subckt sky130_fd_sc_hd__a211oi_1 A1 A2 B1 C1 VGND VNB VPB VPWR Y
.ends

* Black-box entry subcircuit for sky130_fd_sc_hd__a21bo_1 abstract view
.subckt sky130_fd_sc_hd__a21bo_1 A1 A2 B1_N VGND VNB VPB VPWR X
.ends

* Black-box entry subcircuit for sky130_fd_sc_hd__decap_6 abstract view
.subckt sky130_fd_sc_hd__decap_6 VGND VNB VPB VPWR
.ends

* Black-box entry subcircuit for sky130_fd_sc_hd__and2b_1 abstract view
.subckt sky130_fd_sc_hd__and2b_1 A_N B VGND VNB VPB VPWR X
.ends

* Black-box entry subcircuit for sky130_fd_sc_hd__or2_1 abstract view
.subckt sky130_fd_sc_hd__or2_1 A B VGND VNB VPB VPWR X
.ends

* Black-box entry subcircuit for sky130_fd_sc_hd__o21bai_2 abstract view
.subckt sky130_fd_sc_hd__o21bai_2 A1 A2 B1_N VGND VNB VPB VPWR Y
.ends

* Black-box entry subcircuit for sky130_fd_sc_hd__and4bb_1 abstract view
.subckt sky130_fd_sc_hd__and4bb_1 A_N B_N C D VGND VNB VPB VPWR X
.ends

* Black-box entry subcircuit for sky130_fd_sc_hd__inv_2 abstract view
.subckt sky130_fd_sc_hd__inv_2 A VGND VNB VPB VPWR Y
.ends

* Black-box entry subcircuit for sky130_fd_sc_hd__nand3_1 abstract view
.subckt sky130_fd_sc_hd__nand3_1 A B C VGND VNB VPB VPWR Y
.ends

* Black-box entry subcircuit for sky130_fd_sc_hd__a22oi_1 abstract view
.subckt sky130_fd_sc_hd__a22oi_1 A1 A2 B1 B2 VGND VNB VPB VPWR Y
.ends

* Black-box entry subcircuit for sky130_fd_sc_hd__and2_1 abstract view
.subckt sky130_fd_sc_hd__and2_1 A B VGND VNB VPB VPWR X
.ends

* Black-box entry subcircuit for sky130_fd_sc_hd__buf_4 abstract view
.subckt sky130_fd_sc_hd__buf_4 A VGND VNB VPB VPWR X
.ends

* Black-box entry subcircuit for sky130_fd_sc_hd__buf_2 abstract view
.subckt sky130_fd_sc_hd__buf_2 A VGND VNB VPB VPWR X
.ends

* Black-box entry subcircuit for sky130_fd_sc_hd__clkbuf_4 abstract view
.subckt sky130_fd_sc_hd__clkbuf_4 A VGND VNB VPB VPWR X
.ends

* Black-box entry subcircuit for sky130_fd_sc_hd__clkbuf_2 abstract view
.subckt sky130_fd_sc_hd__clkbuf_2 A VGND VNB VPB VPWR X
.ends

* Black-box entry subcircuit for sky130_fd_sc_hd__xor2_1 abstract view
.subckt sky130_fd_sc_hd__xor2_1 A B VGND VNB VPB VPWR X
.ends

* Black-box entry subcircuit for sky130_fd_sc_hd__and3b_1 abstract view
.subckt sky130_fd_sc_hd__and3b_1 A_N B C VGND VNB VPB VPWR X
.ends

* Black-box entry subcircuit for sky130_fd_sc_hd__o2bb2a_1 abstract view
.subckt sky130_fd_sc_hd__o2bb2a_1 A1_N A2_N B1 B2 VGND VNB VPB VPWR X
.ends

* Black-box entry subcircuit for sky130_fd_sc_hd__xnor2_2 abstract view
.subckt sky130_fd_sc_hd__xnor2_2 A B VGND VNB VPB VPWR Y
.ends

* Black-box entry subcircuit for sky130_fd_sc_hd__a31o_1 abstract view
.subckt sky130_fd_sc_hd__a31o_1 A1 A2 A3 B1 VGND VNB VPB VPWR X
.ends

* Black-box entry subcircuit for sky130_fd_sc_hd__nand4_1 abstract view
.subckt sky130_fd_sc_hd__nand4_1 A B C D VGND VNB VPB VPWR Y
.ends

* Black-box entry subcircuit for sky130_fd_sc_hd__or2_4 abstract view
.subckt sky130_fd_sc_hd__or2_4 A B VGND VNB VPB VPWR X
.ends

* Black-box entry subcircuit for sky130_fd_sc_hd__a211oi_4 abstract view
.subckt sky130_fd_sc_hd__a211oi_4 A1 A2 B1 C1 VGND VNB VPB VPWR Y
.ends

* Black-box entry subcircuit for sky130_fd_sc_hd__a22oi_2 abstract view
.subckt sky130_fd_sc_hd__a22oi_2 A1 A2 B1 B2 VGND VNB VPB VPWR Y
.ends

* Black-box entry subcircuit for sky130_fd_sc_hd__dfrtp_1 abstract view
.subckt sky130_fd_sc_hd__dfrtp_1 CLK D RESET_B VGND VNB VPB VPWR Q
.ends

* Black-box entry subcircuit for sky130_fd_sc_hd__and4b_1 abstract view
.subckt sky130_fd_sc_hd__and4b_1 A_N B C D VGND VNB VPB VPWR X
.ends

* Black-box entry subcircuit for sky130_fd_sc_hd__a32o_1 abstract view
.subckt sky130_fd_sc_hd__a32o_1 A1 A2 A3 B1 B2 VGND VNB VPB VPWR X
.ends

* Black-box entry subcircuit for sky130_fd_sc_hd__nand2_4 abstract view
.subckt sky130_fd_sc_hd__nand2_4 A B VGND VNB VPB VPWR Y
.ends

* Black-box entry subcircuit for sky130_fd_sc_hd__o21bai_1 abstract view
.subckt sky130_fd_sc_hd__o21bai_1 A1 A2 B1_N VGND VNB VPB VPWR Y
.ends

* Black-box entry subcircuit for sky130_fd_sc_hd__diode_2 abstract view
.subckt sky130_fd_sc_hd__diode_2 DIODE VGND VNB VPB VPWR
.ends

* Black-box entry subcircuit for sky130_fd_sc_hd__o21ai_1 abstract view
.subckt sky130_fd_sc_hd__o21ai_1 A1 A2 B1 VGND VNB VPB VPWR Y
.ends

* Black-box entry subcircuit for sky130_fd_sc_hd__clkbuf_1 abstract view
.subckt sky130_fd_sc_hd__clkbuf_1 A VGND VNB VPB VPWR X
.ends

* Black-box entry subcircuit for sky130_fd_sc_hd__o211ai_1 abstract view
.subckt sky130_fd_sc_hd__o211ai_1 A1 A2 B1 C1 VGND VNB VPB VPWR Y
.ends

* Black-box entry subcircuit for sky130_fd_sc_hd__or3_4 abstract view
.subckt sky130_fd_sc_hd__or3_4 A B C VGND VNB VPB VPWR X
.ends

* Black-box entry subcircuit for sky130_fd_sc_hd__clkbuf_8 abstract view
.subckt sky130_fd_sc_hd__clkbuf_8 A VGND VNB VPB VPWR X
.ends

* Black-box entry subcircuit for sky130_fd_sc_hd__o21ba_1 abstract view
.subckt sky130_fd_sc_hd__o21ba_1 A1 A2 B1_N VGND VNB VPB VPWR X
.ends

* Black-box entry subcircuit for sky130_fd_sc_hd__dlymetal6s2s_1 abstract view
.subckt sky130_fd_sc_hd__dlymetal6s2s_1 A VGND VNB VPB VPWR X
.ends

* Black-box entry subcircuit for sky130_fd_sc_hd__clkbuf_16 abstract view
.subckt sky130_fd_sc_hd__clkbuf_16 A VGND VNB VPB VPWR X
.ends

* Black-box entry subcircuit for sky130_fd_sc_hd__a21boi_1 abstract view
.subckt sky130_fd_sc_hd__a21boi_1 A1 A2 B1_N VGND VNB VPB VPWR Y
.ends

* Black-box entry subcircuit for sky130_fd_sc_hd__mux2_1 abstract view
.subckt sky130_fd_sc_hd__mux2_1 A0 A1 S VGND VNB VPB VPWR X
.ends

* Black-box entry subcircuit for sky130_fd_sc_hd__xor2_2 abstract view
.subckt sky130_fd_sc_hd__xor2_2 A B VGND VNB VPB VPWR X
.ends

* Black-box entry subcircuit for sky130_fd_sc_hd__nand3b_1 abstract view
.subckt sky130_fd_sc_hd__nand3b_1 A_N B C VGND VNB VPB VPWR Y
.ends

* Black-box entry subcircuit for sky130_fd_sc_hd__o311a_4 abstract view
.subckt sky130_fd_sc_hd__o311a_4 A1 A2 A3 B1 C1 VGND VNB VPB VPWR X
.ends

* Black-box entry subcircuit for sky130_fd_sc_hd__xnor2_4 abstract view
.subckt sky130_fd_sc_hd__xnor2_4 A B VGND VNB VPB VPWR Y
.ends

* Black-box entry subcircuit for sky130_fd_sc_hd__a21oi_2 abstract view
.subckt sky130_fd_sc_hd__a21oi_2 A1 A2 B1 VGND VNB VPB VPWR Y
.ends

* Black-box entry subcircuit for sky130_fd_sc_hd__nor3b_1 abstract view
.subckt sky130_fd_sc_hd__nor3b_1 A B C_N VGND VNB VPB VPWR Y
.ends

* Black-box entry subcircuit for sky130_fd_sc_hd__o211ai_2 abstract view
.subckt sky130_fd_sc_hd__o211ai_2 A1 A2 B1 C1 VGND VNB VPB VPWR Y
.ends

* Black-box entry subcircuit for sky130_fd_sc_hd__o31ai_2 abstract view
.subckt sky130_fd_sc_hd__o31ai_2 A1 A2 A3 B1 VGND VNB VPB VPWR Y
.ends

* Black-box entry subcircuit for sky130_fd_sc_hd__buf_1 abstract view
.subckt sky130_fd_sc_hd__buf_1 A VGND VNB VPB VPWR X
.ends

* Black-box entry subcircuit for sky130_fd_sc_hd__a211o_1 abstract view
.subckt sky130_fd_sc_hd__a211o_1 A1 A2 B1 C1 VGND VNB VPB VPWR X
.ends

* Black-box entry subcircuit for sky130_fd_sc_hd__a41o_1 abstract view
.subckt sky130_fd_sc_hd__a41o_1 A1 A2 A3 A4 B1 VGND VNB VPB VPWR X
.ends

* Black-box entry subcircuit for sky130_fd_sc_hd__o211ai_4 abstract view
.subckt sky130_fd_sc_hd__o211ai_4 A1 A2 B1 C1 VGND VNB VPB VPWR Y
.ends

* Black-box entry subcircuit for sky130_fd_sc_hd__or3b_1 abstract view
.subckt sky130_fd_sc_hd__or3b_1 A B C_N VGND VNB VPB VPWR X
.ends

* Black-box entry subcircuit for sky130_fd_sc_hd__a2bb2o_1 abstract view
.subckt sky130_fd_sc_hd__a2bb2o_1 A1_N A2_N B1 B2 VGND VNB VPB VPWR X
.ends

* Black-box entry subcircuit for sky130_fd_sc_hd__o31a_1 abstract view
.subckt sky130_fd_sc_hd__o31a_1 A1 A2 A3 B1 VGND VNB VPB VPWR X
.ends

* Black-box entry subcircuit for sky130_fd_sc_hd__o22a_2 abstract view
.subckt sky130_fd_sc_hd__o22a_2 A1 A2 B1 B2 VGND VNB VPB VPWR X
.ends

* Black-box entry subcircuit for sky130_fd_sc_hd__xor2_4 abstract view
.subckt sky130_fd_sc_hd__xor2_4 A B VGND VNB VPB VPWR X
.ends

* Black-box entry subcircuit for sky130_fd_sc_hd__o22ai_1 abstract view
.subckt sky130_fd_sc_hd__o22ai_1 A1 A2 B1 B2 VGND VNB VPB VPWR Y
.ends

* Black-box entry subcircuit for sky130_fd_sc_hd__a21oi_4 abstract view
.subckt sky130_fd_sc_hd__a21oi_4 A1 A2 B1 VGND VNB VPB VPWR Y
.ends

* Black-box entry subcircuit for sky130_fd_sc_hd__a31oi_2 abstract view
.subckt sky130_fd_sc_hd__a31oi_2 A1 A2 A3 B1 VGND VNB VPB VPWR Y
.ends

* Black-box entry subcircuit for sky130_fd_sc_hd__nand3_2 abstract view
.subckt sky130_fd_sc_hd__nand3_2 A B C VGND VNB VPB VPWR Y
.ends

* Black-box entry subcircuit for sky130_fd_sc_hd__or4_4 abstract view
.subckt sky130_fd_sc_hd__or4_4 A B C D VGND VNB VPB VPWR X
.ends

* Black-box entry subcircuit for sky130_fd_sc_hd__or4bb_2 abstract view
.subckt sky130_fd_sc_hd__or4bb_2 A B C_N D_N VGND VNB VPB VPWR X
.ends

* Black-box entry subcircuit for sky130_fd_sc_hd__nand3b_2 abstract view
.subckt sky130_fd_sc_hd__nand3b_2 A_N B C VGND VNB VPB VPWR Y
.ends

* Black-box entry subcircuit for sky130_fd_sc_hd__o21ai_2 abstract view
.subckt sky130_fd_sc_hd__o21ai_2 A1 A2 B1 VGND VNB VPB VPWR Y
.ends

* Black-box entry subcircuit for sky130_fd_sc_hd__or4bb_1 abstract view
.subckt sky130_fd_sc_hd__or4bb_1 A B C_N D_N VGND VNB VPB VPWR X
.ends

* Black-box entry subcircuit for sky130_fd_sc_hd__a21boi_4 abstract view
.subckt sky130_fd_sc_hd__a21boi_4 A1 A2 B1_N VGND VNB VPB VPWR Y
.ends

* Black-box entry subcircuit for sky130_fd_sc_hd__o31ai_1 abstract view
.subckt sky130_fd_sc_hd__o31ai_1 A1 A2 A3 B1 VGND VNB VPB VPWR Y
.ends

* Black-box entry subcircuit for sky130_fd_sc_hd__or3b_2 abstract view
.subckt sky130_fd_sc_hd__or3b_2 A B C_N VGND VNB VPB VPWR X
.ends

* Black-box entry subcircuit for sky130_fd_sc_hd__nor3b_2 abstract view
.subckt sky130_fd_sc_hd__nor3b_2 A B C_N VGND VNB VPB VPWR Y
.ends

* Black-box entry subcircuit for sky130_fd_sc_hd__a211oi_2 abstract view
.subckt sky130_fd_sc_hd__a211oi_2 A1 A2 B1 C1 VGND VNB VPB VPWR Y
.ends

* Black-box entry subcircuit for sky130_fd_sc_hd__a311o_1 abstract view
.subckt sky130_fd_sc_hd__a311o_1 A1 A2 A3 B1 C1 VGND VNB VPB VPWR X
.ends

* Black-box entry subcircuit for sky130_fd_sc_hd__nand4_2 abstract view
.subckt sky130_fd_sc_hd__nand4_2 A B C D VGND VNB VPB VPWR Y
.ends

* Black-box entry subcircuit for sky130_fd_sc_hd__o32a_1 abstract view
.subckt sky130_fd_sc_hd__o32a_1 A1 A2 A3 B1 B2 VGND VNB VPB VPWR X
.ends

* Black-box entry subcircuit for sky130_fd_sc_hd__and2_4 abstract view
.subckt sky130_fd_sc_hd__and2_4 A B VGND VNB VPB VPWR X
.ends

* Black-box entry subcircuit for sky130_fd_sc_hd__a2bb2o_4 abstract view
.subckt sky130_fd_sc_hd__a2bb2o_4 A1_N A2_N B1 B2 VGND VNB VPB VPWR X
.ends

* Black-box entry subcircuit for sky130_fd_sc_hd__nand2_2 abstract view
.subckt sky130_fd_sc_hd__nand2_2 A B VGND VNB VPB VPWR Y
.ends

* Black-box entry subcircuit for sky130_fd_sc_hd__or3_2 abstract view
.subckt sky130_fd_sc_hd__or3_2 A B C VGND VNB VPB VPWR X
.ends

* Black-box entry subcircuit for sky130_fd_sc_hd__o21ai_4 abstract view
.subckt sky130_fd_sc_hd__o21ai_4 A1 A2 B1 VGND VNB VPB VPWR Y
.ends

* Black-box entry subcircuit for sky130_fd_sc_hd__buf_6 abstract view
.subckt sky130_fd_sc_hd__buf_6 A VGND VNB VPB VPWR X
.ends

* Black-box entry subcircuit for sky130_fd_sc_hd__o32ai_1 abstract view
.subckt sky130_fd_sc_hd__o32ai_1 A1 A2 A3 B1 B2 VGND VNB VPB VPWR Y
.ends

* Black-box entry subcircuit for sky130_fd_sc_hd__bufinv_16 abstract view
.subckt sky130_fd_sc_hd__bufinv_16 A VGND VNB VPB VPWR Y
.ends

* Black-box entry subcircuit for sky130_fd_sc_hd__o21ba_4 abstract view
.subckt sky130_fd_sc_hd__o21ba_4 A1 A2 B1_N VGND VNB VPB VPWR X
.ends

* Black-box entry subcircuit for sky130_fd_sc_hd__and3_2 abstract view
.subckt sky130_fd_sc_hd__and3_2 A B C VGND VNB VPB VPWR X
.ends

* Black-box entry subcircuit for sky130_fd_sc_hd__or2_2 abstract view
.subckt sky130_fd_sc_hd__or2_2 A B VGND VNB VPB VPWR X
.ends

* Black-box entry subcircuit for sky130_fd_sc_hd__a21boi_2 abstract view
.subckt sky130_fd_sc_hd__a21boi_2 A1 A2 B1_N VGND VNB VPB VPWR Y
.ends

* Black-box entry subcircuit for sky130_fd_sc_hd__and2_2 abstract view
.subckt sky130_fd_sc_hd__and2_2 A B VGND VNB VPB VPWR X
.ends

* Black-box entry subcircuit for sky130_fd_sc_hd__buf_8 abstract view
.subckt sky130_fd_sc_hd__buf_8 A VGND VNB VPB VPWR X
.ends

* Black-box entry subcircuit for sky130_fd_sc_hd__nor4_1 abstract view
.subckt sky130_fd_sc_hd__nor4_1 A B C D VGND VNB VPB VPWR Y
.ends

* Black-box entry subcircuit for sky130_fd_sc_hd__nor2_2 abstract view
.subckt sky130_fd_sc_hd__nor2_2 A B VGND VNB VPB VPWR Y
.ends

* Black-box entry subcircuit for sky130_fd_sc_hd__nor2_4 abstract view
.subckt sky130_fd_sc_hd__nor2_4 A B VGND VNB VPB VPWR Y
.ends

* Black-box entry subcircuit for sky130_fd_sc_hd__buf_12 abstract view
.subckt sky130_fd_sc_hd__buf_12 A VGND VNB VPB VPWR X
.ends

* Black-box entry subcircuit for sky130_fd_sc_hd__a31oi_1 abstract view
.subckt sky130_fd_sc_hd__a31oi_1 A1 A2 A3 B1 VGND VNB VPB VPWR Y
.ends

* Black-box entry subcircuit for sky130_fd_sc_hd__o21a_4 abstract view
.subckt sky130_fd_sc_hd__o21a_4 A1 A2 B1 VGND VNB VPB VPWR X
.ends

* Black-box entry subcircuit for sky130_fd_sc_hd__nor4b_1 abstract view
.subckt sky130_fd_sc_hd__nor4b_1 A B C D_N VGND VNB VPB VPWR Y
.ends

* Black-box entry subcircuit for sky130_fd_sc_hd__o22a_1 abstract view
.subckt sky130_fd_sc_hd__o22a_1 A1 A2 B1 B2 VGND VNB VPB VPWR X
.ends

* Black-box entry subcircuit for sky130_fd_sc_hd__nor3_4 abstract view
.subckt sky130_fd_sc_hd__nor3_4 A B C VGND VNB VPB VPWR Y
.ends

* Black-box entry subcircuit for sky130_fd_sc_hd__a311oi_1 abstract view
.subckt sky130_fd_sc_hd__a311oi_1 A1 A2 A3 B1 C1 VGND VNB VPB VPWR Y
.ends

* Black-box entry subcircuit for sky130_fd_sc_hd__o41a_1 abstract view
.subckt sky130_fd_sc_hd__o41a_1 A1 A2 A3 A4 B1 VGND VNB VPB VPWR X
.ends

* Black-box entry subcircuit for sky130_fd_sc_hd__nor3_2 abstract view
.subckt sky130_fd_sc_hd__nor3_2 A B C VGND VNB VPB VPWR Y
.ends

* Black-box entry subcircuit for sky130_fd_sc_hd__and3_4 abstract view
.subckt sky130_fd_sc_hd__and3_4 A B C VGND VNB VPB VPWR X
.ends

* Black-box entry subcircuit for sky130_fd_sc_hd__o311ai_2 abstract view
.subckt sky130_fd_sc_hd__o311ai_2 A1 A2 A3 B1 C1 VGND VNB VPB VPWR Y
.ends

* Black-box entry subcircuit for sky130_fd_sc_hd__or4b_1 abstract view
.subckt sky130_fd_sc_hd__or4b_1 A B C D_N VGND VNB VPB VPWR X
.ends

* Black-box entry subcircuit for sky130_fd_sc_hd__o21ba_2 abstract view
.subckt sky130_fd_sc_hd__o21ba_2 A1 A2 B1_N VGND VNB VPB VPWR X
.ends

* Black-box entry subcircuit for sky130_fd_sc_hd__a211o_2 abstract view
.subckt sky130_fd_sc_hd__a211o_2 A1 A2 B1 C1 VGND VNB VPB VPWR X
.ends

* Black-box entry subcircuit for sky130_fd_sc_hd__o211a_4 abstract view
.subckt sky130_fd_sc_hd__o211a_4 A1 A2 B1 C1 VGND VNB VPB VPWR X
.ends

* Black-box entry subcircuit for sky130_fd_sc_hd__and4b_2 abstract view
.subckt sky130_fd_sc_hd__and4b_2 A_N B C D VGND VNB VPB VPWR X
.ends

* Black-box entry subcircuit for sky130_fd_sc_hd__o31a_2 abstract view
.subckt sky130_fd_sc_hd__o31a_2 A1 A2 A3 B1 VGND VNB VPB VPWR X
.ends

* Black-box entry subcircuit for sky130_fd_sc_hd__nor4_2 abstract view
.subckt sky130_fd_sc_hd__nor4_2 A B C D VGND VNB VPB VPWR Y
.ends

* Black-box entry subcircuit for sky130_fd_sc_hd__a211o_4 abstract view
.subckt sky130_fd_sc_hd__a211o_4 A1 A2 B1 C1 VGND VNB VPB VPWR X
.ends

* Black-box entry subcircuit for sky130_fd_sc_hd__o2bb2ai_1 abstract view
.subckt sky130_fd_sc_hd__o2bb2ai_1 A1_N A2_N B1 B2 VGND VNB VPB VPWR Y
.ends

* Black-box entry subcircuit for sky130_fd_sc_hd__nand4b_1 abstract view
.subckt sky130_fd_sc_hd__nand4b_1 A_N B C D VGND VNB VPB VPWR Y
.ends

* Black-box entry subcircuit for sky130_fd_sc_hd__and3b_2 abstract view
.subckt sky130_fd_sc_hd__and3b_2 A_N B C VGND VNB VPB VPWR X
.ends

* Black-box entry subcircuit for sky130_fd_sc_hd__a31oi_4 abstract view
.subckt sky130_fd_sc_hd__a31oi_4 A1 A2 A3 B1 VGND VNB VPB VPWR Y
.ends

* Black-box entry subcircuit for sky130_fd_sc_hd__or4bb_4 abstract view
.subckt sky130_fd_sc_hd__or4bb_4 A B C_N D_N VGND VNB VPB VPWR X
.ends

* Black-box entry subcircuit for sky130_fd_sc_hd__nand2b_2 abstract view
.subckt sky130_fd_sc_hd__nand2b_2 A_N B VGND VNB VPB VPWR Y
.ends

* Black-box entry subcircuit for sky130_fd_sc_hd__o31ai_4 abstract view
.subckt sky130_fd_sc_hd__o31ai_4 A1 A2 A3 B1 VGND VNB VPB VPWR Y
.ends

* Black-box entry subcircuit for sky130_fd_sc_hd__o31a_4 abstract view
.subckt sky130_fd_sc_hd__o31a_4 A1 A2 A3 B1 VGND VNB VPB VPWR X
.ends

.subckt synth_top VGND VPWR clk rst_n w00[0] w00[1] w00[2] w00[3] w00[4] w00[5] w00[6]
+ w00[7] w01[0] w01[1] w01[2] w01[3] w01[4] w01[5] w01[6] w01[7] w02[0] w02[1] w02[2]
+ w02[3] w02[4] w02[5] w02[6] w02[7] w03[0] w03[1] w03[2] w03[3] w03[4] w03[5] w03[6]
+ w03[7] w10[0] w10[1] w10[2] w10[3] w10[4] w10[5] w10[6] w10[7] w11[0] w11[1] w11[2]
+ w11[3] w11[4] w11[5] w11[6] w11[7] w12[0] w12[1] w12[2] w12[3] w12[4] w12[5] w12[6]
+ w12[7] w13[0] w13[1] w13[2] w13[3] w13[4] w13[5] w13[6] w13[7] w20[0] w20[1] w20[2]
+ w20[3] w20[4] w20[5] w20[6] w20[7] w21[0] w21[1] w21[2] w21[3] w21[4] w21[5] w21[6]
+ w21[7] w22[0] w22[1] w22[2] w22[3] w22[4] w22[5] w22[6] w22[7] w23[0] w23[1] w23[2]
+ w23[3] w23[4] w23[5] w23[6] w23[7] w30[0] w30[1] w30[2] w30[3] w30[4] w30[5] w30[6]
+ w30[7] w31[0] w31[1] w31[2] w31[3] w31[4] w31[5] w31[6] w31[7] w32[0] w32[1] w32[2]
+ w32[3] w32[4] w32[5] w32[6] w32[7] w33[0] w33[1] w33[2] w33[3] w33[4] w33[5] w33[6]
+ w33[7] x0[0] x0[1] x0[2] x0[3] x0[4] x0[5] x0[6] x0[7] x1[0] x1[1] x1[2] x1[3] x1[4]
+ x1[5] x1[6] x1[7] x2[0] x2[1] x2[2] x2[3] x2[4] x2[5] x2[6] x2[7] x3[0] x3[1] x3[2]
+ x3[3] x3[4] x3[5] x3[6] x3[7] y0[0] y0[10] y0[11] y0[12] y0[13] y0[14] y0[15] y0[16]
+ y0[1] y0[2] y0[3] y0[4] y0[5] y0[6] y0[7] y0[8] y0[9] y1[0] y1[10] y1[11] y1[12]
+ y1[13] y1[14] y1[15] y1[16] y1[1] y1[2] y1[3] y1[4] y1[5] y1[6] y1[7] y1[8] y1[9]
+ y2[0] y2[10] y2[11] y2[12] y2[13] y2[14] y2[15] y2[16] y2[1] y2[2] y2[3] y2[4] y2[5]
+ y2[6] y2[7] y2[8] y2[9] y3[0] y3[10] y3[11] y3[12] y3[13] y3[14] y3[15] y3[16] y3[1]
+ y3[2] y3[3] y3[4] y3[5] y3[6] y3[7] y3[8] y3[9]
XFILLER_100_127 VGND VGND VPWR VPWR sky130_fd_sc_hd__fill_1
XFILLER_79_391 VGND VGND VPWR VPWR sky130_fd_sc_hd__fill_1
X_09671_ _01894_ _02208_ VGND VGND VPWR VPWR _02209_ sky130_fd_sc_hd__nand2_1
XFILLER_82_501 VPWR VGND VPWR VGND sky130_ef_sc_hd__decap_12
X_06883_ net674 net672 net459 net451 VGND VGND VPWR VPWR _02063_ sky130_fd_sc_hd__and4_1
X_08622_ _01080_ _01087_ VGND VGND VPWR VPWR _01089_ sky130_fd_sc_hd__nand2_1
XFILLER_94_372 VGND VGND VPWR VPWR sky130_fd_sc_hd__fill_1
XFILLER_27_439 VGND VGND VPWR VPWR sky130_fd_sc_hd__fill_1
XFILLER_39_299 VGND VGND VPWR VPWR sky130_fd_sc_hd__decap_4
X_08553_ _00998_ _00999_ _01000_ _01021_ VGND VGND VPWR VPWR _01022_ sky130_fd_sc_hd__or4_1
XFILLER_63_781 VGND VGND VPWR VPWR sky130_fd_sc_hd__decap_3
X_07504_ _06731_ _06732_ VGND VGND VPWR VPWR _06733_ sky130_fd_sc_hd__nor2_1
X_08484_ _00956_ _00955_ VGND VGND VPWR VPWR _00957_ sky130_fd_sc_hd__nand2b_1
X_07435_ net267 net710 net611 net604 VGND VGND VPWR VPWR _06665_ sky130_fd_sc_hd__and4_1
XFILLER_52_29 VPWR VGND VPWR VGND sky130_ef_sc_hd__decap_12
XFILLER_22_122 VPWR VGND VPWR VGND sky130_ef_sc_hd__decap_12
XFILLER_50_475 VGND VGND VPWR VPWR sky130_fd_sc_hd__fill_1
XTAP_TAPCELL_ROW_98_1723 VGND VPWR sky130_fd_sc_hd__tapvpwrvgnd_1
X_07366_ _06587_ _06595_ VGND VGND VPWR VPWR _06596_ sky130_fd_sc_hd__nand2_1
XFILLER_136_514 VGND VGND VPWR VPWR sky130_fd_sc_hd__decap_8
X_09105_ net447 net334 net61 net440 VGND VGND VPWR VPWR _01591_ sky130_fd_sc_hd__a22o_1
XFILLER_108_205 VGND VGND VPWR VPWR sky130_fd_sc_hd__fill_1
X_07297_ _06524_ _06525_ _06526_ VGND VGND VPWR VPWR _06528_ sky130_fd_sc_hd__or3_1
X_09036_ _01367_ _01403_ _01405_ VGND VGND VPWR VPWR _01516_ sky130_fd_sc_hd__a21oi_1
XFILLER_108_227 VPWR VGND VPWR VGND sky130_ef_sc_hd__decap_12
XFILLER_117_750 VGND VGND VPWR VPWR sky130_fd_sc_hd__fill_1
XPHY_EDGE_ROW_107_Left_246 VGND VGND VPWR VPWR sky130_fd_sc_hd__decap_3
XFILLER_117_783 VGND VGND VPWR VPWR sky130_fd_sc_hd__fill_1
XFILLER_116_271 VPWR VGND VPWR VGND sky130_ef_sc_hd__decap_12
XFILLER_104_400 VGND VGND VPWR VPWR sky130_fd_sc_hd__decap_3
XFILLER_117_55 VGND VGND VPWR VPWR sky130_fd_sc_hd__fill_1
XFILLER_77_37 VPWR VGND VPWR VGND sky130_ef_sc_hd__decap_12
X_09938_ _02497_ _02498_ VGND VGND VPWR VPWR _02500_ sky130_fd_sc_hd__xnor2_1
XFILLER_89_166 VGND VGND VPWR VPWR sky130_fd_sc_hd__fill_2
XFILLER_89_199 VPWR VGND VPWR VGND sky130_ef_sc_hd__decap_12
XTAP_TAPCELL_ROW_51_1041 VGND VPWR sky130_fd_sc_hd__tapvpwrvgnd_1
XTAP_TAPCELL_ROW_125_2108 VGND VPWR sky130_fd_sc_hd__tapvpwrvgnd_1
X_09869_ _02424_ _02423_ VGND VGND VPWR VPWR _02425_ sky130_fd_sc_hd__nand2b_1
XFILLER_92_309 VPWR VGND VPWR VGND sky130_ef_sc_hd__decap_12
XTAP_TAPCELL_ROW_5_376 VGND VPWR sky130_fd_sc_hd__tapvpwrvgnd_1
XTAP_TAPCELL_ROW_5_365 VGND VPWR sky130_fd_sc_hd__tapvpwrvgnd_1
XPHY_EDGE_ROW_116_Left_255 VGND VGND VPWR VPWR sky130_fd_sc_hd__decap_3
XFILLER_73_545 VPWR VGND VPWR VGND sky130_ef_sc_hd__decap_12
X_12880_ _05699_ _05700_ VGND VGND VPWR VPWR _05704_ sky130_fd_sc_hd__xnor2_1
XFILLER_58_597 VGND VGND VPWR VPWR sky130_fd_sc_hd__decap_8
XFILLER_45_214 VGND VGND VPWR VPWR sky130_fd_sc_hd__decap_8
X_11900_ _03964_ _04368_ VGND VGND VPWR VPWR _04637_ sky130_fd_sc_hd__nor2_1
XTAP_TAPCELL_ROW_107_1852 VGND VPWR sky130_fd_sc_hd__tapvpwrvgnd_1
XFILLER_93_69 VPWR VGND VPWR VGND sky130_ef_sc_hd__decap_12
XFILLER_61_707 VGND VGND VPWR VPWR sky130_fd_sc_hd__fill_2
X_11831_ _04480_ _04481_ _04484_ VGND VGND VPWR VPWR _04562_ sky130_fd_sc_hd__o21a_1
XFILLER_26_41 VPWR VGND VPWR VGND sky130_ef_sc_hd__decap_12
XFILLER_61_729 VGND VGND VPWR VPWR sky130_fd_sc_hd__fill_1
XTAP_TAPCELL_ROW_44_938 VGND VPWR sky130_fd_sc_hd__tapvpwrvgnd_1
X_13501_ _06200_ _06202_ _06380_ VGND VGND VPWR VPWR _06382_ sky130_fd_sc_hd__nor3_1
XFILLER_13_133 VGND VGND VPWR VPWR sky130_fd_sc_hd__fill_1
X_11762_ _04370_ _04374_ _04485_ VGND VGND VPWR VPWR _04487_ sky130_fd_sc_hd__and3_1
XFILLER_26_85 VGND VGND VPWR VPWR sky130_fd_sc_hd__decap_3
XFILLER_13_144 VGND VGND VPWR VPWR sky130_fd_sc_hd__fill_1
XFILLER_14_678 VGND VGND VPWR VPWR sky130_fd_sc_hd__decap_3
X_11693_ _04410_ _04411_ VGND VGND VPWR VPWR _04412_ sky130_fd_sc_hd__nor2_1
X_10713_ _03184_ _03186_ _03340_ _03341_ VGND VGND VPWR VPWR _03342_ sky130_fd_sc_hd__o211a_1
XTAP_TAPCELL_ROW_24_640 VGND VPWR sky130_fd_sc_hd__tapvpwrvgnd_1
XTAP_TAPCELL_ROW_24_651 VGND VPWR sky130_fd_sc_hd__tapvpwrvgnd_1
X_13432_ _05315_ _06305_ VGND VGND VPWR VPWR _06306_ sky130_fd_sc_hd__nand2_1
X_10644_ net528 net288 _03121_ VGND VGND VPWR VPWR _03266_ sky130_fd_sc_hd__a21o_1
X_13363_ _06110_ _06122_ _06108_ VGND VGND VPWR VPWR _06231_ sky130_fd_sc_hd__o21a_1
XTAP_TAPCELL_ROW_62_1192 VGND VPWR sky130_fd_sc_hd__tapvpwrvgnd_1
XFILLER_6_811 VGND VGND VPWR VPWR sky130_fd_sc_hd__fill_1
X_10575_ _03187_ _03188_ _03035_ _03037_ VGND VGND VPWR VPWR _03191_ sky130_fd_sc_hd__a211oi_1
XPHY_EDGE_ROW_125_Left_264 VGND VGND VPWR VPWR sky130_fd_sc_hd__decap_3
X_12314_ _05083_ _05084_ VGND VGND VPWR VPWR _05085_ sky130_fd_sc_hd__nand2_1
X_13294_ _05891_ _06021_ _06020_ VGND VGND VPWR VPWR _06156_ sky130_fd_sc_hd__a21oi_1
XFILLER_5_354 VGND VGND VPWR VPWR sky130_fd_sc_hd__fill_1
X_12245_ _05008_ _05009_ VGND VGND VPWR VPWR _05010_ sky130_fd_sc_hd__nor2_1
XFILLER_5_387 VGND VGND VPWR VPWR sky130_fd_sc_hd__decap_4
X_12176_ _04924_ _04929_ _04931_ VGND VGND VPWR VPWR _04935_ sky130_fd_sc_hd__a21bo_1
XFILLER_123_797 VGND VGND VPWR VPWR sky130_fd_sc_hd__decap_6
XFILLER_122_274 VPWR VGND VPWR VGND sky130_ef_sc_hd__decap_12
X_11127_ _03791_ _03792_ VGND VGND VPWR VPWR _03794_ sky130_fd_sc_hd__and2b_1
XFILLER_110_425 VPWR VGND VPWR VGND sky130_ef_sc_hd__decap_12
XFILLER_95_136 VGND VGND VPWR VPWR sky130_fd_sc_hd__decap_8
XFILLER_95_125 VGND VGND VPWR VPWR sky130_fd_sc_hd__fill_1
XPHY_EDGE_ROW_134_Left_273 VGND VGND VPWR VPWR sky130_fd_sc_hd__decap_3
XFILLER_95_169 VPWR VGND VPWR VGND sky130_ef_sc_hd__decap_12
XTAP_TAPCELL_ROW_69_1302 VGND VPWR sky130_fd_sc_hd__tapvpwrvgnd_1
X_11058_ _03585_ _03588_ VGND VGND VPWR VPWR _03719_ sky130_fd_sc_hd__nand2_1
X_10009_ _02327_ _02471_ _02470_ VGND VGND VPWR VPWR _02577_ sky130_fd_sc_hd__a21oi_1
XFILLER_64_523 VGND VGND VPWR VPWR sky130_fd_sc_hd__decap_8
XFILLER_37_748 VGND VGND VPWR VPWR sky130_fd_sc_hd__decap_8
XFILLER_64_545 VPWR VGND VPWR VGND sky130_ef_sc_hd__decap_12
XFILLER_91_375 VGND VGND VPWR VPWR sky130_fd_sc_hd__decap_8
XFILLER_83_80 VPWR VGND VPWR VGND sky130_ef_sc_hd__decap_12
XFILLER_64_589 VPWR VGND VPWR VGND sky130_ef_sc_hd__decap_12
XFILLER_52_729 VPWR VGND VPWR VGND sky130_ef_sc_hd__decap_12
X_07220_ _05712_ _05723_ VGND VGND VPWR VPWR _05733_ sky130_fd_sc_hd__or2_1
X_07151_ _03237_ _03259_ _04958_ VGND VGND VPWR VPWR _04980_ sky130_fd_sc_hd__nor3_1
XFILLER_9_671 VGND VGND VPWR VPWR sky130_fd_sc_hd__fill_1
XFILLER_20_659 VGND VGND VPWR VPWR sky130_fd_sc_hd__decap_4
X_07082_ _02402_ _04210_ _04199_ VGND VGND VPWR VPWR _04232_ sky130_fd_sc_hd__o21bai_2
XTAP_TAPCELL_ROW_93_1653 VGND VPWR sky130_fd_sc_hd__tapvpwrvgnd_1
XTAP_TAPCELL_ROW_93_1642 VGND VPWR sky130_fd_sc_hd__tapvpwrvgnd_1
XFILLER_113_241 VGND VGND VPWR VPWR sky130_fd_sc_hd__fill_1
XFILLER_113_263 VGND VGND VPWR VPWR sky130_fd_sc_hd__fill_2
XFILLER_101_414 VGND VGND VPWR VPWR sky130_fd_sc_hd__decap_8
XFILLER_87_615 VGND VGND VPWR VPWR sky130_fd_sc_hd__fill_1
XFILLER_87_659 VPWR VGND VPWR VGND sky130_ef_sc_hd__decap_12
XFILLER_86_147 VGND VGND VPWR VPWR sky130_fd_sc_hd__fill_1
X_07984_ _00317_ _00325_ _00324_ VGND VGND VPWR VPWR _00461_ sky130_fd_sc_hd__a21oi_1
X_09723_ _02263_ _02264_ net419 net331 VGND VGND VPWR VPWR _02266_ sky130_fd_sc_hd__and4bb_1
XFILLER_74_309 VGND VGND VPWR VPWR sky130_fd_sc_hd__decap_4
X_06935_ _02619_ VGND VGND VPWR VPWR _02630_ sky130_fd_sc_hd__inv_2
X_09654_ _02188_ _02189_ VGND VGND VPWR VPWR _02190_ sky130_fd_sc_hd__xnor2_1
X_06866_ _01824_ _01857_ VGND VGND VPWR VPWR _01878_ sky130_fd_sc_hd__nand2_1
XTAP_TAPCELL_ROW_2_335 VGND VPWR sky130_fd_sc_hd__tapvpwrvgnd_1
XTAP_TAPCELL_ROW_2_324 VGND VPWR sky130_fd_sc_hd__tapvpwrvgnd_1
XFILLER_28_726 VPWR VGND VPWR VGND sky130_ef_sc_hd__decap_12
X_08605_ _01022_ _01028_ _01071_ VGND VGND VPWR VPWR _01073_ sky130_fd_sc_hd__nand3_1
XFILLER_103_57 VPWR VGND VPWR VGND sky130_ef_sc_hd__decap_12
X_09585_ _02113_ _02114_ VGND VGND VPWR VPWR _02115_ sky130_fd_sc_hd__nor2_1
XFILLER_70_504 VGND VGND VPWR VPWR sky130_fd_sc_hd__decap_8
XFILLER_63_39 VPWR VGND VPWR VGND sky130_ef_sc_hd__decap_12
XFILLER_43_729 VGND VGND VPWR VPWR sky130_fd_sc_hd__decap_8
XFILLER_36_781 VPWR VGND VPWR VGND sky130_ef_sc_hd__decap_12
XTAP_TAPCELL_ROW_120_2038 VGND VPWR sky130_fd_sc_hd__tapvpwrvgnd_1
X_08536_ net646 net378 net375 net657 VGND VGND VPWR VPWR _01005_ sky130_fd_sc_hd__a22oi_1
X_08467_ _00842_ _00844_ _00939_ VGND VGND VPWR VPWR _00940_ sky130_fd_sc_hd__o21a_1
XTAP_TAPCELL_ROW_102_1782 VGND VPWR sky130_fd_sc_hd__tapvpwrvgnd_1
XTAP_TAPCELL_ROW_102_1771 VGND VPWR sky130_fd_sc_hd__tapvpwrvgnd_1
X_07418_ _06645_ _06646_ _06160_ VGND VGND VPWR VPWR _06648_ sky130_fd_sc_hd__a21bo_1
X_08398_ _00708_ _00710_ _00870_ VGND VGND VPWR VPWR _00872_ sky130_fd_sc_hd__nor3_1
XTAP_TAPCELL_ROW_21_610 VGND VPWR sky130_fd_sc_hd__tapvpwrvgnd_1
X_07349_ net699 net546 net537 net701 VGND VGND VPWR VPWR _06579_ sky130_fd_sc_hd__a22o_1
XFILLER_136_355 VGND VGND VPWR VPWR sky130_fd_sc_hd__fill_1
XFILLER_12_65 VPWR VGND VPWR VGND sky130_ef_sc_hd__decap_12
X_10360_ _02949_ _02955_ VGND VGND VPWR VPWR _02956_ sky130_fd_sc_hd__xnor2_1
XFILLER_128_65 VPWR VGND VPWR VGND sky130_ef_sc_hd__decap_12
X_09019_ _01495_ _01496_ _01438_ VGND VGND VPWR VPWR _01499_ sky130_fd_sc_hd__a21o_1
X_10291_ _02869_ _02879_ VGND VGND VPWR VPWR _02881_ sky130_fd_sc_hd__and2_1
XFILLER_105_753 VPWR VGND VPWR VGND sky130_ef_sc_hd__decap_12
X_12030_ net594 net584 net577 net659 VGND VGND VPWR VPWR _04775_ sky130_fd_sc_hd__and4_1
XFILLER_132_572 VPWR VGND VPWR VGND sky130_ef_sc_hd__decap_12
XFILLER_120_701 VGND VGND VPWR VPWR sky130_fd_sc_hd__decap_8
XFILLER_105_797 VPWR VGND VPWR VGND sky130_ef_sc_hd__decap_12
XFILLER_2_379 VGND VGND VPWR VPWR sky130_fd_sc_hd__fill_2
XFILLER_104_285 VGND VGND VPWR VPWR sky130_fd_sc_hd__fill_2
XFILLER_77_125 VGND VGND VPWR VPWR sky130_fd_sc_hd__decap_6
Xfanout650 net653 VGND VGND VPWR VPWR net650 sky130_fd_sc_hd__buf_4
XFILLER_77_169 VGND VGND VPWR VPWR sky130_fd_sc_hd__fill_1
Xfanout672 net123 VGND VGND VPWR VPWR net672 sky130_fd_sc_hd__buf_2
Xfanout661 net129 VGND VGND VPWR VPWR net661 sky130_fd_sc_hd__clkbuf_4
Xfanout683 net118 VGND VGND VPWR VPWR net683 sky130_fd_sc_hd__clkbuf_2
Xfanout694 net110 VGND VGND VPWR VPWR net694 sky130_fd_sc_hd__clkbuf_2
X_12932_ _05627_ _05638_ _05637_ VGND VGND VPWR VPWR _05760_ sky130_fd_sc_hd__a21o_1
XFILLER_19_726 VGND VGND VPWR VPWR sky130_fd_sc_hd__fill_2
XFILLER_19_737 VGND VGND VPWR VPWR sky130_fd_sc_hd__decap_3
XTAP_TAPCELL_ROW_29_721 VGND VPWR sky130_fd_sc_hd__tapvpwrvgnd_1
XFILLER_37_51 VGND VGND VPWR VPWR sky130_fd_sc_hd__decap_4
XFILLER_85_191 VGND VGND VPWR VPWR sky130_fd_sc_hd__fill_1
XFILLER_46_556 VGND VGND VPWR VPWR sky130_fd_sc_hd__fill_1
XFILLER_18_247 VGND VGND VPWR VPWR sky130_fd_sc_hd__decap_4
X_12863_ _05315_ _05683_ VGND VGND VPWR VPWR _05685_ sky130_fd_sc_hd__xnor2_1
XFILLER_33_206 VGND VGND VPWR VPWR sky130_fd_sc_hd__decap_8
X_12794_ _05597_ _05608_ VGND VGND VPWR VPWR _05609_ sky130_fd_sc_hd__xor2_1
XTAP_TAPCELL_ROW_64_1232 VGND VPWR sky130_fd_sc_hd__tapvpwrvgnd_1
XTAP_TAPCELL_ROW_64_1221 VGND VPWR sky130_fd_sc_hd__tapvpwrvgnd_1
XFILLER_61_559 VGND VGND VPWR VPWR sky130_fd_sc_hd__fill_1
X_11814_ _04541_ _04542_ VGND VGND VPWR VPWR _04544_ sky130_fd_sc_hd__nor2_1
XFILLER_42_751 VGND VGND VPWR VPWR sky130_fd_sc_hd__decap_4
XFILLER_41_250 VPWR VGND VPWR VGND sky130_ef_sc_hd__decap_12
XFILLER_14_442 VGND VGND VPWR VPWR sky130_fd_sc_hd__decap_4
X_11745_ _04263_ _04367_ VGND VGND VPWR VPWR _04468_ sky130_fd_sc_hd__nor2_1
X_13415_ _06178_ _06287_ VGND VGND VPWR VPWR _06288_ sky130_fd_sc_hd__xnor2_1
X_11676_ net272 _03426_ net410 VGND VGND VPWR VPWR _04393_ sky130_fd_sc_hd__and3b_1
XFILLER_127_333 VGND VGND VPWR VPWR sky130_fd_sc_hd__decap_3
X_10627_ _03207_ _03245_ VGND VGND VPWR VPWR _03247_ sky130_fd_sc_hd__xor2_1
X_13346_ _06211_ _06179_ VGND VGND VPWR VPWR _06212_ sky130_fd_sc_hd__and2b_1
X_10558_ _03169_ _03170_ _03171_ VGND VGND VPWR VPWR _03173_ sky130_fd_sc_hd__and3_1
XFILLER_127_377 VGND VGND VPWR VPWR sky130_fd_sc_hd__decap_4
X_13277_ _06126_ _06135_ VGND VGND VPWR VPWR _06137_ sky130_fd_sc_hd__xor2_1
XFILLER_6_674 VPWR VGND VPWR VGND sky130_ef_sc_hd__decap_12
X_12228_ _04990_ _04983_ VGND VGND VPWR VPWR _04992_ sky130_fd_sc_hd__and2b_1
X_10489_ _02947_ _03096_ VGND VGND VPWR VPWR _03097_ sky130_fd_sc_hd__xor2_1
XFILLER_111_712 VPWR VGND VPWR VGND sky130_ef_sc_hd__decap_12
XTAP_TAPCELL_ROW_75_1383 VGND VPWR sky130_fd_sc_hd__tapvpwrvgnd_1
XFILLER_69_615 VGND VGND VPWR VPWR sky130_fd_sc_hd__fill_1
XFILLER_110_222 VGND VGND VPWR VPWR sky130_fd_sc_hd__decap_6
XFILLER_96_434 VPWR VGND VPWR VGND sky130_ef_sc_hd__decap_12
X_12159_ _04807_ _04913_ _04914_ VGND VGND VPWR VPWR _04917_ sky130_fd_sc_hd__nand3_1
XFILLER_56_309 VPWR VGND VPWR VGND sky130_ef_sc_hd__decap_12
XFILLER_1_390 VGND VGND VPWR VPWR sky130_fd_sc_hd__fill_2
XFILLER_110_299 VGND VGND VPWR VPWR sky130_fd_sc_hd__fill_1
XFILLER_92_640 VGND VGND VPWR VPWR sky130_fd_sc_hd__decap_4
XFILLER_76_180 VPWR VGND VPWR VGND sky130_ef_sc_hd__decap_12
XFILLER_92_695 VGND VGND VPWR VPWR sky130_fd_sc_hd__decap_4
XFILLER_92_684 VGND VGND VPWR VPWR sky130_fd_sc_hd__fill_1
XFILLER_80_813 VGND VGND VPWR VPWR sky130_fd_sc_hd__decap_6
XFILLER_52_515 VGND VGND VPWR VPWR sky130_fd_sc_hd__decap_8
XFILLER_18_781 VPWR VGND VPWR VGND sky130_ef_sc_hd__decap_12
X_09370_ net542 net361 net363 net266 VGND VGND VPWR VPWR _01881_ sky130_fd_sc_hd__o2bb2a_1
XFILLER_52_537 VGND VGND VPWR VPWR sky130_fd_sc_hd__decap_6
X_08321_ _00675_ _00685_ VGND VGND VPWR VPWR _00796_ sky130_fd_sc_hd__nor2_1
XFILLER_138_609 VGND VGND VPWR VPWR sky130_fd_sc_hd__decap_3
X_08252_ net603 net704 net261 net705 VGND VGND VPWR VPWR _00727_ sky130_fd_sc_hd__o2bb2a_1
XFILLER_20_401 VPWR VGND VPWR VGND sky130_ef_sc_hd__decap_12
X_07203_ _05527_ _05538_ VGND VGND VPWR VPWR _00049_ sky130_fd_sc_hd__and2b_1
XFILLER_32_294 VGND VGND VPWR VPWR sky130_fd_sc_hd__fill_1
XFILLER_118_333 VGND VGND VPWR VPWR sky130_fd_sc_hd__decap_3
X_08183_ _00656_ _00657_ VGND VGND VPWR VPWR _00659_ sky130_fd_sc_hd__xnor2_2
X_07134_ _04783_ _04558_ VGND VGND VPWR VPWR _04794_ sky130_fd_sc_hd__and2b_1
XFILLER_118_399 VPWR VGND VPWR VGND sky130_ef_sc_hd__decap_12
X_07065_ _02118_ _02216_ _02107_ VGND VGND VPWR VPWR _04046_ sky130_fd_sc_hd__a21o_1
XTAP_TAPCELL_ROW_7_405 VGND VPWR sky130_fd_sc_hd__tapvpwrvgnd_1
Xoutput220 net220 VGND VGND VPWR VPWR y3[16] sky130_fd_sc_hd__buf_2
XFILLER_133_369 VGND VGND VPWR VPWR sky130_fd_sc_hd__decap_4
XFILLER_102_701 VGND VGND VPWR VPWR sky130_fd_sc_hd__decap_4
XFILLER_59_125 VGND VGND VPWR VPWR sky130_fd_sc_hd__decap_4
XFILLER_87_467 VGND VGND VPWR VPWR sky130_fd_sc_hd__fill_1
X_07967_ net691 net536 net263 net693 VGND VGND VPWR VPWR _00444_ sky130_fd_sc_hd__o2bb2a_1
X_09706_ _02241_ _02245_ VGND VGND VPWR VPWR _02247_ sky130_fd_sc_hd__xnor2_1
XFILLER_101_299 VGND VGND VPWR VPWR sky130_fd_sc_hd__fill_1
XFILLER_101_277 VGND VGND VPWR VPWR sky130_fd_sc_hd__decap_3
XFILLER_74_139 VGND VGND VPWR VPWR sky130_fd_sc_hd__fill_1
XFILLER_68_681 VPWR VGND VPWR VGND sky130_ef_sc_hd__decap_12
X_06918_ net114 net687 net512 net503 VGND VGND VPWR VPWR _02445_ sky130_fd_sc_hd__and4_1
XFILLER_67_191 VPWR VGND VPWR VGND sky130_ef_sc_hd__decap_12
X_07898_ _00374_ _00375_ VGND VGND VPWR VPWR _00376_ sky130_fd_sc_hd__nand2_1
XFILLER_28_567 VGND VGND VPWR VPWR sky130_fd_sc_hd__fill_1
X_09637_ _02026_ _02171_ VGND VGND VPWR VPWR _02172_ sky130_fd_sc_hd__xnor2_1
XTAP_TAPCELL_ROW_104_1800 VGND VPWR sky130_fd_sc_hd__tapvpwrvgnd_1
XFILLER_83_673 VPWR VGND VPWR VGND sky130_ef_sc_hd__decap_12
X_06849_ _01671_ _01682_ VGND VGND VPWR VPWR _01692_ sky130_fd_sc_hd__xor2_1
XFILLER_55_375 VGND VGND VPWR VPWR sky130_fd_sc_hd__fill_1
XFILLER_15_206 VGND VGND VPWR VPWR sky130_fd_sc_hd__decap_6
XFILLER_28_589 VGND VGND VPWR VPWR sky130_fd_sc_hd__decap_6
X_09568_ _02091_ _02095_ VGND VGND VPWR VPWR _02097_ sky130_fd_sc_hd__and2_1
XTAP_TAPCELL_ROW_104_1811 VGND VPWR sky130_fd_sc_hd__tapvpwrvgnd_1
XFILLER_70_334 VGND VGND VPWR VPWR sky130_fd_sc_hd__decap_4
XFILLER_43_559 VGND VGND VPWR VPWR sky130_fd_sc_hd__fill_1
XFILLER_130_77 VGND VGND VPWR VPWR sky130_fd_sc_hd__decap_6
XFILLER_90_15 VPWR VGND VPWR VGND sky130_ef_sc_hd__decap_12
X_08519_ _00925_ _00990_ VGND VGND VPWR VPWR _00991_ sky130_fd_sc_hd__xnor2_1
X_09499_ _01853_ _01855_ _02021_ VGND VGND VPWR VPWR _02022_ sky130_fd_sc_hd__nand3_1
X_11530_ _04219_ _04234_ VGND VGND VPWR VPWR _04235_ sky130_fd_sc_hd__xnor2_1
XFILLER_135_3 VPWR VGND VPWR VGND sky130_ef_sc_hd__decap_12
XFILLER_7_405 VGND VGND VPWR VPWR sky130_fd_sc_hd__decap_4
XFILLER_11_456 VPWR VGND VPWR VGND sky130_ef_sc_hd__decap_12
XTAP_TAPCELL_ROW_34_790 VGND VPWR sky130_fd_sc_hd__tapvpwrvgnd_1
XPHY_EDGE_ROW_137_Right_137 VGND VGND VPWR VPWR sky130_fd_sc_hd__decap_3
XFILLER_7_449 VGND VGND VPWR VPWR sky130_fd_sc_hd__decap_8
XFILLER_7_438 VGND VGND VPWR VPWR sky130_fd_sc_hd__decap_8
X_11461_ _03875_ _04159_ VGND VGND VPWR VPWR _04160_ sky130_fd_sc_hd__xor2_1
XFILLER_136_141 VPWR VGND VPWR VGND sky130_ef_sc_hd__decap_12
XTAP_TAPCELL_ROW_133_2229 VGND VPWR sky130_fd_sc_hd__tapvpwrvgnd_1
X_13200_ _05940_ _05947_ _05945_ VGND VGND VPWR VPWR _06053_ sky130_fd_sc_hd__a21o_1
X_11392_ net521 net287 _03939_ _03938_ VGND VGND VPWR VPWR _04084_ sky130_fd_sc_hd__a31o_1
X_10412_ net468 net276 _03011_ _03012_ VGND VGND VPWR VPWR _03013_ sky130_fd_sc_hd__nand4_1
XFILLER_124_303 VGND VGND VPWR VPWR sky130_fd_sc_hd__decap_4
XFILLER_109_399 VGND VGND VPWR VPWR sky130_fd_sc_hd__fill_1
XFILLER_109_388 VGND VGND VPWR VPWR sky130_fd_sc_hd__fill_1
XFILLER_99_57 VPWR VGND VPWR VGND sky130_ef_sc_hd__decap_12
X_13131_ _05971_ _05977_ VGND VGND VPWR VPWR _05978_ sky130_fd_sc_hd__nand2b_1
XFILLER_3_611 VGND VGND VPWR VPWR sky130_fd_sc_hd__decap_4
X_10343_ _02876_ _02928_ VGND VGND VPWR VPWR _02937_ sky130_fd_sc_hd__xor2_1
XTAP_TAPCELL_ROW_115_1973 VGND VPWR sky130_fd_sc_hd__tapvpwrvgnd_1
XTAP_TAPCELL_ROW_115_1962 VGND VPWR sky130_fd_sc_hd__tapvpwrvgnd_1
XFILLER_2_121 VPWR VGND VPWR VGND sky130_ef_sc_hd__decap_12
XFILLER_105_561 VGND VGND VPWR VPWR sky130_fd_sc_hd__decap_4
X_13062_ _05901_ VGND VGND VPWR VPWR _05902_ sky130_fd_sc_hd__inv_2
XFILLER_78_401 VGND VGND VPWR VPWR sky130_fd_sc_hd__fill_2
X_10274_ _02859_ _02860_ VGND VGND VPWR VPWR _02862_ sky130_fd_sc_hd__xnor2_1
X_12013_ net18 _04755_ VGND VGND VPWR VPWR _04756_ sky130_fd_sc_hd__and2_1
Xfanout480 net482 VGND VGND VPWR VPWR net480 sky130_fd_sc_hd__buf_2
XFILLER_59_692 VPWR VGND VPWR VGND sky130_ef_sc_hd__decap_12
XFILLER_48_83 VGND VGND VPWR VPWR sky130_fd_sc_hd__fill_1
Xfanout491 net151 VGND VGND VPWR VPWR net491 sky130_fd_sc_hd__clkbuf_4
XFILLER_46_320 VGND VGND VPWR VPWR sky130_fd_sc_hd__fill_1
XFILLER_19_545 VGND VGND VPWR VPWR sky130_fd_sc_hd__decap_6
XFILLER_19_556 VGND VGND VPWR VPWR sky130_fd_sc_hd__decap_4
X_12915_ net564 net555 net422 net408 VGND VGND VPWR VPWR _05741_ sky130_fd_sc_hd__and4_1
XFILLER_62_813 VGND VGND VPWR VPWR sky130_fd_sc_hd__decap_6
XFILLER_0_57 VPWR VGND VPWR VGND sky130_ef_sc_hd__decap_12
X_12846_ _05664_ _05665_ VGND VGND VPWR VPWR _05666_ sky130_fd_sc_hd__xnor2_1
XFILLER_61_312 VPWR VGND VPWR VGND sky130_ef_sc_hd__decap_12
XFILLER_34_537 VPWR VGND VPWR VGND sky130_ef_sc_hd__decap_12
XFILLER_64_93 VGND VGND VPWR VPWR sky130_fd_sc_hd__decap_3
X_12777_ _05588_ _05589_ VGND VGND VPWR VPWR _05590_ sky130_fd_sc_hd__nor2_1
XFILLER_61_389 VGND VGND VPWR VPWR sky130_fd_sc_hd__decap_3
XFILLER_42_581 VGND VGND VPWR VPWR sky130_fd_sc_hd__decap_6
XFILLER_9_77 VGND VGND VPWR VPWR sky130_fd_sc_hd__fill_2
XFILLER_9_55 VGND VGND VPWR VPWR sky130_fd_sc_hd__fill_1
X_11728_ _04446_ _04447_ VGND VGND VPWR VPWR _04450_ sky130_fd_sc_hd__nor2_1
XPHY_EDGE_ROW_104_Right_104 VGND VGND VPWR VPWR sky130_fd_sc_hd__decap_3
XFILLER_80_81 VGND VGND VPWR VPWR sky130_fd_sc_hd__decap_3
X_11659_ _04365_ _04372_ VGND VGND VPWR VPWR _04375_ sky130_fd_sc_hd__xnor2_1
XFILLER_128_664 VGND VGND VPWR VPWR sky130_fd_sc_hd__decap_8
XFILLER_128_642 VGND VGND VPWR VPWR sky130_fd_sc_hd__fill_2
XTAP_TAPCELL_ROW_77_1412 VGND VPWR sky130_fd_sc_hd__tapvpwrvgnd_1
XTAP_TAPCELL_ROW_12_473 VGND VPWR sky130_fd_sc_hd__tapvpwrvgnd_1
X_13329_ _05946_ _06082_ VGND VGND VPWR VPWR _06194_ sky130_fd_sc_hd__nand2_1
XTAP_TAPCELL_ROW_90_1601 VGND VPWR sky130_fd_sc_hd__tapvpwrvgnd_1
XFILLER_50_3 VPWR VGND VPWR VGND sky130_ef_sc_hd__decap_12
X_08870_ net473 net334 _01189_ _01187_ VGND VGND VPWR VPWR _01336_ sky130_fd_sc_hd__a31o_1
XFILLER_97_721 VGND VGND VPWR VPWR sky130_fd_sc_hd__decap_6
XFILLER_69_423 VPWR VGND VPWR VGND sky130_ef_sc_hd__decap_12
XFILLER_111_542 VPWR VGND VPWR VGND sky130_ef_sc_hd__decap_12
XFILLER_96_253 VGND VGND VPWR VPWR sky130_fd_sc_hd__decap_8
XFILLER_96_242 VGND VGND VPWR VPWR sky130_fd_sc_hd__decap_8
XFILLER_96_231 VGND VGND VPWR VPWR sky130_fd_sc_hd__decap_3
X_07821_ net560 net552 net688 VGND VGND VPWR VPWR _00299_ sky130_fd_sc_hd__and3_1
XFILLER_111_575 VPWR VGND VPWR VGND sky130_ef_sc_hd__decap_12
XFILLER_56_139 VGND VGND VPWR VPWR sky130_fd_sc_hd__fill_1
X_07752_ net457 net449 VGND VGND VPWR VPWR _00231_ sky130_fd_sc_hd__or2_4
XTAP_TAPCELL_ROW_88_1574 VGND VPWR sky130_fd_sc_hd__tapvpwrvgnd_1
XFILLER_65_673 VGND VGND VPWR VPWR sky130_fd_sc_hd__decap_3
X_07683_ _00160_ _00161_ VGND VGND VPWR VPWR _00162_ sky130_fd_sc_hd__nor2_1
X_09422_ _01582_ _01935_ VGND VGND VPWR VPWR _01937_ sky130_fd_sc_hd__xnor2_1
XFILLER_52_334 VPWR VGND VPWR VGND sky130_ef_sc_hd__decap_12
XFILLER_25_559 VGND VGND VPWR VPWR sky130_fd_sc_hd__fill_1
XFILLER_37_397 VGND VGND VPWR VPWR sky130_fd_sc_hd__fill_1
X_09353_ _01691_ _01742_ _01741_ VGND VGND VPWR VPWR _01862_ sky130_fd_sc_hd__a21oi_1
XFILLER_40_518 VPWR VGND VPWR VGND sky130_ef_sc_hd__decap_12
XFILLER_80_698 VGND VGND VPWR VPWR sky130_fd_sc_hd__fill_2
XFILLER_52_389 VPWR VGND VPWR VGND sky130_ef_sc_hd__decap_12
X_08304_ _00752_ _00777_ VGND VGND VPWR VPWR _00779_ sky130_fd_sc_hd__xnor2_1
XFILLER_21_732 VGND VGND VPWR VPWR sky130_fd_sc_hd__decap_4
X_09284_ net421 net336 VGND VGND VPWR VPWR _01787_ sky130_fd_sc_hd__nand2_1
XFILLER_60_18 VGND VGND VPWR VPWR sky130_fd_sc_hd__decap_8
XFILLER_119_620 VPWR VGND VPWR VGND sky130_ef_sc_hd__decap_12
XFILLER_60_29 VPWR VGND VPWR VGND sky130_ef_sc_hd__decap_12
X_08235_ _00579_ _00582_ _00709_ VGND VGND VPWR VPWR _00710_ sky130_fd_sc_hd__a21oi_1
XFILLER_20_253 VGND VGND VPWR VPWR sky130_fd_sc_hd__decap_6
XFILLER_118_141 VGND VGND VPWR VPWR sky130_fd_sc_hd__decap_4
X_08166_ _00504_ _00509_ _00377_ VGND VGND VPWR VPWR _00642_ sky130_fd_sc_hd__a21o_1
XFILLER_134_601 VPWR VGND VPWR VGND sky130_ef_sc_hd__decap_12
XFILLER_119_697 VGND VGND VPWR VPWR sky130_fd_sc_hd__decap_6
X_07117_ _04580_ _04591_ _04602_ VGND VGND VPWR VPWR _04613_ sky130_fd_sc_hd__or3_1
XFILLER_4_419 VGND VGND VPWR VPWR sky130_fd_sc_hd__fill_1
XFILLER_134_645 VGND VGND VPWR VPWR sky130_fd_sc_hd__fill_1
XFILLER_133_133 VGND VGND VPWR VPWR sky130_fd_sc_hd__fill_2
XFILLER_133_111 VGND VGND VPWR VPWR sky130_fd_sc_hd__fill_1
X_08097_ _00442_ _00445_ _00441_ VGND VGND VPWR VPWR _00573_ sky130_fd_sc_hd__a21oi_1
X_07048_ _03850_ _03806_ _03751_ _03773_ VGND VGND VPWR VPWR _03861_ sky130_fd_sc_hd__a211oi_4
XFILLER_88_732 VGND VGND VPWR VPWR sky130_fd_sc_hd__decap_8
XFILLER_0_636 VGND VGND VPWR VPWR sky130_fd_sc_hd__decap_8
XFILLER_125_55 VGND VGND VPWR VPWR sky130_fd_sc_hd__fill_1
XFILLER_88_765 VGND VGND VPWR VPWR sky130_fd_sc_hd__fill_1
XFILLER_85_15 VPWR VGND VPWR VGND sky130_ef_sc_hd__decap_12
XTAP_TAPCELL_ROW_110_1892 VGND VPWR sky130_fd_sc_hd__tapvpwrvgnd_1
X_08999_ net646 net371 net40 net653 VGND VGND VPWR VPWR _01477_ sky130_fd_sc_hd__a22oi_2
XFILLER_18_53 VPWR VGND VPWR VGND sky130_ef_sc_hd__decap_12
XTAP_TAPCELL_ROW_48_1002 VGND VPWR sky130_fd_sc_hd__tapvpwrvgnd_1
XFILLER_44_813 VGND VGND VPWR VPWR sky130_fd_sc_hd__decap_8
X_10961_ net449 net274 _03459_ _03460_ VGND VGND VPWR VPWR _03613_ sky130_fd_sc_hd__a31o_1
XTAP_TAPCELL_ROW_39_860 VGND VPWR sky130_fd_sc_hd__tapvpwrvgnd_1
XTAP_TAPCELL_ROW_39_871 VGND VPWR sky130_fd_sc_hd__tapvpwrvgnd_1
X_12700_ _05490_ _05506_ _05507_ VGND VGND VPWR VPWR _05508_ sky130_fd_sc_hd__and3_1
XFILLER_70_120 VGND VGND VPWR VPWR sky130_fd_sc_hd__fill_2
X_13680_ clknet_3_2__leaf_clk _00015_ net712 VGND VGND VPWR VPWR net199 sky130_fd_sc_hd__dfrtp_1
XFILLER_18_97 VGND VGND VPWR VPWR sky130_fd_sc_hd__decap_3
X_12631_ _05429_ net409 net572 _06762_ VGND VGND VPWR VPWR _05432_ sky130_fd_sc_hd__and4b_1
X_10892_ _03410_ _03413_ _03535_ VGND VGND VPWR VPWR _03537_ sky130_fd_sc_hd__and3_1
XFILLER_34_41 VPWR VGND VPWR VGND sky130_ef_sc_hd__decap_12
X_12562_ _05353_ _05356_ VGND VGND VPWR VPWR _05357_ sky130_fd_sc_hd__xnor2_1
X_12493_ net420 net391 VGND VGND VPWR VPWR _05281_ sky130_fd_sc_hd__nand2_1
XFILLER_7_213 VGND VGND VPWR VPWR sky130_fd_sc_hd__decap_8
XFILLER_11_275 VGND VGND VPWR VPWR sky130_fd_sc_hd__decap_4
X_11513_ net257 net290 VGND VGND VPWR VPWR _04216_ sky130_fd_sc_hd__nor2_1
XFILLER_8_769 VPWR VGND VPWR VGND sky130_ef_sc_hd__decap_12
XFILLER_7_235 VPWR VGND VPWR VGND sky130_ef_sc_hd__decap_12
X_11444_ _04116_ _04140_ VGND VGND VPWR VPWR _04141_ sky130_fd_sc_hd__or2_1
XFILLER_109_163 VGND VGND VPWR VPWR sky130_fd_sc_hd__fill_1
XFILLER_7_279 VGND VGND VPWR VPWR sky130_fd_sc_hd__fill_1
XFILLER_124_122 VPWR VGND VPWR VGND sky130_ef_sc_hd__decap_12
XTAP_TAPCELL_ROW_59_1153 VGND VPWR sky130_fd_sc_hd__tapvpwrvgnd_1
X_11375_ _04027_ _04064_ VGND VGND VPWR VPWR _04065_ sky130_fd_sc_hd__and2b_1
X_13114_ _05953_ _05957_ VGND VGND VPWR VPWR _05959_ sky130_fd_sc_hd__xnor2_1
X_10326_ net569 net312 _02916_ _02914_ VGND VGND VPWR VPWR _02918_ sky130_fd_sc_hd__a31o_1
XFILLER_3_463 VGND VGND VPWR VPWR sky130_fd_sc_hd__fill_2
XFILLER_124_177 VPWR VGND VPWR VGND sky130_ef_sc_hd__decap_12
X_13045_ _05883_ _05881_ VGND VGND VPWR VPWR _05884_ sky130_fd_sc_hd__and2b_1
XTAP_TAPCELL_ROW_72_1342 VGND VPWR sky130_fd_sc_hd__tapvpwrvgnd_1
X_10257_ _02806_ _02841_ VGND VGND VPWR VPWR _02843_ sky130_fd_sc_hd__xor2_1
XFILLER_78_253 VGND VGND VPWR VPWR sky130_fd_sc_hd__decap_8
XFILLER_59_93 VGND VGND VPWR VPWR sky130_fd_sc_hd__decap_6
X_10188_ _02720_ _02770_ VGND VGND VPWR VPWR _02772_ sky130_fd_sc_hd__xnor2_1
XFILLER_94_713 VPWR VGND VPWR VGND sky130_ef_sc_hd__decap_12
XFILLER_39_629 VPWR VGND VPWR VGND sky130_ef_sc_hd__decap_12
XFILLER_94_757 VGND VGND VPWR VPWR sky130_fd_sc_hd__decap_3
XFILLER_93_245 VGND VGND VPWR VPWR sky130_fd_sc_hd__decap_4
XFILLER_93_223 VGND VGND VPWR VPWR sky130_fd_sc_hd__fill_1
XFILLER_78_297 VGND VGND VPWR VPWR sky130_fd_sc_hd__decap_8
XFILLER_81_418 VGND VGND VPWR VPWR sky130_fd_sc_hd__decap_3
XFILLER_47_673 VPWR VGND VPWR VGND sky130_ef_sc_hd__decap_12
XFILLER_62_643 VGND VGND VPWR VPWR sky130_fd_sc_hd__fill_1
XFILLER_62_621 VGND VGND VPWR VPWR sky130_fd_sc_hd__decap_3
XTAP_TAPCELL_ROW_17_543 VGND VPWR sky130_fd_sc_hd__tapvpwrvgnd_1
XFILLER_98_3 VPWR VGND VPWR VGND sky130_ef_sc_hd__decap_12
X_12829_ _05642_ _05647_ VGND VGND VPWR VPWR _05648_ sky130_fd_sc_hd__and2_1
XFILLER_15_592 VGND VGND VPWR VPWR sky130_fd_sc_hd__fill_1
X_08020_ _00485_ _00496_ VGND VGND VPWR VPWR _00497_ sky130_fd_sc_hd__xnor2_1
XFILLER_116_601 VPWR VGND VPWR VGND sky130_ef_sc_hd__decap_12
XFILLER_115_111 VGND VGND VPWR VPWR sky130_fd_sc_hd__fill_1
XFILLER_131_615 VGND VGND VPWR VPWR sky130_fd_sc_hd__fill_1
X_09971_ net525 net342 _02375_ _02374_ net413 VGND VGND VPWR VPWR _02536_ sky130_fd_sc_hd__a32o_1
XFILLER_116_689 VGND VGND VPWR VPWR sky130_fd_sc_hd__decap_3
X_08922_ net574 net361 _01255_ _01254_ VGND VGND VPWR VPWR _01392_ sky130_fd_sc_hd__a31o_1
XFILLER_97_551 VGND VGND VPWR VPWR sky130_fd_sc_hd__fill_1
X_08853_ _01315_ _01318_ VGND VGND VPWR VPWR _01319_ sky130_fd_sc_hd__xnor2_1
XFILLER_84_212 VGND VGND VPWR VPWR sky130_fd_sc_hd__fill_1
XFILLER_69_275 VGND VGND VPWR VPWR sky130_fd_sc_hd__decap_4
X_08784_ _01248_ _01249_ VGND VGND VPWR VPWR _01250_ sky130_fd_sc_hd__xnor2_1
XFILLER_84_223 VPWR VGND VPWR VGND sky130_ef_sc_hd__decap_12
X_07804_ _00149_ _00282_ VGND VGND VPWR VPWR _00283_ sky130_fd_sc_hd__xnor2_1
XFILLER_72_429 VGND VGND VPWR VPWR sky130_fd_sc_hd__fill_2
X_07735_ _00209_ _00212_ VGND VGND VPWR VPWR _00214_ sky130_fd_sc_hd__xor2_1
XFILLER_26_813 VGND VGND VPWR VPWR sky130_fd_sc_hd__decap_6
XFILLER_38_662 VPWR VGND VPWR VGND sky130_ef_sc_hd__decap_12
XFILLER_25_301 VPWR VGND VPWR VGND sky130_ef_sc_hd__decap_12
XFILLER_37_161 VGND VGND VPWR VPWR sky130_fd_sc_hd__decap_4
X_09405_ net515 net509 net343 VGND VGND VPWR VPWR _01919_ sky130_fd_sc_hd__and3_1
XFILLER_53_665 VGND VGND VPWR VPWR sky130_fd_sc_hd__decap_6
XFILLER_52_153 VGND VGND VPWR VPWR sky130_fd_sc_hd__decap_8
XFILLER_52_131 VGND VGND VPWR VPWR sky130_fd_sc_hd__decap_8
X_07666_ _06734_ _06780_ _06779_ VGND VGND VPWR VPWR _00145_ sky130_fd_sc_hd__a21oi_1
XFILLER_111_57 VPWR VGND VPWR VGND sky130_ef_sc_hd__decap_12
XFILLER_80_495 VGND VGND VPWR VPWR sky130_fd_sc_hd__fill_1
X_07597_ net452 net664 net662 net460 VGND VGND VPWR VPWR _00077_ sky130_fd_sc_hd__a22o_1
XFILLER_25_389 VGND VGND VPWR VPWR sky130_fd_sc_hd__decap_3
XFILLER_40_315 VGND VGND VPWR VPWR sky130_fd_sc_hd__fill_2
X_09336_ _01841_ _01842_ _01665_ _01667_ VGND VGND VPWR VPWR _01844_ sky130_fd_sc_hd__o211a_1
XFILLER_52_197 VGND VGND VPWR VPWR sky130_fd_sc_hd__fill_1
XFILLER_21_540 VPWR VGND VPWR VGND sky130_ef_sc_hd__decap_12
XFILLER_138_225 VPWR VGND VPWR VGND sky130_ef_sc_hd__decap_12
X_09267_ net522 net342 VGND VGND VPWR VPWR _01768_ sky130_fd_sc_hd__nand2_4
XFILLER_21_595 VPWR VGND VPWR VGND sky130_ef_sc_hd__decap_12
X_08218_ net689 net536 net534 net688 VGND VGND VPWR VPWR _00693_ sky130_fd_sc_hd__and4b_1
X_09198_ _01571_ _01602_ _01603_ _01606_ _01570_ VGND VGND VPWR VPWR _01693_ sky130_fd_sc_hd__a32o_1
XFILLER_107_601 VGND VGND VPWR VPWR sky130_fd_sc_hd__fill_1
X_08149_ _00623_ _00624_ VGND VGND VPWR VPWR _00625_ sky130_fd_sc_hd__and2_1
XFILLER_134_464 VPWR VGND VPWR VGND sky130_ef_sc_hd__decap_12
XFILLER_106_166 VPWR VGND VPWR VGND sky130_ef_sc_hd__decap_12
X_11160_ net627 net618 net317 net316 VGND VGND VPWR VPWR _03831_ sky130_fd_sc_hd__and4_1
XFILLER_136_65 VPWR VGND VPWR VGND sky130_ef_sc_hd__decap_12
XFILLER_134_486 VGND VGND VPWR VPWR sky130_fd_sc_hd__decap_4
XTAP_TAPCELL_ROW_112_1921 VGND VPWR sky130_fd_sc_hd__tapvpwrvgnd_1
X_10111_ _02582_ _02583_ _02588_ _02580_ VGND VGND VPWR VPWR _02688_ sky130_fd_sc_hd__a22o_1
X_11091_ _03752_ _03753_ VGND VGND VPWR VPWR _03755_ sky130_fd_sc_hd__nor2_1
X_10042_ net255 _02611_ VGND VGND VPWR VPWR _02613_ sky130_fd_sc_hd__xnor2_1
XFILLER_102_361 VGND VGND VPWR VPWR sky130_fd_sc_hd__decap_3
XFILLER_76_713 VPWR VGND VPWR VGND sky130_ef_sc_hd__decap_12
XTAP_TAPCELL_ROW_54_1083 VGND VPWR sky130_fd_sc_hd__tapvpwrvgnd_1
XFILLER_76_757 VGND VGND VPWR VPWR sky130_fd_sc_hd__fill_1
XFILLER_76_746 VGND VGND VPWR VPWR sky130_fd_sc_hd__decap_8
XFILLER_75_223 VGND VGND VPWR VPWR sky130_fd_sc_hd__fill_1
XFILLER_48_459 VGND VGND VPWR VPWR sky130_fd_sc_hd__fill_1
XFILLER_91_727 VGND VGND VPWR VPWR sky130_fd_sc_hd__fill_1
XFILLER_75_267 VPWR VGND VPWR VGND sky130_ef_sc_hd__decap_12
XFILLER_35_109 VGND VGND VPWR VPWR sky130_fd_sc_hd__decap_3
XFILLER_90_226 VGND VGND VPWR VPWR sky130_fd_sc_hd__decap_6
X_11993_ _04687_ _04733_ VGND VGND VPWR VPWR _04735_ sky130_fd_sc_hd__xnor2_1
XFILLER_90_259 VGND VGND VPWR VPWR sky130_fd_sc_hd__fill_1
XFILLER_45_51 VGND VGND VPWR VPWR sky130_fd_sc_hd__decap_4
X_10944_ _03454_ _03476_ _03475_ VGND VGND VPWR VPWR _03594_ sky130_fd_sc_hd__a21o_1
XFILLER_28_194 VGND VGND VPWR VPWR sky130_fd_sc_hd__fill_2
XFILLER_32_805 VGND VGND VPWR VPWR sky130_fd_sc_hd__decap_6
X_13663_ clknet_3_4__leaf_clk _00057_ net717 VGND VGND VPWR VPWR net182 sky130_fd_sc_hd__dfrtp_1
XFILLER_71_484 VGND VGND VPWR VPWR sky130_fd_sc_hd__fill_1
X_10875_ _03414_ _03517_ VGND VGND VPWR VPWR _03519_ sky130_fd_sc_hd__xor2_1
XTAP_TAPCELL_ROW_14_502 VGND VPWR sky130_fd_sc_hd__tapvpwrvgnd_1
X_12614_ _05411_ _05412_ VGND VGND VPWR VPWR _05413_ sky130_fd_sc_hd__xnor2_1
X_13594_ _06407_ _06408_ _06405_ VGND VGND VPWR VPWR _06483_ sky130_fd_sc_hd__o21bai_1
XFILLER_31_337 VGND VGND VPWR VPWR sky130_fd_sc_hd__decap_6
XFILLER_129_225 VPWR VGND VPWR VGND sky130_ef_sc_hd__decap_12
X_12545_ net615 net386 _05175_ _05174_ VGND VGND VPWR VPWR _05338_ sky130_fd_sc_hd__a31o_1
XFILLER_138_781 VGND VGND VPWR VPWR sky130_fd_sc_hd__decap_3
X_12476_ _05252_ _05260_ VGND VGND VPWR VPWR _05262_ sky130_fd_sc_hd__xnor2_2
XFILLER_8_577 VGND VGND VPWR VPWR sky130_fd_sc_hd__fill_2
XFILLER_8_599 VGND VGND VPWR VPWR sky130_fd_sc_hd__decap_8
XANTENNA_5 net66 VGND VGND VPWR VPWR sky130_fd_sc_hd__diode_2
X_11427_ _03982_ _04121_ VGND VGND VPWR VPWR _04122_ sky130_fd_sc_hd__xor2_1
X_11358_ net248 _03905_ _03903_ VGND VGND VPWR VPWR _04047_ sky130_fd_sc_hd__o21ai_1
XFILLER_113_637 VGND VGND VPWR VPWR sky130_fd_sc_hd__decap_8
XFILLER_98_348 VGND VGND VPWR VPWR sky130_fd_sc_hd__fill_1
XFILLER_98_326 VGND VGND VPWR VPWR sky130_fd_sc_hd__decap_8
X_10309_ _02891_ _02899_ VGND VGND VPWR VPWR _02900_ sky130_fd_sc_hd__or2_1
X_11289_ _03831_ _03834_ VGND VGND VPWR VPWR _03972_ sky130_fd_sc_hd__nor2_1
XFILLER_121_681 VGND VGND VPWR VPWR sky130_fd_sc_hd__fill_2
X_13028_ _05863_ _05864_ VGND VGND VPWR VPWR _05866_ sky130_fd_sc_hd__nand2b_1
XFILLER_94_521 VGND VGND VPWR VPWR sky130_fd_sc_hd__fill_1
XFILLER_13_3 VPWR VGND VPWR VGND sky130_ef_sc_hd__decap_12
XFILLER_94_587 VGND VGND VPWR VPWR sky130_fd_sc_hd__fill_1
XTAP_TAPCELL_ROW_85_1533 VGND VPWR sky130_fd_sc_hd__tapvpwrvgnd_1
XFILLER_19_161 VGND VGND VPWR VPWR sky130_fd_sc_hd__fill_2
X_07520_ net581 net690 _06591_ _06590_ VGND VGND VPWR VPWR _06749_ sky130_fd_sc_hd__a31o_1
XFILLER_90_793 VPWR VGND VPWR VGND sky130_ef_sc_hd__decap_12
X_07451_ net101 net622 _06679_ _06680_ VGND VGND VPWR VPWR _06681_ sky130_fd_sc_hd__a22o_1
XFILLER_50_613 VPWR VGND VPWR VGND sky130_ef_sc_hd__decap_12
XFILLER_62_495 VPWR VGND VPWR VGND sky130_ef_sc_hd__decap_12
XFILLER_50_657 VPWR VGND VPWR VGND sky130_ef_sc_hd__decap_12
X_07382_ _06610_ _06611_ VGND VGND VPWR VPWR _06612_ sky130_fd_sc_hd__nand2_1
XFILLER_22_348 VPWR VGND VPWR VGND sky130_ef_sc_hd__decap_12
X_09121_ _01608_ VGND VGND VPWR VPWR _01609_ sky130_fd_sc_hd__inv_2
XFILLER_136_729 VGND VGND VPWR VPWR sky130_fd_sc_hd__decap_3
X_09052_ net352 net153 VGND VGND VPWR VPWR _01534_ sky130_fd_sc_hd__and2b_1
XFILLER_135_217 VGND VGND VPWR VPWR sky130_fd_sc_hd__decap_6
X_08003_ _00343_ _00479_ VGND VGND VPWR VPWR _00480_ sky130_fd_sc_hd__xor2_1
XTAP_TAPCELL_ROW_96_1695 VGND VPWR sky130_fd_sc_hd__tapvpwrvgnd_1
XTAP_TAPCELL_ROW_96_1684 VGND VPWR sky130_fd_sc_hd__tapvpwrvgnd_1
Xmax_cap241 _00913_ VGND VGND VPWR VPWR net241 sky130_fd_sc_hd__clkbuf_1
XFILLER_2_709 VGND VGND VPWR VPWR sky130_fd_sc_hd__decap_3
XFILLER_104_626 VPWR VGND VPWR VGND sky130_ef_sc_hd__decap_12
XFILLER_89_337 VGND VGND VPWR VPWR sky130_fd_sc_hd__decap_4
X_09954_ _02512_ _02515_ VGND VGND VPWR VPWR _02517_ sky130_fd_sc_hd__xor2_1
XFILLER_106_13 VPWR VGND VPWR VGND sky130_ef_sc_hd__decap_12
XFILLER_103_158 VGND VGND VPWR VPWR sky130_fd_sc_hd__decap_3
X_08905_ _01371_ _01372_ VGND VGND VPWR VPWR _01373_ sky130_fd_sc_hd__xnor2_1
X_09885_ _02182_ _02440_ VGND VGND VPWR VPWR _02442_ sky130_fd_sc_hd__xnor2_1
XFILLER_131_478 VGND VGND VPWR VPWR sky130_fd_sc_hd__fill_2
XFILLER_103_169 VGND VGND VPWR VPWR sky130_fd_sc_hd__decap_3
X_08836_ _01299_ _01300_ _01301_ VGND VGND VPWR VPWR _01302_ sky130_fd_sc_hd__or3_1
XFILLER_58_746 VGND VGND VPWR VPWR sky130_fd_sc_hd__decap_4
XFILLER_85_565 VGND VGND VPWR VPWR sky130_fd_sc_hd__fill_1
X_08767_ _01224_ _01226_ _01228_ _01232_ VGND VGND VPWR VPWR _01234_ sky130_fd_sc_hd__o211ai_1
XFILLER_66_790 VPWR VGND VPWR VGND sky130_ef_sc_hd__decap_12
XFILLER_26_632 VPWR VGND VPWR VGND sky130_ef_sc_hd__decap_12
XFILLER_38_470 VGND VGND VPWR VPWR sky130_fd_sc_hd__decap_6
X_08698_ _01163_ _01164_ VGND VGND VPWR VPWR _01165_ sky130_fd_sc_hd__nor2_1
XFILLER_82_27 VGND VGND VPWR VPWR sky130_fd_sc_hd__fill_1
XFILLER_53_440 VGND VGND VPWR VPWR sky130_fd_sc_hd__decap_8
X_07718_ net513 net502 net675 VGND VGND VPWR VPWR _00197_ sky130_fd_sc_hd__and3_1
XFILLER_25_131 VGND VGND VPWR VPWR sky130_fd_sc_hd__fill_1
XFILLER_53_473 VPWR VGND VPWR VGND sky130_ef_sc_hd__decap_12
X_07649_ _06781_ _00127_ _00128_ VGND VGND VPWR VPWR _00129_ sky130_fd_sc_hd__nand3_1
XTAP_TAPCELL_ROW_0_285 VGND VPWR sky130_fd_sc_hd__tapvpwrvgnd_1
XTAP_TAPCELL_ROW_0_296 VGND VPWR sky130_fd_sc_hd__tapvpwrvgnd_1
XFILLER_13_315 VPWR VGND VPWR VGND sky130_ef_sc_hd__decap_12
XFILLER_26_698 VGND VGND VPWR VPWR sky130_fd_sc_hd__fill_2
XFILLER_80_281 VGND VGND VPWR VPWR sky130_fd_sc_hd__decap_6
XFILLER_13_337 VGND VGND VPWR VPWR sky130_fd_sc_hd__decap_3
X_10660_ net435 net426 net281 net280 VGND VGND VPWR VPWR _03284_ sky130_fd_sc_hd__and4_1
X_09319_ _01822_ _01823_ _00108_ VGND VGND VPWR VPWR _01826_ sky130_fd_sc_hd__a21o_1
XFILLER_41_668 VGND VGND VPWR VPWR sky130_fd_sc_hd__decap_4
X_10591_ _02980_ _03129_ _03131_ VGND VGND VPWR VPWR _03208_ sky130_fd_sc_hd__a21o_1
X_12330_ _04812_ _04960_ _04786_ VGND VGND VPWR VPWR _05103_ sky130_fd_sc_hd__o21a_1
X_12261_ _05025_ _05026_ _05027_ VGND VGND VPWR VPWR _05028_ sky130_fd_sc_hd__or3_4
XFILLER_5_536 VGND VGND VPWR VPWR sky130_fd_sc_hd__fill_1
XFILLER_31_86 VGND VGND VPWR VPWR sky130_fd_sc_hd__fill_1
XFILLER_134_250 VGND VGND VPWR VPWR sky130_fd_sc_hd__fill_2
XTAP_TAPCELL_ROW_56_1112 VGND VPWR sky130_fd_sc_hd__tapvpwrvgnd_1
X_11212_ _03885_ _03886_ VGND VGND VPWR VPWR _03887_ sky130_fd_sc_hd__or2_1
XFILLER_31_97 VGND VGND VPWR VPWR sky130_fd_sc_hd__decap_4
XFILLER_122_401 VPWR VGND VPWR VGND sky130_ef_sc_hd__decap_12
X_12192_ net583 net577 net500 net593 VGND VGND VPWR VPWR _04952_ sky130_fd_sc_hd__a22o_1
XFILLER_1_720 VGND VGND VPWR VPWR sky130_fd_sc_hd__decap_8
XFILLER_1_753 VPWR VGND VPWR VGND sky130_ef_sc_hd__decap_12
X_11143_ _03639_ _03643_ VGND VGND VPWR VPWR _03812_ sky130_fd_sc_hd__and2_1
XFILLER_95_329 VGND VGND VPWR VPWR sky130_fd_sc_hd__decap_6
Xinput120 w32[6] VGND VGND VPWR VPWR net120 sky130_fd_sc_hd__clkbuf_2
X_11074_ _03734_ _03735_ VGND VGND VPWR VPWR _03736_ sky130_fd_sc_hd__nand2b_1
X_10025_ _02591_ _02592_ VGND VGND VPWR VPWR _02594_ sky130_fd_sc_hd__and2_1
XFILLER_102_180 VPWR VGND VPWR VGND sky130_ef_sc_hd__decap_12
Xinput142 x1[4] VGND VGND VPWR VPWR net142 sky130_fd_sc_hd__clkbuf_1
Xinput153 x2[7] VGND VGND VPWR VPWR net153 sky130_fd_sc_hd__clkbuf_8
Xinput131 x0[1] VGND VGND VPWR VPWR net131 sky130_fd_sc_hd__buf_4
XFILLER_1_797 VPWR VGND VPWR VGND sky130_ef_sc_hd__decap_12
XFILLER_76_587 VGND VGND VPWR VPWR sky130_fd_sc_hd__fill_1
XFILLER_76_576 VGND VGND VPWR VPWR sky130_fd_sc_hd__decap_3
X_11976_ net454 net393 net391 net462 VGND VGND VPWR VPWR _04716_ sky130_fd_sc_hd__a22oi_1
XFILLER_72_793 VPWR VGND VPWR VGND sky130_ef_sc_hd__decap_12
XTAP_TAPCELL_ROW_67_1274 VGND VPWR sky130_fd_sc_hd__tapvpwrvgnd_1
X_10927_ _03574_ _03569_ VGND VGND VPWR VPWR _03575_ sky130_fd_sc_hd__and2b_1
X_13646_ clknet_3_6__leaf_clk _00029_ net718 VGND VGND VPWR VPWR net165 sky130_fd_sc_hd__dfrtp_1
XTAP_TAPCELL_ROW_27_693 VGND VPWR sky130_fd_sc_hd__tapvpwrvgnd_1
XFILLER_31_134 VGND VGND VPWR VPWR sky130_fd_sc_hd__fill_1
XTAP_TAPCELL_ROW_80_1463 VGND VPWR sky130_fd_sc_hd__tapvpwrvgnd_1
XTAP_TAPCELL_ROW_80_1452 VGND VPWR sky130_fd_sc_hd__tapvpwrvgnd_1
X_10858_ _03497_ _03498_ VGND VGND VPWR VPWR _03501_ sky130_fd_sc_hd__xor2_1
XFILLER_31_156 VPWR VGND VPWR VGND sky130_ef_sc_hd__decap_12
X_13577_ _06441_ _06463_ VGND VGND VPWR VPWR _06464_ sky130_fd_sc_hd__xor2_1
X_10789_ _03421_ _03422_ VGND VGND VPWR VPWR _03425_ sky130_fd_sc_hd__xnor2_1
X_12528_ net461 net382 _05315_ VGND VGND VPWR VPWR _05320_ sky130_fd_sc_hd__and3_1
XFILLER_8_341 VGND VGND VPWR VPWR sky130_fd_sc_hd__decap_8
XFILLER_12_392 VGND VGND VPWR VPWR sky130_fd_sc_hd__fill_2
X_12459_ _05075_ _05077_ _05074_ VGND VGND VPWR VPWR _05244_ sky130_fd_sc_hd__o21ba_1
XFILLER_125_261 VGND VGND VPWR VPWR sky130_fd_sc_hd__fill_1
XFILLER_99_668 VGND VGND VPWR VPWR sky130_fd_sc_hd__decap_4
Xfanout309 net77 VGND VGND VPWR VPWR net309 sky130_fd_sc_hd__dlymetal6s2s_1
X_06951_ _02315_ _02793_ VGND VGND VPWR VPWR _02802_ sky130_fd_sc_hd__and2_1
X_09670_ _02078_ _02080_ _02077_ VGND VGND VPWR VPWR _02208_ sky130_fd_sc_hd__a21o_1
XFILLER_39_223 VGND VGND VPWR VPWR sky130_fd_sc_hd__fill_1
X_08621_ _01080_ _01087_ VGND VGND VPWR VPWR _01088_ sky130_fd_sc_hd__or2_1
XFILLER_94_362 VGND VGND VPWR VPWR sky130_fd_sc_hd__fill_2
X_06882_ net672 net459 net451 net674 VGND VGND VPWR VPWR _02052_ sky130_fd_sc_hd__a22oi_1
XFILLER_55_716 VGND VGND VPWR VPWR sky130_fd_sc_hd__decap_8
X_08552_ _01019_ _01020_ VGND VGND VPWR VPWR _01021_ sky130_fd_sc_hd__or2_1
XFILLER_82_557 VPWR VGND VPWR VGND sky130_ef_sc_hd__decap_12
XFILLER_63_760 VGND VGND VPWR VPWR sky130_fd_sc_hd__decap_8
X_07503_ _06619_ _06621_ _06730_ VGND VGND VPWR VPWR _06732_ sky130_fd_sc_hd__and3_1
XFILLER_35_462 VPWR VGND VPWR VGND sky130_ef_sc_hd__decap_12
X_08483_ _00800_ _00883_ _00882_ VGND VGND VPWR VPWR _00956_ sky130_fd_sc_hd__o21ba_1
X_07434_ net710 net604 VGND VGND VPWR VPWR _06664_ sky130_fd_sc_hd__nand2_1
XFILLER_50_432 VGND VGND VPWR VPWR sky130_fd_sc_hd__fill_1
XFILLER_22_134 VGND VGND VPWR VPWR sky130_fd_sc_hd__decap_6
XFILLER_23_635 VGND VGND VPWR VPWR sky130_fd_sc_hd__fill_1
XFILLER_10_307 VGND VGND VPWR VPWR sky130_fd_sc_hd__fill_1
XFILLER_22_156 VGND VGND VPWR VPWR sky130_fd_sc_hd__fill_1
XTAP_TAPCELL_ROW_98_1713 VGND VPWR sky130_fd_sc_hd__tapvpwrvgnd_1
X_07365_ _06592_ _06593_ VGND VGND VPWR VPWR _06595_ sky130_fd_sc_hd__xnor2_1
X_09104_ net447 net440 net334 net61 VGND VGND VPWR VPWR _01590_ sky130_fd_sc_hd__nand4_1
XTAP_TAPCELL_ROW_98_1724 VGND VPWR sky130_fd_sc_hd__tapvpwrvgnd_1
X_07296_ _06525_ _06526_ VGND VGND VPWR VPWR _06527_ sky130_fd_sc_hd__nor2_1
X_09035_ _01513_ _01515_ VGND VGND VPWR VPWR _00064_ sky130_fd_sc_hd__xor2_1
XFILLER_108_239 VGND VGND VPWR VPWR sky130_fd_sc_hd__decap_8
XFILLER_123_209 VGND VGND VPWR VPWR sky130_fd_sc_hd__decap_8
XFILLER_116_283 VGND VGND VPWR VPWR sky130_fd_sc_hd__decap_4
XFILLER_89_101 VGND VGND VPWR VPWR sky130_fd_sc_hd__decap_8
XFILLER_132_743 VPWR VGND VPWR VGND sky130_ef_sc_hd__decap_12
X_09937_ net368 net601 VGND VGND VPWR VPWR _02498_ sky130_fd_sc_hd__and2b_1
XFILLER_77_49 VGND VGND VPWR VPWR sky130_fd_sc_hd__decap_6
XFILLER_58_521 VGND VGND VPWR VPWR sky130_fd_sc_hd__decap_8
XFILLER_58_510 VGND VGND VPWR VPWR sky130_fd_sc_hd__fill_1
XTAP_TAPCELL_ROW_51_1042 VGND VPWR sky130_fd_sc_hd__tapvpwrvgnd_1
XFILLER_133_55 VGND VGND VPWR VPWR sky130_fd_sc_hd__fill_1
XTAP_TAPCELL_ROW_125_2109 VGND VPWR sky130_fd_sc_hd__tapvpwrvgnd_1
X_09868_ _02272_ _02297_ _02296_ VGND VGND VPWR VPWR _02424_ sky130_fd_sc_hd__o21a_1
XFILLER_93_15 VPWR VGND VPWR VGND sky130_ef_sc_hd__decap_12
XTAP_TAPCELL_ROW_5_377 VGND VPWR sky130_fd_sc_hd__tapvpwrvgnd_1
XTAP_TAPCELL_ROW_5_366 VGND VPWR sky130_fd_sc_hd__tapvpwrvgnd_1
X_09799_ _02342_ _02346_ VGND VGND VPWR VPWR _02349_ sky130_fd_sc_hd__xor2_1
X_08819_ net531 net347 _01284_ VGND VGND VPWR VPWR _01285_ sky130_fd_sc_hd__and3_1
XTAP_TAPCELL_ROW_107_1853 VGND VPWR sky130_fd_sc_hd__tapvpwrvgnd_1
XFILLER_73_557 VGND VGND VPWR VPWR sky130_fd_sc_hd__decap_3
XFILLER_61_719 VGND VGND VPWR VPWR sky130_fd_sc_hd__decap_8
XFILLER_45_248 VGND VGND VPWR VPWR sky130_fd_sc_hd__fill_2
X_11830_ _04559_ _04560_ VGND VGND VPWR VPWR _04561_ sky130_fd_sc_hd__xnor2_1
Xclkbuf_3_6__f_clk clknet_0_clk VGND VGND VPWR VPWR clknet_3_6__leaf_clk sky130_fd_sc_hd__clkbuf_16
XTAP_TAPCELL_ROW_44_939 VGND VPWR sky130_fd_sc_hd__tapvpwrvgnd_1
XFILLER_14_602 VGND VGND VPWR VPWR sky130_fd_sc_hd__decap_6
X_11761_ _04370_ _04374_ _04485_ VGND VGND VPWR VPWR _04486_ sky130_fd_sc_hd__a21oi_1
XFILLER_26_53 VGND VGND VPWR VPWR sky130_fd_sc_hd__decap_4
XFILLER_26_64 VPWR VGND VPWR VGND sky130_ef_sc_hd__decap_12
X_13500_ _06200_ _06202_ _06380_ VGND VGND VPWR VPWR _06381_ sky130_fd_sc_hd__o21a_1
XFILLER_53_281 VPWR VGND VPWR VGND sky130_ef_sc_hd__decap_12
X_10712_ _03338_ _03339_ _03280_ VGND VGND VPWR VPWR _03341_ sky130_fd_sc_hd__a21o_1
X_11692_ _04239_ _04278_ _04277_ VGND VGND VPWR VPWR _04411_ sky130_fd_sc_hd__a21boi_1
XTAP_TAPCELL_ROW_24_641 VGND VPWR sky130_fd_sc_hd__tapvpwrvgnd_1
XTAP_TAPCELL_ROW_24_652 VGND VPWR sky130_fd_sc_hd__tapvpwrvgnd_1
X_13431_ net601 net606 net284 VGND VGND VPWR VPWR _06305_ sky130_fd_sc_hd__mux2_1
XFILLER_42_41 VPWR VGND VPWR VGND sky130_ef_sc_hd__decap_12
X_10643_ _03253_ _03264_ VGND VGND VPWR VPWR _03265_ sky130_fd_sc_hd__xnor2_1
X_13362_ _06217_ _06229_ VGND VGND VPWR VPWR _06230_ sky130_fd_sc_hd__xnor2_1
XTAP_TAPCELL_ROW_62_1193 VGND VPWR sky130_fd_sc_hd__tapvpwrvgnd_1
XFILLER_42_85 VPWR VGND VPWR VGND sky130_ef_sc_hd__decap_12
X_10574_ _03189_ VGND VGND VPWR VPWR _03190_ sky130_fd_sc_hd__inv_2
XFILLER_22_690 VGND VGND VPWR VPWR sky130_fd_sc_hd__decap_4
X_12313_ net541 net711 _05082_ VGND VGND VPWR VPWR _05084_ sky130_fd_sc_hd__nand3_1
X_13293_ _06033_ _06154_ VGND VGND VPWR VPWR _06155_ sky130_fd_sc_hd__xnor2_2
XFILLER_135_581 VGND VGND VPWR VPWR sky130_fd_sc_hd__decap_3
X_12244_ _05005_ _05006_ _05007_ VGND VGND VPWR VPWR _05009_ sky130_fd_sc_hd__a21oi_1
XFILLER_123_754 VGND VGND VPWR VPWR sky130_fd_sc_hd__decap_6
X_12175_ _04928_ _04933_ VGND VGND VPWR VPWR _04934_ sky130_fd_sc_hd__xor2_2
XFILLER_122_253 VGND VGND VPWR VPWR sky130_fd_sc_hd__fill_2
XFILLER_96_605 VPWR VGND VPWR VGND sky130_ef_sc_hd__decap_12
XFILLER_68_307 VGND VGND VPWR VPWR sky130_fd_sc_hd__fill_1
XFILLER_1_561 VGND VGND VPWR VPWR sky130_fd_sc_hd__fill_2
X_11126_ _03792_ _03791_ VGND VGND VPWR VPWR _03793_ sky130_fd_sc_hd__nand2b_1
XFILLER_122_286 VGND VGND VPWR VPWR sky130_fd_sc_hd__fill_2
XFILLER_110_437 VGND VGND VPWR VPWR sky130_fd_sc_hd__decap_6
XFILLER_3_57 VPWR VGND VPWR VGND sky130_ef_sc_hd__decap_12
XFILLER_92_811 VGND VGND VPWR VPWR sky130_fd_sc_hd__fill_1
XTAP_TAPCELL_ROW_69_1303 VGND VPWR sky130_fd_sc_hd__tapvpwrvgnd_1
X_11057_ _03544_ _03716_ VGND VGND VPWR VPWR _03717_ sky130_fd_sc_hd__xor2_1
X_10008_ _02462_ _02487_ _02490_ VGND VGND VPWR VPWR _02576_ sky130_fd_sc_hd__o21ba_1
XFILLER_36_204 VGND VGND VPWR VPWR sky130_fd_sc_hd__decap_3
XFILLER_37_727 VGND VGND VPWR VPWR sky130_fd_sc_hd__fill_1
XFILLER_64_557 VPWR VGND VPWR VGND sky130_ef_sc_hd__decap_12
XFILLER_36_259 VGND VGND VPWR VPWR sky130_fd_sc_hd__fill_1
XFILLER_83_92 VPWR VGND VPWR VGND sky130_ef_sc_hd__decap_12
X_11959_ _04696_ _04698_ VGND VGND VPWR VPWR _04699_ sky130_fd_sc_hd__nand2_1
XFILLER_44_281 VGND VGND VPWR VPWR sky130_fd_sc_hd__fill_1
XFILLER_32_421 VGND VGND VPWR VPWR sky130_fd_sc_hd__decap_4
X_13629_ _06471_ _06520_ _06467_ VGND VGND VPWR VPWR _06521_ sky130_fd_sc_hd__mux2_1
X_07150_ _03237_ _03259_ _04958_ VGND VGND VPWR VPWR _04969_ sky130_fd_sc_hd__o21a_1
X_07081_ _04199_ _04210_ VGND VGND VPWR VPWR _04221_ sky130_fd_sc_hd__nor2_1
XFILLER_8_193 VGND VGND VPWR VPWR sky130_fd_sc_hd__decap_3
XTAP_TAPCELL_ROW_93_1643 VGND VPWR sky130_fd_sc_hd__tapvpwrvgnd_1
XFILLER_114_754 VGND VGND VPWR VPWR sky130_fd_sc_hd__fill_2
XFILLER_99_432 VGND VGND VPWR VPWR sky130_fd_sc_hd__fill_2
XTAP_TAPCELL_ROW_93_1654 VGND VPWR sky130_fd_sc_hd__tapvpwrvgnd_1
XFILLER_87_605 VGND VGND VPWR VPWR sky130_fd_sc_hd__fill_2
X_09722_ net419 net331 _02263_ _02264_ VGND VGND VPWR VPWR _02265_ sky130_fd_sc_hd__o2bb2a_1
XFILLER_101_437 VGND VGND VPWR VPWR sky130_fd_sc_hd__decap_8
XFILLER_86_115 VGND VGND VPWR VPWR sky130_fd_sc_hd__fill_1
X_07983_ _00451_ _00459_ VGND VGND VPWR VPWR _00460_ sky130_fd_sc_hd__xnor2_1
X_06934_ net590 net581 net699 net697 VGND VGND VPWR VPWR _02619_ sky130_fd_sc_hd__and4_1
X_09653_ net549 net356 VGND VGND VPWR VPWR _02189_ sky130_fd_sc_hd__nand2_1
XFILLER_67_362 VGND VGND VPWR VPWR sky130_fd_sc_hd__decap_4
X_06865_ _01824_ _01857_ VGND VGND VPWR VPWR _01867_ sky130_fd_sc_hd__or2_1
XTAP_TAPCELL_ROW_2_325 VGND VPWR sky130_fd_sc_hd__tapvpwrvgnd_1
XFILLER_28_738 VPWR VGND VPWR VGND sky130_ef_sc_hd__decap_12
X_08604_ _01022_ _01028_ _01071_ VGND VGND VPWR VPWR _01072_ sky130_fd_sc_hd__a21oi_1
X_09584_ _02111_ _02112_ net418 net333 VGND VGND VPWR VPWR _02114_ sky130_fd_sc_hd__and4bb_1
XFILLER_27_237 VGND VGND VPWR VPWR sky130_fd_sc_hd__fill_1
XPHY_EDGE_ROW_118_Right_118 VGND VGND VPWR VPWR sky130_fd_sc_hd__decap_3
X_08535_ _01003_ _01004_ VGND VGND VPWR VPWR _00009_ sky130_fd_sc_hd__and2_1
XFILLER_103_69 VPWR VGND VPWR VGND sky130_ef_sc_hd__decap_12
XFILLER_82_376 VPWR VGND VPWR VGND sky130_ef_sc_hd__decap_12
XFILLER_82_365 VGND VGND VPWR VPWR sky130_fd_sc_hd__fill_2
XTAP_TAPCELL_ROW_120_2039 VGND VPWR sky130_fd_sc_hd__tapvpwrvgnd_1
XFILLER_35_281 VPWR VGND VPWR VGND sky130_ef_sc_hd__decap_12
XFILLER_36_793 VPWR VGND VPWR VGND sky130_ef_sc_hd__decap_12
X_08466_ _00927_ _00938_ VGND VGND VPWR VPWR _00939_ sky130_fd_sc_hd__xnor2_1
XTAP_TAPCELL_ROW_102_1783 VGND VPWR sky130_fd_sc_hd__tapvpwrvgnd_1
XTAP_TAPCELL_ROW_102_1772 VGND VPWR sky130_fd_sc_hd__tapvpwrvgnd_1
X_07417_ _06160_ _06645_ _06646_ VGND VGND VPWR VPWR _06647_ sky130_fd_sc_hd__nand3b_1
XFILLER_51_785 VPWR VGND VPWR VGND sky130_ef_sc_hd__decap_12
X_08397_ _00708_ _00710_ _00870_ VGND VGND VPWR VPWR _00871_ sky130_fd_sc_hd__o21a_1
XFILLER_11_638 VPWR VGND VPWR VGND sky130_ef_sc_hd__decap_12
XTAP_TAPCELL_ROW_21_600 VGND VPWR sky130_fd_sc_hd__tapvpwrvgnd_1
XFILLER_10_159 VGND VGND VPWR VPWR sky130_fd_sc_hd__fill_2
X_07348_ net701 net699 net546 net537 VGND VGND VPWR VPWR _06578_ sky130_fd_sc_hd__and4_1
XTAP_TAPCELL_ROW_135_2260 VGND VPWR sky130_fd_sc_hd__tapvpwrvgnd_1
XFILLER_109_559 VGND VGND VPWR VPWR sky130_fd_sc_hd__fill_1
X_07279_ net449 net666 VGND VGND VPWR VPWR _06378_ sky130_fd_sc_hd__nand2_1
XFILLER_12_77 VGND VGND VPWR VPWR sky130_fd_sc_hd__decap_6
XFILLER_136_378 VGND VGND VPWR VPWR sky130_fd_sc_hd__fill_2
XFILLER_128_77 VGND VGND VPWR VPWR sky130_fd_sc_hd__decap_6
X_09018_ _01438_ _01495_ _01496_ VGND VGND VPWR VPWR _01498_ sky130_fd_sc_hd__nand3_1
XFILLER_105_721 VGND VGND VPWR VPWR sky130_fd_sc_hd__decap_6
XFILLER_88_15 VPWR VGND VPWR VGND sky130_ef_sc_hd__decap_12
X_10290_ _02869_ _02879_ VGND VGND VPWR VPWR _02880_ sky130_fd_sc_hd__nor2_1
XFILLER_105_765 VPWR VGND VPWR VGND sky130_ef_sc_hd__decap_12
XFILLER_104_253 VGND VGND VPWR VPWR sky130_fd_sc_hd__decap_8
XFILLER_132_584 VGND VGND VPWR VPWR sky130_fd_sc_hd__decap_4
XFILLER_120_757 VGND VGND VPWR VPWR sky130_fd_sc_hd__decap_3
Xfanout640 net641 VGND VGND VPWR VPWR net640 sky130_fd_sc_hd__clkbuf_2
XFILLER_104_297 VGND VGND VPWR VPWR sky130_fd_sc_hd__decap_4
XFILLER_78_638 VGND VGND VPWR VPWR sky130_fd_sc_hd__decap_6
Xfanout651 net653 VGND VGND VPWR VPWR net651 sky130_fd_sc_hd__buf_2
XFILLER_93_608 VGND VGND VPWR VPWR sky130_fd_sc_hd__decap_8
Xfanout673 net123 VGND VGND VPWR VPWR net673 sky130_fd_sc_hd__clkbuf_2
Xfanout662 net129 VGND VGND VPWR VPWR net662 sky130_fd_sc_hd__dlymetal6s2s_1
Xfanout684 net117 VGND VGND VPWR VPWR net684 sky130_fd_sc_hd__buf_2
XFILLER_100_470 VGND VGND VPWR VPWR sky130_fd_sc_hd__decap_6
X_12931_ _05600_ net247 _05605_ VGND VGND VPWR VPWR _05759_ sky130_fd_sc_hd__a21o_1
Xfanout695 net11 VGND VGND VPWR VPWR net695 sky130_fd_sc_hd__buf_2
XFILLER_74_811 VGND VGND VPWR VPWR sky130_fd_sc_hd__fill_1
XTAP_TAPCELL_ROW_29_722 VGND VPWR sky130_fd_sc_hd__tapvpwrvgnd_1
XFILLER_100_492 VPWR VGND VPWR VGND sky130_ef_sc_hd__decap_12
XFILLER_100_481 VGND VGND VPWR VPWR sky130_fd_sc_hd__fill_1
XFILLER_73_343 VGND VGND VPWR VPWR sky130_fd_sc_hd__fill_1
X_12862_ _05316_ _05683_ VGND VGND VPWR VPWR _05684_ sky130_fd_sc_hd__nor2_1
XFILLER_61_505 VPWR VGND VPWR VGND sky130_ef_sc_hd__decap_12
X_11813_ _04296_ _04425_ _04303_ _04426_ _04541_ VGND VGND VPWR VPWR _04543_ sky130_fd_sc_hd__o311a_4
XFILLER_27_771 VPWR VGND VPWR VGND sky130_ef_sc_hd__decap_12
X_12793_ _05598_ _05606_ VGND VGND VPWR VPWR _05608_ sky130_fd_sc_hd__xor2_1
XTAP_TAPCELL_ROW_64_1233 VGND VPWR sky130_fd_sc_hd__tapvpwrvgnd_1
XTAP_TAPCELL_ROW_64_1222 VGND VPWR sky130_fd_sc_hd__tapvpwrvgnd_1
XFILLER_42_730 VGND VGND VPWR VPWR sky130_fd_sc_hd__decap_3
XFILLER_53_51 VGND VGND VPWR VPWR sky130_fd_sc_hd__decap_4
X_11744_ _04212_ _04466_ VGND VGND VPWR VPWR _04467_ sky130_fd_sc_hd__xnor2_4
XFILLER_41_262 VPWR VGND VPWR VGND sky130_ef_sc_hd__decap_12
X_11675_ net256 net272 _03427_ VGND VGND VPWR VPWR _04392_ sky130_fd_sc_hd__o21a_1
XFILLER_128_813 VGND VGND VPWR VPWR sky130_fd_sc_hd__decap_8
X_13414_ _06284_ _06285_ VGND VGND VPWR VPWR _06287_ sky130_fd_sc_hd__xor2_1
X_10626_ _03245_ _03207_ VGND VGND VPWR VPWR _03246_ sky130_fd_sc_hd__and2b_1
XFILLER_127_312 VGND VGND VPWR VPWR sky130_fd_sc_hd__fill_1
XFILLER_10_671 VPWR VGND VPWR VGND sky130_ef_sc_hd__decap_12
X_13345_ _06209_ _06210_ VGND VGND VPWR VPWR _06211_ sky130_fd_sc_hd__nand2b_1
XFILLER_6_653 VGND VGND VPWR VPWR sky130_fd_sc_hd__fill_2
X_10557_ _02985_ _02999_ _02998_ VGND VGND VPWR VPWR _03171_ sky130_fd_sc_hd__a21bo_1
XFILLER_127_389 VGND VGND VPWR VPWR sky130_fd_sc_hd__decap_3
XFILLER_115_529 VGND VGND VPWR VPWR sky130_fd_sc_hd__decap_4
X_13276_ _06135_ _06126_ VGND VGND VPWR VPWR _06136_ sky130_fd_sc_hd__and2b_1
XFILLER_6_686 VGND VGND VPWR VPWR sky130_fd_sc_hd__decap_8
X_10488_ _03091_ _03092_ VGND VGND VPWR VPWR _03096_ sky130_fd_sc_hd__xnor2_2
XFILLER_108_581 VGND VGND VPWR VPWR sky130_fd_sc_hd__decap_6
X_12227_ _04987_ _04989_ VGND VGND VPWR VPWR _04990_ sky130_fd_sc_hd__xnor2_1
XTAP_TAPCELL_ROW_75_1384 VGND VPWR sky130_fd_sc_hd__tapvpwrvgnd_1
XFILLER_111_724 VGND VGND VPWR VPWR sky130_fd_sc_hd__decap_4
XFILLER_96_446 VGND VGND VPWR VPWR sky130_fd_sc_hd__decap_8
X_12158_ _04807_ _04913_ _04914_ VGND VGND VPWR VPWR _04916_ sky130_fd_sc_hd__and3_1
X_12089_ _04832_ _04837_ VGND VGND VPWR VPWR _04840_ sky130_fd_sc_hd__xor2_1
X_11109_ net492 net290 _03772_ _03774_ VGND VGND VPWR VPWR _03775_ sky130_fd_sc_hd__a22o_1
XFILLER_77_671 VGND VGND VPWR VPWR sky130_fd_sc_hd__fill_1
XFILLER_76_192 VGND VGND VPWR VPWR sky130_fd_sc_hd__decap_4
XFILLER_64_365 VPWR VGND VPWR VGND sky130_ef_sc_hd__decap_12
XFILLER_91_173 VGND VGND VPWR VPWR sky130_fd_sc_hd__fill_1
XFILLER_17_281 VGND VGND VPWR VPWR sky130_fd_sc_hd__fill_1
XFILLER_18_793 VPWR VGND VPWR VGND sky130_ef_sc_hd__decap_12
X_08320_ _00793_ _00794_ VGND VGND VPWR VPWR _00795_ sky130_fd_sc_hd__and2b_1
X_08251_ net610 _00516_ _00514_ VGND VGND VPWR VPWR _00726_ sky130_fd_sc_hd__a21oi_2
XFILLER_20_413 VGND VGND VPWR VPWR sky130_fd_sc_hd__decap_6
XFILLER_32_251 VGND VGND VPWR VPWR sky130_fd_sc_hd__fill_1
XFILLER_33_785 VPWR VGND VPWR VGND sky130_ef_sc_hd__decap_12
X_07202_ _04177_ _04232_ _05505_ _05516_ VGND VGND VPWR VPWR _05538_ sky130_fd_sc_hd__a22o_1
X_08182_ _00657_ _00656_ VGND VGND VPWR VPWR _00658_ sky130_fd_sc_hd__nand2b_1
XFILLER_134_805 VGND VGND VPWR VPWR sky130_fd_sc_hd__decap_6
X_07133_ _03314_ _04772_ VGND VGND VPWR VPWR _04783_ sky130_fd_sc_hd__xnor2_1
X_07064_ _03937_ _03959_ _03948_ VGND VGND VPWR VPWR _04035_ sky130_fd_sc_hd__o21ai_1
Xoutput210 net210 VGND VGND VPWR VPWR y2[7] sky130_fd_sc_hd__buf_2
XPHY_EDGE_ROW_12_Right_12 VGND VGND VPWR VPWR sky130_fd_sc_hd__decap_3
XFILLER_133_337 VPWR VGND VPWR VGND sky130_ef_sc_hd__decap_12
Xoutput221 net221 VGND VGND VPWR VPWR y3[1] sky130_fd_sc_hd__buf_2
XTAP_TAPCELL_ROW_7_406 VGND VPWR sky130_fd_sc_hd__tapvpwrvgnd_1
XFILLER_99_240 VGND VGND VPWR VPWR sky130_fd_sc_hd__fill_2
XFILLER_58_29 VPWR VGND VPWR VGND sky130_ef_sc_hd__decap_12
XTAP_TAPCELL_ROW_130_2190 VGND VPWR sky130_fd_sc_hd__tapvpwrvgnd_1
XFILLER_101_223 VGND VGND VPWR VPWR sky130_fd_sc_hd__fill_1
XFILLER_102_757 VPWR VGND VPWR VGND sky130_ef_sc_hd__decap_12
X_07966_ net693 net691 net536 net534 VGND VGND VPWR VPWR _00443_ sky130_fd_sc_hd__and4b_1
X_09705_ _02241_ _02245_ VGND VGND VPWR VPWR _02246_ sky130_fd_sc_hd__and2b_1
XFILLER_68_693 VGND VGND VPWR VPWR sky130_fd_sc_hd__decap_6
X_06917_ net687 net511 net503 net114 VGND VGND VPWR VPWR _02434_ sky130_fd_sc_hd__a22oi_1
X_09636_ _02168_ _02169_ VGND VGND VPWR VPWR _02171_ sky130_fd_sc_hd__xor2_1
X_07897_ _00075_ _00232_ _00373_ VGND VGND VPWR VPWR _00375_ sky130_fd_sc_hd__o21ai_1
XTAP_TAPCELL_ROW_104_1801 VGND VPWR sky130_fd_sc_hd__tapvpwrvgnd_1
XFILLER_83_685 VPWR VGND VPWR VGND sky130_ef_sc_hd__decap_12
XFILLER_71_803 VGND VGND VPWR VPWR sky130_fd_sc_hd__fill_1
X_06848_ net674 net459 VGND VGND VPWR VPWR _01682_ sky130_fd_sc_hd__nand2_1
XFILLER_43_505 VGND VGND VPWR VPWR sky130_fd_sc_hd__decap_4
XFILLER_16_708 VGND VGND VPWR VPWR sky130_fd_sc_hd__fill_1
XPHY_EDGE_ROW_21_Right_21 VGND VGND VPWR VPWR sky130_fd_sc_hd__decap_3
X_09567_ _01768_ _02094_ VGND VGND VPWR VPWR _02095_ sky130_fd_sc_hd__xnor2_1
XTAP_TAPCELL_ROW_104_1812 VGND VPWR sky130_fd_sc_hd__tapvpwrvgnd_1
XFILLER_82_195 VGND VGND VPWR VPWR sky130_fd_sc_hd__fill_1
X_09498_ _01688_ _02019_ VGND VGND VPWR VPWR _02021_ sky130_fd_sc_hd__xnor2_1
XFILLER_90_27 VGND VGND VPWR VPWR sky130_fd_sc_hd__fill_1
X_08518_ _00923_ _00945_ _00922_ VGND VGND VPWR VPWR _00990_ sky130_fd_sc_hd__o21a_1
XFILLER_51_582 VPWR VGND VPWR VGND sky130_ef_sc_hd__decap_12
X_08449_ _00819_ _00846_ _00920_ VGND VGND VPWR VPWR _00922_ sky130_fd_sc_hd__o21ai_1
XFILLER_128_109 VPWR VGND VPWR VGND sky130_ef_sc_hd__decap_12
XFILLER_11_446 VGND VGND VPWR VPWR sky130_fd_sc_hd__fill_2
XTAP_TAPCELL_ROW_34_791 VGND VPWR sky130_fd_sc_hd__tapvpwrvgnd_1
XFILLER_128_3 VPWR VGND VPWR VGND sky130_ef_sc_hd__decap_12
X_11460_ _04155_ _04157_ VGND VGND VPWR VPWR _04159_ sky130_fd_sc_hd__xor2_1
XFILLER_11_468 VPWR VGND VPWR VGND sky130_ef_sc_hd__decap_12
X_11391_ _04075_ _04082_ VGND VGND VPWR VPWR _04083_ sky130_fd_sc_hd__xnor2_1
XPHY_EDGE_ROW_30_Right_30 VGND VGND VPWR VPWR sky130_fd_sc_hd__decap_3
X_10411_ _03000_ _03001_ _03009_ VGND VGND VPWR VPWR _03012_ sky130_fd_sc_hd__a21o_1
XFILLER_136_153 VPWR VGND VPWR VGND sky130_ef_sc_hd__decap_12
XFILLER_99_69 VPWR VGND VPWR VGND sky130_ef_sc_hd__decap_12
X_13130_ _05975_ _05976_ VGND VGND VPWR VPWR _05977_ sky130_fd_sc_hd__xnor2_2
X_10342_ _02903_ _02934_ VGND VGND VPWR VPWR _02936_ sky130_fd_sc_hd__xor2_1
XTAP_TAPCELL_ROW_115_1963 VGND VPWR sky130_fd_sc_hd__tapvpwrvgnd_1
X_13061_ net578 net500 net539 net533 VGND VGND VPWR VPWR _05901_ sky130_fd_sc_hd__and4b_1
X_12012_ net516 net507 net406 VGND VGND VPWR VPWR _04755_ sky130_fd_sc_hd__and3_1
XFILLER_3_656 VPWR VGND VPWR VGND sky130_ef_sc_hd__decap_12
XFILLER_2_133 VGND VGND VPWR VPWR sky130_fd_sc_hd__decap_6
X_10273_ net520 net295 VGND VGND VPWR VPWR _02861_ sky130_fd_sc_hd__nand2_1
Xfanout481 net482 VGND VGND VPWR VPWR net481 sky130_fd_sc_hd__clkbuf_2
Xfanout470 net471 VGND VGND VPWR VPWR net470 sky130_fd_sc_hd__buf_2
Xfanout492 net499 VGND VGND VPWR VPWR net492 sky130_fd_sc_hd__clkbuf_4
XFILLER_93_449 VGND VGND VPWR VPWR sky130_fd_sc_hd__decap_8
XFILLER_74_641 VGND VGND VPWR VPWR sky130_fd_sc_hd__decap_3
XFILLER_58_181 VGND VGND VPWR VPWR sky130_fd_sc_hd__fill_1
X_12914_ net564 net555 net408 VGND VGND VPWR VPWR _05740_ sky130_fd_sc_hd__and3_1
XFILLER_74_663 VGND VGND VPWR VPWR sky130_fd_sc_hd__decap_3
XFILLER_46_365 VGND VGND VPWR VPWR sky130_fd_sc_hd__decap_8
XFILLER_0_69 VGND VGND VPWR VPWR sky130_fd_sc_hd__decap_8
X_12845_ net420 net388 VGND VGND VPWR VPWR _05665_ sky130_fd_sc_hd__nand2_1
XFILLER_61_324 VPWR VGND VPWR VGND sky130_ef_sc_hd__decap_12
XFILLER_46_387 VGND VGND VPWR VPWR sky130_fd_sc_hd__decap_3
XFILLER_34_549 VPWR VGND VPWR VGND sky130_ef_sc_hd__decap_12
X_12776_ net541 net659 net680 net266 VGND VGND VPWR VPWR _05589_ sky130_fd_sc_hd__o2bb2a_1
XFILLER_15_741 VGND VGND VPWR VPWR sky130_fd_sc_hd__decap_3
XFILLER_14_251 VGND VGND VPWR VPWR sky130_fd_sc_hd__fill_1
XFILLER_15_785 VPWR VGND VPWR VGND sky130_ef_sc_hd__decap_12
X_11727_ _04446_ _04447_ VGND VGND VPWR VPWR _04448_ sky130_fd_sc_hd__nand2_1
XFILLER_42_593 VGND VGND VPWR VPWR sky130_fd_sc_hd__fill_1
XFILLER_14_295 VGND VGND VPWR VPWR sky130_fd_sc_hd__fill_1
XFILLER_128_632 VGND VGND VPWR VPWR sky130_fd_sc_hd__decap_4
X_11658_ _04365_ _04372_ VGND VGND VPWR VPWR _04374_ sky130_fd_sc_hd__nand2_1
XFILLER_127_120 VPWR VGND VPWR VGND sky130_ef_sc_hd__decap_12
XFILLER_116_805 VGND VGND VPWR VPWR sky130_fd_sc_hd__decap_6
XTAP_TAPCELL_ROW_77_1413 VGND VPWR sky130_fd_sc_hd__tapvpwrvgnd_1
X_10609_ net588 net579 net304 net301 VGND VGND VPWR VPWR _03228_ sky130_fd_sc_hd__and4_1
X_11589_ _04163_ _04019_ _04161_ VGND VGND VPWR VPWR _04299_ sky130_fd_sc_hd__nor3b_1
XTAP_TAPCELL_ROW_12_474 VGND VPWR sky130_fd_sc_hd__tapvpwrvgnd_1
XFILLER_127_164 VGND VGND VPWR VPWR sky130_fd_sc_hd__fill_1
X_13328_ _06055_ _06057_ VGND VGND VPWR VPWR _06193_ sky130_fd_sc_hd__nand2_1
XFILLER_115_337 VGND VGND VPWR VPWR sky130_fd_sc_hd__decap_4
XTAP_TAPCELL_ROW_90_1602 VGND VPWR sky130_fd_sc_hd__tapvpwrvgnd_1
X_13259_ _05316_ _06115_ VGND VGND VPWR VPWR _06118_ sky130_fd_sc_hd__xnor2_1
XFILLER_43_3 VPWR VGND VPWR VGND sky130_ef_sc_hd__decap_12
XFILLER_123_370 VGND VGND VPWR VPWR sky130_fd_sc_hd__fill_2
XFILLER_96_221 VGND VGND VPWR VPWR sky130_fd_sc_hd__decap_6
XFILLER_69_435 VPWR VGND VPWR VGND sky130_ef_sc_hd__decap_12
XFILLER_111_565 VGND VGND VPWR VPWR sky130_fd_sc_hd__fill_1
XFILLER_111_554 VGND VGND VPWR VPWR sky130_fd_sc_hd__decap_6
X_07820_ _00190_ _00222_ _00221_ VGND VGND VPWR VPWR _00298_ sky130_fd_sc_hd__a21oi_2
XFILLER_111_587 VPWR VGND VPWR VGND sky130_ef_sc_hd__decap_12
XFILLER_84_405 VPWR VGND VPWR VGND sky130_ef_sc_hd__decap_12
X_07751_ _00228_ _00229_ VGND VGND VPWR VPWR _00230_ sky130_fd_sc_hd__or2_1
XFILLER_38_811 VGND VGND VPWR VPWR sky130_fd_sc_hd__fill_1
XFILLER_37_321 VGND VGND VPWR VPWR sky130_fd_sc_hd__fill_1
XTAP_TAPCELL_ROW_88_1575 VGND VPWR sky130_fd_sc_hd__tapvpwrvgnd_1
XFILLER_37_343 VGND VGND VPWR VPWR sky130_fd_sc_hd__fill_1
XFILLER_37_365 VPWR VGND VPWR VGND sky130_ef_sc_hd__decap_12
X_07682_ net697 net538 net264 net700 VGND VGND VPWR VPWR _00161_ sky130_fd_sc_hd__o2bb2a_1
X_09421_ net336 net255 VGND VGND VPWR VPWR _01936_ sky130_fd_sc_hd__nor2_1
XFILLER_80_633 VGND VGND VPWR VPWR sky130_fd_sc_hd__fill_1
XFILLER_64_173 VGND VGND VPWR VPWR sky130_fd_sc_hd__fill_2
XFILLER_52_313 VGND VGND VPWR VPWR sky130_fd_sc_hd__fill_1
X_09352_ _01860_ _01861_ VGND VGND VPWR VPWR _00066_ sky130_fd_sc_hd__xor2_1
XFILLER_52_346 VPWR VGND VPWR VGND sky130_ef_sc_hd__decap_12
XFILLER_40_508 VGND VGND VPWR VPWR sky130_fd_sc_hd__decap_3
XFILLER_100_26 VGND VGND VPWR VPWR sky130_fd_sc_hd__fill_2
X_08303_ _00752_ _00777_ VGND VGND VPWR VPWR _00778_ sky130_fd_sc_hd__or2_1
X_09283_ _01784_ _01785_ VGND VGND VPWR VPWR _01786_ sky130_fd_sc_hd__and2b_1
XTAP_TAPCELL_ROW_119_2030 VGND VPWR sky130_fd_sc_hd__tapvpwrvgnd_1
X_08234_ _00702_ _00707_ VGND VGND VPWR VPWR _00709_ sky130_fd_sc_hd__xor2_1
XTAP_TAPCELL_ROW_31_750 VGND VPWR sky130_fd_sc_hd__tapvpwrvgnd_1
XFILLER_119_632 VPWR VGND VPWR VGND sky130_ef_sc_hd__decap_12
XFILLER_118_131 VGND VGND VPWR VPWR sky130_fd_sc_hd__fill_2
X_08165_ _00639_ _00640_ VGND VGND VPWR VPWR _00641_ sky130_fd_sc_hd__xnor2_1
XFILLER_134_613 VPWR VGND VPWR VGND sky130_ef_sc_hd__decap_12
X_07116_ net512 net685 net504 net116 VGND VGND VPWR VPWR _04602_ sky130_fd_sc_hd__a22oi_2
XFILLER_118_197 VGND VGND VPWR VPWR sky130_fd_sc_hd__decap_4
XFILLER_109_57 VPWR VGND VPWR VGND sky130_ef_sc_hd__decap_12
XFILLER_106_337 VGND VGND VPWR VPWR sky130_fd_sc_hd__fill_1
X_08096_ _00570_ _00571_ VGND VGND VPWR VPWR _00572_ sky130_fd_sc_hd__and2b_1
XFILLER_133_167 VGND VGND VPWR VPWR sky130_fd_sc_hd__fill_1
X_07047_ _03795_ _03828_ _03839_ VGND VGND VPWR VPWR _03850_ sky130_fd_sc_hd__or3_4
XFILLER_0_615 VGND VGND VPWR VPWR sky130_fd_sc_hd__fill_1
XTAP_TAPCELL_ROW_110_1893 VGND VPWR sky130_fd_sc_hd__tapvpwrvgnd_1
XFILLER_102_587 VGND VGND VPWR VPWR sky130_fd_sc_hd__fill_1
X_08998_ net652 net646 net371 net368 VGND VGND VPWR VPWR _01476_ sky130_fd_sc_hd__and4_1
XFILLER_85_27 VPWR VGND VPWR VGND sky130_ef_sc_hd__decap_12
XFILLER_47_107 VGND VGND VPWR VPWR sky130_fd_sc_hd__decap_4
XFILLER_75_449 VPWR VGND VPWR VGND sky130_ef_sc_hd__decap_12
X_07949_ _00139_ _00288_ _00289_ VGND VGND VPWR VPWR _00427_ sky130_fd_sc_hd__a21boi_1
XFILLER_90_408 VPWR VGND VPWR VGND sky130_ef_sc_hd__decap_12
XFILLER_55_140 VGND VGND VPWR VPWR sky130_fd_sc_hd__decap_4
XFILLER_18_65 VGND VGND VPWR VPWR sky130_fd_sc_hd__decap_8
XFILLER_18_76 VGND VGND VPWR VPWR sky130_fd_sc_hd__decap_3
X_10960_ _03436_ _03439_ VGND VGND VPWR VPWR _03612_ sky130_fd_sc_hd__nand2_1
XFILLER_28_365 VPWR VGND VPWR VGND sky130_ef_sc_hd__decap_12
XTAP_TAPCELL_ROW_39_861 VGND VPWR sky130_fd_sc_hd__tapvpwrvgnd_1
X_09619_ _02150_ _02152_ VGND VGND VPWR VPWR _02153_ sky130_fd_sc_hd__and2_1
XFILLER_43_335 VGND VGND VPWR VPWR sky130_fd_sc_hd__fill_1
X_10891_ _03410_ _03413_ _03535_ VGND VGND VPWR VPWR _03536_ sky130_fd_sc_hd__a21oi_1
XFILLER_28_387 VPWR VGND VPWR VGND sky130_ef_sc_hd__decap_12
X_12630_ net572 net423 VGND VGND VPWR VPWR _05431_ sky130_fd_sc_hd__nand2_1
XFILLER_43_379 VGND VGND VPWR VPWR sky130_fd_sc_hd__fill_1
XFILLER_31_519 VPWR VGND VPWR VGND sky130_ef_sc_hd__decap_12
XFILLER_34_53 VPWR VGND VPWR VGND sky130_ef_sc_hd__decap_12
X_12561_ _06694_ _05354_ VGND VGND VPWR VPWR _05356_ sky130_fd_sc_hd__xor2_1
X_12492_ _05118_ _05279_ VGND VGND VPWR VPWR _05280_ sky130_fd_sc_hd__xnor2_1
XFILLER_8_737 VPWR VGND VPWR VGND sky130_ef_sc_hd__decap_12
XFILLER_11_243 VPWR VGND VPWR VGND sky130_ef_sc_hd__decap_12
X_11512_ _04213_ _04214_ VGND VGND VPWR VPWR _04215_ sky130_fd_sc_hd__nand2b_1
XFILLER_109_131 VPWR VGND VPWR VGND sky130_ef_sc_hd__decap_12
XFILLER_50_41 VPWR VGND VPWR VGND sky130_ef_sc_hd__decap_12
XFILLER_7_247 VPWR VGND VPWR VGND sky130_ef_sc_hd__decap_12
XFILLER_7_225 VGND VGND VPWR VPWR sky130_fd_sc_hd__decap_6
X_11443_ _04138_ _04139_ VGND VGND VPWR VPWR _04140_ sky130_fd_sc_hd__xnor2_1
XFILLER_137_462 VGND VGND VPWR VPWR sky130_fd_sc_hd__fill_1
XFILLER_50_85 VPWR VGND VPWR VGND sky130_ef_sc_hd__decap_12
XFILLER_124_134 VGND VGND VPWR VPWR sky130_fd_sc_hd__decap_6
X_13113_ _05953_ _05957_ VGND VGND VPWR VPWR _05958_ sky130_fd_sc_hd__and2b_1
XTAP_TAPCELL_ROW_59_1154 VGND VPWR sky130_fd_sc_hd__tapvpwrvgnd_1
X_11374_ _04028_ _04062_ VGND VGND VPWR VPWR _04064_ sky130_fd_sc_hd__xnor2_1
XFILLER_98_519 VGND VGND VPWR VPWR sky130_fd_sc_hd__fill_2
XFILLER_79_700 VGND VGND VPWR VPWR sky130_fd_sc_hd__decap_3
X_10325_ _02914_ _02916_ VGND VGND VPWR VPWR _02917_ sky130_fd_sc_hd__and2b_1
XFILLER_124_189 VGND VGND VPWR VPWR sky130_fd_sc_hd__decap_6
X_13044_ _05568_ _05730_ _05882_ _05728_ VGND VGND VPWR VPWR _05883_ sky130_fd_sc_hd__o2bb2a_1
XFILLER_78_210 VPWR VGND VPWR VGND sky130_ef_sc_hd__decap_12
XTAP_TAPCELL_ROW_72_1343 VGND VPWR sky130_fd_sc_hd__tapvpwrvgnd_1
X_10256_ _02806_ _02841_ VGND VGND VPWR VPWR _02842_ sky130_fd_sc_hd__and2_1
X_10187_ _02056_ _02723_ _02722_ VGND VGND VPWR VPWR _02770_ sky130_fd_sc_hd__o21a_1
XFILLER_94_725 VPWR VGND VPWR VGND sky130_ef_sc_hd__decap_12
XFILLER_47_685 VGND VGND VPWR VPWR sky130_fd_sc_hd__fill_2
XFILLER_61_132 VPWR VGND VPWR VGND sky130_ef_sc_hd__decap_12
XTAP_TAPCELL_ROW_17_544 VGND VPWR sky130_fd_sc_hd__tapvpwrvgnd_1
XFILLER_22_508 VGND VGND VPWR VPWR sky130_fd_sc_hd__decap_8
X_12828_ _05476_ _05645_ VGND VGND VPWR VPWR _05647_ sky130_fd_sc_hd__xnor2_1
XFILLER_62_699 VGND VGND VPWR VPWR sky130_fd_sc_hd__fill_1
XFILLER_61_165 VGND VGND VPWR VPWR sky130_fd_sc_hd__decap_3
X_12759_ _05398_ _05449_ _05448_ VGND VGND VPWR VPWR _05571_ sky130_fd_sc_hd__a21oi_1
XFILLER_91_81 VGND VGND VPWR VPWR sky130_fd_sc_hd__decap_8
XFILLER_30_530 VGND VGND VPWR VPWR sky130_fd_sc_hd__fill_2
XFILLER_30_541 VGND VGND VPWR VPWR sky130_fd_sc_hd__fill_1
XFILLER_116_613 VPWR VGND VPWR VGND sky130_ef_sc_hd__decap_12
XFILLER_116_657 VPWR VGND VPWR VGND sky130_ef_sc_hd__decap_12
X_09970_ _02363_ _02533_ VGND VGND VPWR VPWR _02535_ sky130_fd_sc_hd__xor2_1
XFILLER_6_291 VGND VGND VPWR VPWR sky130_fd_sc_hd__decap_8
X_08921_ _01389_ _01390_ VGND VGND VPWR VPWR _01391_ sky130_fd_sc_hd__xnor2_1
XFILLER_130_148 VPWR VGND VPWR VGND sky130_ef_sc_hd__decap_12
X_08852_ _01316_ _01317_ VGND VGND VPWR VPWR _01318_ sky130_fd_sc_hd__and2b_1
XFILLER_111_351 VGND VGND VPWR VPWR sky130_fd_sc_hd__decap_4
XFILLER_57_416 VPWR VGND VPWR VGND sky130_ef_sc_hd__decap_12
X_07803_ _00279_ _00280_ VGND VGND VPWR VPWR _00282_ sky130_fd_sc_hd__xnor2_1
X_08783_ net550 net366 VGND VGND VPWR VPWR _01249_ sky130_fd_sc_hd__nand2_1
XFILLER_111_384 VGND VGND VPWR VPWR sky130_fd_sc_hd__fill_1
XFILLER_85_758 VGND VGND VPWR VPWR sky130_fd_sc_hd__decap_6
XFILLER_57_449 VGND VGND VPWR VPWR sky130_fd_sc_hd__fill_2
X_07734_ _00209_ _00212_ VGND VGND VPWR VPWR _00213_ sky130_fd_sc_hd__and2_1
XFILLER_55_19 VPWR VGND VPWR VGND sky130_ef_sc_hd__decap_12
XFILLER_53_600 VGND VGND VPWR VPWR sky130_fd_sc_hd__decap_3
XFILLER_38_674 VPWR VGND VPWR VGND sky130_ef_sc_hd__decap_12
X_07665_ _06574_ _00136_ _00135_ VGND VGND VPWR VPWR _00144_ sky130_fd_sc_hd__o21ba_1
XFILLER_25_313 VPWR VGND VPWR VGND sky130_ef_sc_hd__decap_12
XTAP_TAPCELL_ROW_36_820 VGND VPWR sky130_fd_sc_hd__tapvpwrvgnd_1
XFILLER_38_696 VGND VGND VPWR VPWR sky130_fd_sc_hd__decap_4
X_09404_ _01916_ _01917_ VGND VGND VPWR VPWR _01918_ sky130_fd_sc_hd__xnor2_2
XFILLER_25_335 VGND VGND VPWR VPWR sky130_fd_sc_hd__fill_1
XFILLER_111_69 VPWR VGND VPWR VGND sky130_ef_sc_hd__decap_12
X_07596_ net460 net449 net664 net662 VGND VGND VPWR VPWR _00076_ sky130_fd_sc_hd__nand4_1
X_09335_ _01665_ _01667_ _01841_ _01842_ VGND VGND VPWR VPWR _01843_ sky130_fd_sc_hd__a211oi_1
X_09266_ _01582_ _01765_ VGND VGND VPWR VPWR _01767_ sky130_fd_sc_hd__xnor2_1
XFILLER_21_552 VGND VGND VPWR VPWR sky130_fd_sc_hd__decap_8
XFILLER_138_237 VPWR VGND VPWR VGND sky130_ef_sc_hd__decap_12
X_08217_ net545 _00436_ _00568_ net688 VGND VGND VPWR VPWR _00692_ sky130_fd_sc_hd__o211ai_2
X_09197_ _01547_ _01563_ _01561_ VGND VGND VPWR VPWR _01691_ sky130_fd_sc_hd__o21ai_1
XFILLER_107_613 VGND VGND VPWR VPWR sky130_fd_sc_hd__decap_3
XFILLER_5_729 VPWR VGND VPWR VGND sky130_ef_sc_hd__decap_12
XFILLER_4_206 VGND VGND VPWR VPWR sky130_fd_sc_hd__decap_4
XFILLER_134_421 VGND VGND VPWR VPWR sky130_fd_sc_hd__fill_2
XFILLER_112_6 VPWR VGND VPWR VGND sky130_ef_sc_hd__decap_12
X_08148_ _00393_ _00518_ _00258_ VGND VGND VPWR VPWR _00624_ sky130_fd_sc_hd__o21bai_1
XFILLER_4_217 VGND VGND VPWR VPWR sky130_fd_sc_hd__fill_1
X_08079_ _00554_ _00555_ VGND VGND VPWR VPWR _00042_ sky130_fd_sc_hd__xnor2_1
XFILLER_136_77 VGND VGND VPWR VPWR sky130_fd_sc_hd__decap_6
X_10110_ _02685_ _02686_ VGND VGND VPWR VPWR _02687_ sky130_fd_sc_hd__nand2b_1
XTAP_TAPCELL_ROW_112_1922 VGND VPWR sky130_fd_sc_hd__tapvpwrvgnd_1
XFILLER_106_178 VPWR VGND VPWR VGND sky130_ef_sc_hd__decap_12
XFILLER_96_15 VPWR VGND VPWR VGND sky130_ef_sc_hd__decap_12
X_11090_ _03752_ _03753_ VGND VGND VPWR VPWR _03754_ sky130_fd_sc_hd__nand2_1
X_10041_ _01581_ _02611_ VGND VGND VPWR VPWR _02612_ sky130_fd_sc_hd__and2_1
XFILLER_0_434 VGND VGND VPWR VPWR sky130_fd_sc_hd__decap_3
XFILLER_76_725 VGND VGND VPWR VPWR sky130_fd_sc_hd__decap_6
XTAP_TAPCELL_ROW_54_1084 VGND VPWR sky130_fd_sc_hd__tapvpwrvgnd_1
XFILLER_75_246 VGND VGND VPWR VPWR sky130_fd_sc_hd__decap_8
X_11992_ _04687_ _04733_ VGND VGND VPWR VPWR _04734_ sky130_fd_sc_hd__and2_1
XFILLER_75_279 VGND VGND VPWR VPWR sky130_fd_sc_hd__fill_1
XFILLER_29_97 VPWR VGND VPWR VGND sky130_ef_sc_hd__decap_12
XFILLER_84_791 VPWR VGND VPWR VGND sky130_ef_sc_hd__decap_12
XFILLER_56_493 VGND VGND VPWR VPWR sky130_fd_sc_hd__fill_1
X_10943_ _03433_ _03448_ _03447_ VGND VGND VPWR VPWR _03593_ sky130_fd_sc_hd__a21bo_1
XFILLER_28_173 VGND VGND VPWR VPWR sky130_fd_sc_hd__fill_1
XFILLER_90_249 VGND VGND VPWR VPWR sky130_fd_sc_hd__decap_3
X_13662_ clknet_3_4__leaf_clk _00056_ net717 VGND VGND VPWR VPWR net181 sky130_fd_sc_hd__dfrtp_1
XFILLER_71_474 VGND VGND VPWR VPWR sky130_fd_sc_hd__decap_3
XFILLER_44_699 VGND VGND VPWR VPWR sky130_fd_sc_hd__fill_1
XFILLER_43_165 VGND VGND VPWR VPWR sky130_fd_sc_hd__decap_3
X_10874_ _03414_ _03517_ VGND VGND VPWR VPWR _03518_ sky130_fd_sc_hd__nor2_1
XTAP_TAPCELL_ROW_14_503 VGND VPWR sky130_fd_sc_hd__tapvpwrvgnd_1
X_12613_ net550 net659 VGND VGND VPWR VPWR _05412_ sky130_fd_sc_hd__nand2_1
X_13593_ _06480_ _06481_ VGND VGND VPWR VPWR _06482_ sky130_fd_sc_hd__or2_1
XFILLER_31_327 VGND VGND VPWR VPWR sky130_fd_sc_hd__fill_2
X_12544_ _05313_ _05336_ VGND VGND VPWR VPWR _05337_ sky130_fd_sc_hd__xnor2_1
XFILLER_8_523 VGND VGND VPWR VPWR sky130_fd_sc_hd__fill_1
X_12475_ _05252_ _05260_ VGND VGND VPWR VPWR _05261_ sky130_fd_sc_hd__nand2_1
XFILLER_137_281 VGND VGND VPWR VPWR sky130_fd_sc_hd__decap_6
XFILLER_137_270 VGND VGND VPWR VPWR sky130_fd_sc_hd__decap_8
XANTENNA_6 net66 VGND VGND VPWR VPWR sky130_fd_sc_hd__diode_2
X_11426_ _04119_ _04120_ VGND VGND VPWR VPWR _04121_ sky130_fd_sc_hd__xor2_1
XFILLER_99_817 VGND VGND VPWR VPWR sky130_fd_sc_hd__decap_3
X_11357_ _03890_ _04044_ VGND VGND VPWR VPWR _04045_ sky130_fd_sc_hd__xnor2_1
X_10308_ _02895_ _02897_ VGND VGND VPWR VPWR _02899_ sky130_fd_sc_hd__xnor2_1
X_13027_ _05659_ _05713_ _05711_ VGND VGND VPWR VPWR _05864_ sky130_fd_sc_hd__a21bo_1
X_11288_ net261 net323 _03822_ _03825_ VGND VGND VPWR VPWR _03971_ sky130_fd_sc_hd__o31ai_2
XFILLER_121_671 VGND VGND VPWR VPWR sky130_fd_sc_hd__fill_1
X_10239_ _02799_ _02822_ VGND VGND VPWR VPWR _02825_ sky130_fd_sc_hd__nand2b_1
XFILLER_94_533 VPWR VGND VPWR VGND sky130_ef_sc_hd__decap_12
XFILLER_54_419 VGND VGND VPWR VPWR sky130_fd_sc_hd__fill_1
XFILLER_82_739 VPWR VGND VPWR VGND sky130_ef_sc_hd__decap_12
XFILLER_19_151 VGND VGND VPWR VPWR sky130_fd_sc_hd__fill_1
XFILLER_35_600 VPWR VGND VPWR VGND sky130_ef_sc_hd__decap_12
XTAP_TAPCELL_ROW_85_1534 VGND VPWR sky130_fd_sc_hd__tapvpwrvgnd_1
XFILLER_35_655 VGND VGND VPWR VPWR sky130_fd_sc_hd__decap_4
X_07450_ net102 net631 net707 net638 VGND VGND VPWR VPWR _06680_ sky130_fd_sc_hd__a22o_1
XFILLER_62_474 VGND VGND VPWR VPWR sky130_fd_sc_hd__fill_2
XFILLER_62_463 VGND VGND VPWR VPWR sky130_fd_sc_hd__decap_8
XFILLER_50_625 VGND VGND VPWR VPWR sky130_fd_sc_hd__decap_8
X_07381_ _06602_ _06609_ VGND VGND VPWR VPWR _06611_ sky130_fd_sc_hd__or2_1
X_09120_ _01454_ _01456_ VGND VGND VPWR VPWR _01608_ sky130_fd_sc_hd__and2_1
XFILLER_50_669 VPWR VGND VPWR VGND sky130_ef_sc_hd__decap_12
X_09051_ _01368_ _01532_ VGND VGND VPWR VPWR _01533_ sky130_fd_sc_hd__xnor2_1
XFILLER_30_371 VPWR VGND VPWR VGND sky130_ef_sc_hd__decap_12
XFILLER_129_760 VPWR VGND VPWR VGND sky130_ef_sc_hd__decap_12
X_08002_ net493 net675 VGND VGND VPWR VPWR _00479_ sky130_fd_sc_hd__nand2_1
XPHY_EDGE_ROW_6_Right_6 VGND VGND VPWR VPWR sky130_fd_sc_hd__decap_3
Xmax_cap231 _01075_ VGND VGND VPWR VPWR net231 sky130_fd_sc_hd__buf_1
XTAP_TAPCELL_ROW_96_1696 VGND VPWR sky130_fd_sc_hd__tapvpwrvgnd_1
XTAP_TAPCELL_ROW_96_1685 VGND VPWR sky130_fd_sc_hd__tapvpwrvgnd_1
Xmax_cap242 _00912_ VGND VGND VPWR VPWR net242 sky130_fd_sc_hd__clkbuf_1
Xmax_cap253 _00757_ VGND VGND VPWR VPWR net253 sky130_fd_sc_hd__clkbuf_1
XFILLER_104_638 VGND VGND VPWR VPWR sky130_fd_sc_hd__decap_6
X_09953_ _02512_ _02515_ VGND VGND VPWR VPWR _02516_ sky130_fd_sc_hd__nor2_1
XFILLER_106_25 VGND VGND VPWR VPWR sky130_fd_sc_hd__decap_3
X_08904_ net550 net364 VGND VGND VPWR VPWR _01372_ sky130_fd_sc_hd__nand2_1
X_09884_ _02182_ _02440_ VGND VGND VPWR VPWR _02441_ sky130_fd_sc_hd__nand2_1
XFILLER_112_660 VPWR VGND VPWR VGND sky130_ef_sc_hd__decap_12
XFILLER_100_811 VGND VGND VPWR VPWR sky130_fd_sc_hd__fill_1
XFILLER_97_371 VGND VGND VPWR VPWR sky130_fd_sc_hd__decap_6
X_08835_ net463 net334 net61 net455 VGND VGND VPWR VPWR _01301_ sky130_fd_sc_hd__a22oi_2
XFILLER_97_393 VGND VGND VPWR VPWR sky130_fd_sc_hd__fill_2
XFILLER_66_29 VPWR VGND VPWR VGND sky130_ef_sc_hd__decap_12
XTAP_TAPCELL_ROW_127_2140 VGND VPWR sky130_fd_sc_hd__tapvpwrvgnd_1
X_08766_ _01228_ _01232_ _01224_ _01226_ VGND VGND VPWR VPWR _01233_ sky130_fd_sc_hd__a211o_1
XFILLER_85_599 VGND VGND VPWR VPWR sky130_fd_sc_hd__fill_1
X_07717_ _00194_ _00195_ VGND VGND VPWR VPWR _00196_ sky130_fd_sc_hd__xnor2_1
XFILLER_38_482 VGND VGND VPWR VPWR sky130_fd_sc_hd__fill_1
X_08697_ net624 net377 net376 net633 VGND VGND VPWR VPWR _01164_ sky130_fd_sc_hd__a22oi_1
X_07648_ _00125_ _00126_ _06710_ _06712_ VGND VGND VPWR VPWR _00128_ sky130_fd_sc_hd__a211o_1
XFILLER_53_485 VPWR VGND VPWR VGND sky130_ef_sc_hd__decap_12
XTAP_TAPCELL_ROW_0_286 VGND VPWR sky130_fd_sc_hd__tapvpwrvgnd_1
XTAP_TAPCELL_ROW_0_297 VGND VPWR sky130_fd_sc_hd__tapvpwrvgnd_1
XFILLER_25_165 VGND VGND VPWR VPWR sky130_fd_sc_hd__decap_3
X_07579_ _06798_ _06807_ VGND VGND VPWR VPWR _06808_ sky130_fd_sc_hd__xor2_1
XFILLER_13_327 VGND VGND VPWR VPWR sky130_fd_sc_hd__decap_4
XFILLER_15_55 VGND VGND VPWR VPWR sky130_fd_sc_hd__fill_1
XFILLER_40_135 VGND VGND VPWR VPWR sky130_fd_sc_hd__decap_4
X_09318_ _00108_ _01822_ _01823_ VGND VGND VPWR VPWR _01825_ sky130_fd_sc_hd__nand3_1
X_10590_ _03083_ _03085_ _03099_ _03097_ _02924_ VGND VGND VPWR VPWR _03207_ sky130_fd_sc_hd__a32o_1
X_09249_ _01746_ _01748_ VGND VGND VPWR VPWR _01749_ sky130_fd_sc_hd__and2b_1
XFILLER_119_281 VGND VGND VPWR VPWR sky130_fd_sc_hd__decap_4
XFILLER_110_3 VPWR VGND VPWR VGND sky130_ef_sc_hd__decap_12
X_12260_ net645 net338 net321 net656 VGND VGND VPWR VPWR _05027_ sky130_fd_sc_hd__a22oi_2
XFILLER_135_741 VPWR VGND VPWR VGND sky130_ef_sc_hd__decap_12
X_12191_ net593 net583 net577 net500 VGND VGND VPWR VPWR _04951_ sky130_fd_sc_hd__and4_1
XTAP_TAPCELL_ROW_56_1113 VGND VPWR sky130_fd_sc_hd__tapvpwrvgnd_1
X_11211_ net544 net304 _03884_ VGND VGND VPWR VPWR _03886_ sky130_fd_sc_hd__a21oi_1
XFILLER_135_785 VPWR VGND VPWR VGND sky130_ef_sc_hd__decap_12
X_11142_ _03809_ _03810_ VGND VGND VPWR VPWR _03811_ sky130_fd_sc_hd__xor2_1
XFILLER_122_435 VGND VGND VPWR VPWR sky130_fd_sc_hd__decap_4
X_11073_ _03557_ _03559_ VGND VGND VPWR VPWR _03735_ sky130_fd_sc_hd__nand2_1
XFILLER_0_253 VGND VGND VPWR VPWR sky130_fd_sc_hd__fill_2
Xinput110 w31[4] VGND VGND VPWR VPWR net110 sky130_fd_sc_hd__clkbuf_2
XFILLER_1_765 VPWR VGND VPWR VGND sky130_ef_sc_hd__decap_12
X_10024_ _02591_ _02592_ VGND VGND VPWR VPWR _02593_ sky130_fd_sc_hd__nor2_1
Xinput132 x0[2] VGND VGND VPWR VPWR net132 sky130_fd_sc_hd__clkbuf_2
XFILLER_76_511 VGND VGND VPWR VPWR sky130_fd_sc_hd__decap_4
Xinput121 w32[7] VGND VGND VPWR VPWR net121 sky130_fd_sc_hd__clkbuf_2
Xinput143 x1[5] VGND VGND VPWR VPWR net143 sky130_fd_sc_hd__clkbuf_1
Xinput154 x3[0] VGND VGND VPWR VPWR net154 sky130_fd_sc_hd__buf_1
XFILLER_102_192 VGND VGND VPWR VPWR sky130_fd_sc_hd__decap_4
XFILLER_49_769 VPWR VGND VPWR VGND sky130_ef_sc_hd__decap_12
XFILLER_63_216 VGND VGND VPWR VPWR sky130_fd_sc_hd__fill_1
XFILLER_29_471 VPWR VGND VPWR VGND sky130_ef_sc_hd__decap_12
X_11975_ _04676_ _04713_ VGND VGND VPWR VPWR _04715_ sky130_fd_sc_hd__xor2_1
XTAP_TAPCELL_ROW_67_1275 VGND VPWR sky130_fd_sc_hd__tapvpwrvgnd_1
XTAP_TAPCELL_ROW_67_1264 VGND VPWR sky130_fd_sc_hd__tapvpwrvgnd_1
X_10926_ _03571_ _03572_ VGND VGND VPWR VPWR _03574_ sky130_fd_sc_hd__xor2_1
X_13645_ clknet_3_4__leaf_clk _00028_ net718 VGND VGND VPWR VPWR net164 sky130_fd_sc_hd__dfrtp_1
XFILLER_44_496 VGND VGND VPWR VPWR sky130_fd_sc_hd__fill_1
XTAP_TAPCELL_ROW_27_694 VGND VPWR sky130_fd_sc_hd__tapvpwrvgnd_1
XFILLER_31_113 VGND VGND VPWR VPWR sky130_fd_sc_hd__fill_2
X_10857_ _03497_ _03498_ VGND VGND VPWR VPWR _03499_ sky130_fd_sc_hd__and2b_1
XTAP_TAPCELL_ROW_80_1453 VGND VPWR sky130_fd_sc_hd__tapvpwrvgnd_1
X_13576_ _06442_ _06462_ VGND VGND VPWR VPWR _06463_ sky130_fd_sc_hd__xnor2_1
XTAP_TAPCELL_ROW_80_1464 VGND VPWR sky130_fd_sc_hd__tapvpwrvgnd_1
XPHY_EDGE_ROW_59_Right_59 VGND VGND VPWR VPWR sky130_fd_sc_hd__decap_3
XFILLER_9_821 VGND VGND VPWR VPWR sky130_fd_sc_hd__decap_3
X_10788_ net416 net281 _03422_ VGND VGND VPWR VPWR _03424_ sky130_fd_sc_hd__and3_1
X_12527_ _05316_ _05317_ VGND VGND VPWR VPWR _05318_ sky130_fd_sc_hd__nand2_1
XFILLER_8_331 VGND VGND VPWR VPWR sky130_fd_sc_hd__decap_4
X_12458_ _05091_ _05241_ VGND VGND VPWR VPWR _05243_ sky130_fd_sc_hd__xnor2_1
X_11409_ _03960_ _03965_ _03964_ VGND VGND VPWR VPWR _04103_ sky130_fd_sc_hd__o21ai_1
XFILLER_98_113 VGND VGND VPWR VPWR sky130_fd_sc_hd__fill_1
X_12389_ net607 net404 net381 net472 VGND VGND VPWR VPWR _05168_ sky130_fd_sc_hd__a22oi_1
XFILLER_125_284 VPWR VGND VPWR VGND sky130_ef_sc_hd__decap_12
XFILLER_113_457 VGND VGND VPWR VPWR sky130_fd_sc_hd__decap_8
XFILLER_98_135 VGND VGND VPWR VPWR sky130_fd_sc_hd__decap_4
XFILLER_87_809 VPWR VGND VPWR VGND sky130_ef_sc_hd__decap_12
XFILLER_101_608 VGND VGND VPWR VPWR sky130_fd_sc_hd__fill_1
X_06950_ _02608_ _02674_ VGND VGND VPWR VPWR _02793_ sky130_fd_sc_hd__xnor2_1
XFILLER_79_393 VPWR VGND VPWR VGND sky130_ef_sc_hd__decap_12
XPHY_EDGE_ROW_68_Right_68 VGND VGND VPWR VPWR sky130_fd_sc_hd__decap_3
X_06881_ _01627_ _02030_ VGND VGND VPWR VPWR _02041_ sky130_fd_sc_hd__xnor2_1
XFILLER_39_202 VGND VGND VPWR VPWR sky130_fd_sc_hd__decap_4
X_08620_ _01084_ _01086_ VGND VGND VPWR VPWR _01087_ sky130_fd_sc_hd__xnor2_1
XFILLER_94_330 VGND VGND VPWR VPWR sky130_fd_sc_hd__decap_4
XFILLER_67_577 VGND VGND VPWR VPWR sky130_fd_sc_hd__fill_1
XFILLER_39_279 VGND VGND VPWR VPWR sky130_fd_sc_hd__fill_1
X_08551_ _01016_ _01018_ _01015_ VGND VGND VPWR VPWR _01020_ sky130_fd_sc_hd__a21oi_1
XFILLER_82_569 VPWR VGND VPWR VGND sky130_ef_sc_hd__decap_12
XFILLER_50_400 VGND VGND VPWR VPWR sky130_fd_sc_hd__fill_1
XTAP_TAPCELL_ROW_46_970 VGND VPWR sky130_fd_sc_hd__tapvpwrvgnd_1
X_07502_ _06619_ _06621_ _06730_ VGND VGND VPWR VPWR _06731_ sky130_fd_sc_hd__a21oi_1
XFILLER_35_474 VPWR VGND VPWR VGND sky130_ef_sc_hd__decap_12
X_08482_ _00950_ _00954_ VGND VGND VPWR VPWR _00955_ sky130_fd_sc_hd__xnor2_1
XTAP_TAPCELL_ROW_122_2070 VGND VPWR sky130_fd_sc_hd__tapvpwrvgnd_1
X_07433_ _06378_ _06662_ VGND VGND VPWR VPWR _06663_ sky130_fd_sc_hd__xnor2_1
XPHY_EDGE_ROW_77_Right_77 VGND VGND VPWR VPWR sky130_fd_sc_hd__decap_3
XFILLER_11_809 VPWR VGND VPWR VGND sky130_ef_sc_hd__decap_12
XFILLER_23_658 VGND VGND VPWR VPWR sky130_fd_sc_hd__fill_1
X_09103_ net421 net341 _01443_ _01441_ VGND VGND VPWR VPWR _01589_ sky130_fd_sc_hd__a31o_1
XTAP_TAPCELL_ROW_98_1714 VGND VPWR sky130_fd_sc_hd__tapvpwrvgnd_1
XFILLER_50_488 VGND VGND VPWR VPWR sky130_fd_sc_hd__decap_3
XFILLER_50_477 VGND VGND VPWR VPWR sky130_fd_sc_hd__decap_4
X_07364_ _06593_ _06592_ VGND VGND VPWR VPWR _06594_ sky130_fd_sc_hd__nand2b_1
XTAP_TAPCELL_ROW_98_1725 VGND VPWR sky130_fd_sc_hd__tapvpwrvgnd_1
X_07295_ net466 net269 net604 net664 VGND VGND VPWR VPWR _06526_ sky130_fd_sc_hd__and4_1
X_09034_ _01239_ _01244_ _01361_ _01362_ _01514_ VGND VGND VPWR VPWR _01515_ sky130_fd_sc_hd__a41o_1
XFILLER_89_113 VPWR VGND VPWR VGND sky130_ef_sc_hd__decap_12
XFILLER_132_755 VGND VGND VPWR VPWR sky130_fd_sc_hd__fill_1
XFILLER_117_57 VPWR VGND VPWR VGND sky130_ef_sc_hd__decap_12
XFILLER_89_146 VGND VGND VPWR VPWR sky130_fd_sc_hd__fill_1
XFILLER_78_809 VGND VGND VPWR VPWR sky130_fd_sc_hd__decap_3
X_09936_ net606 net367 VGND VGND VPWR VPWR _02497_ sky130_fd_sc_hd__nand2_1
XPHY_EDGE_ROW_86_Right_86 VGND VGND VPWR VPWR sky130_fd_sc_hd__decap_3
XFILLER_131_287 VGND VGND VPWR VPWR sky130_fd_sc_hd__fill_1
XFILLER_58_533 VGND VGND VPWR VPWR sky130_fd_sc_hd__decap_4
XTAP_TAPCELL_ROW_51_1043 VGND VPWR sky130_fd_sc_hd__tapvpwrvgnd_1
XTAP_TAPCELL_ROW_51_1032 VGND VPWR sky130_fd_sc_hd__tapvpwrvgnd_1
X_09867_ _02410_ _02422_ VGND VGND VPWR VPWR _02423_ sky130_fd_sc_hd__xor2_1
XFILLER_58_566 VGND VGND VPWR VPWR sky130_fd_sc_hd__fill_1
XTAP_TAPCELL_ROW_5_378 VGND VPWR sky130_fd_sc_hd__tapvpwrvgnd_1
XTAP_TAPCELL_ROW_5_367 VGND VPWR sky130_fd_sc_hd__tapvpwrvgnd_1
XFILLER_18_408 VGND VGND VPWR VPWR sky130_fd_sc_hd__decap_4
X_09798_ _02342_ _02346_ VGND VGND VPWR VPWR _02348_ sky130_fd_sc_hd__and2_1
X_08818_ net524 net346 VGND VGND VPWR VPWR _01284_ sky130_fd_sc_hd__and2_1
XFILLER_93_27 VPWR VGND VPWR VGND sky130_ef_sc_hd__decap_12
XFILLER_85_374 VGND VGND VPWR VPWR sky130_fd_sc_hd__decap_3
XFILLER_73_503 VGND VGND VPWR VPWR sky130_fd_sc_hd__fill_1
X_08749_ _01205_ _01208_ _01207_ VGND VGND VPWR VPWR _01216_ sky130_fd_sc_hd__a21o_1
XTAP_TAPCELL_ROW_107_1854 VGND VPWR sky130_fd_sc_hd__tapvpwrvgnd_1
X_11760_ _04467_ _04483_ VGND VGND VPWR VPWR _04485_ sky130_fd_sc_hd__xnor2_1
XPHY_EDGE_ROW_95_Right_95 VGND VGND VPWR VPWR sky130_fd_sc_hd__decap_3
XFILLER_53_293 VGND VGND VPWR VPWR sky130_fd_sc_hd__decap_8
XFILLER_13_113 VPWR VGND VPWR VGND sky130_ef_sc_hd__decap_12
X_10711_ _03280_ _03338_ _03339_ VGND VGND VPWR VPWR _03340_ sky130_fd_sc_hd__nand3_1
XFILLER_26_76 VGND VGND VPWR VPWR sky130_fd_sc_hd__decap_8
XFILLER_26_98 VPWR VGND VPWR VGND sky130_ef_sc_hd__decap_12
XFILLER_26_485 VGND VGND VPWR VPWR sky130_fd_sc_hd__fill_2
XFILLER_14_658 VPWR VGND VPWR VGND sky130_ef_sc_hd__decap_12
X_11691_ _04379_ _04409_ VGND VGND VPWR VPWR _04410_ sky130_fd_sc_hd__xnor2_1
XTAP_TAPCELL_ROW_24_642 VGND VPWR sky130_fd_sc_hd__tapvpwrvgnd_1
XTAP_TAPCELL_ROW_24_653 VGND VPWR sky130_fd_sc_hd__tapvpwrvgnd_1
X_13430_ _05315_ _06223_ _06222_ VGND VGND VPWR VPWR _06304_ sky130_fd_sc_hd__a21oi_1
XFILLER_42_53 VPWR VGND VPWR VGND sky130_ef_sc_hd__decap_12
X_10642_ _03262_ _03263_ VGND VGND VPWR VPWR _03264_ sky130_fd_sc_hd__nand2b_1
XFILLER_127_505 VPWR VGND VPWR VGND sky130_ef_sc_hd__decap_12
X_13361_ _06219_ _06227_ VGND VGND VPWR VPWR _06229_ sky130_fd_sc_hd__xnor2_1
XTAP_TAPCELL_ROW_62_1194 VGND VPWR sky130_fd_sc_hd__tapvpwrvgnd_1
X_10573_ _03035_ _03037_ _03187_ _03188_ VGND VGND VPWR VPWR _03189_ sky130_fd_sc_hd__o211a_1
XFILLER_127_549 VGND VGND VPWR VPWR sky130_fd_sc_hd__fill_1
X_12312_ net541 net711 _05082_ VGND VGND VPWR VPWR _05083_ sky130_fd_sc_hd__a21o_1
X_13292_ _06151_ _06152_ VGND VGND VPWR VPWR _06154_ sky130_fd_sc_hd__xor2_2
XFILLER_42_97 VPWR VGND VPWR VGND sky130_ef_sc_hd__decap_12
XFILLER_6_813 VGND VGND VPWR VPWR sky130_fd_sc_hd__decap_8
XFILLER_5_301 VGND VGND VPWR VPWR sky130_fd_sc_hd__decap_4
XFILLER_108_741 VPWR VGND VPWR VGND sky130_ef_sc_hd__decap_12
X_12243_ _05005_ _05006_ _05007_ VGND VGND VPWR VPWR _05008_ sky130_fd_sc_hd__and3_1
XFILLER_107_262 VGND VGND VPWR VPWR sky130_fd_sc_hd__decap_6
XPHY_EDGE_ROW_2_Left_141 VGND VGND VPWR VPWR sky130_fd_sc_hd__decap_3
XPHY_EDGE_ROW_39_Left_178 VGND VGND VPWR VPWR sky130_fd_sc_hd__decap_3
XFILLER_122_210 VGND VGND VPWR VPWR sky130_fd_sc_hd__decap_3
X_12174_ _04734_ _04746_ _04924_ _04929_ VGND VGND VPWR VPWR _04933_ sky130_fd_sc_hd__o211ai_4
XFILLER_96_617 VPWR VGND VPWR VGND sky130_ef_sc_hd__decap_12
X_11125_ _03612_ _03621_ _03619_ VGND VGND VPWR VPWR _03792_ sky130_fd_sc_hd__a21oi_1
X_11056_ _03713_ _03714_ VGND VGND VPWR VPWR _03716_ sky130_fd_sc_hd__xor2_1
XFILLER_3_69 VPWR VGND VPWR VGND sky130_ef_sc_hd__decap_12
X_10007_ _02573_ _02574_ VGND VGND VPWR VPWR _00058_ sky130_fd_sc_hd__xnor2_1
XFILLER_91_311 VGND VGND VPWR VPWR sky130_fd_sc_hd__fill_2
XTAP_TAPCELL_ROW_69_1304 VGND VPWR sky130_fd_sc_hd__tapvpwrvgnd_1
XFILLER_91_344 VGND VGND VPWR VPWR sky130_fd_sc_hd__decap_4
XFILLER_91_322 VGND VGND VPWR VPWR sky130_fd_sc_hd__fill_1
XFILLER_64_569 VGND VGND VPWR VPWR sky130_fd_sc_hd__decap_8
XFILLER_52_709 VGND VGND VPWR VPWR sky130_fd_sc_hd__decap_8
XFILLER_51_208 VGND VGND VPWR VPWR sky130_fd_sc_hd__decap_8
XPHY_EDGE_ROW_48_Left_187 VGND VGND VPWR VPWR sky130_fd_sc_hd__decap_3
XFILLER_45_761 VGND VGND VPWR VPWR sky130_fd_sc_hd__decap_3
X_11958_ _04694_ _04695_ _04692_ VGND VGND VPWR VPWR _04698_ sky130_fd_sc_hd__o21ai_1
X_10909_ net579 net302 _03381_ _03380_ VGND VGND VPWR VPWR _03556_ sky130_fd_sc_hd__a31o_1
X_11889_ _04577_ _04624_ VGND VGND VPWR VPWR _04625_ sky130_fd_sc_hd__xnor2_1
XFILLER_32_466 VGND VGND VPWR VPWR sky130_fd_sc_hd__decap_3
X_13628_ _06468_ _06473_ _06470_ VGND VGND VPWR VPWR _06520_ sky130_fd_sc_hd__a21o_1
XFILLER_32_499 VGND VGND VPWR VPWR sky130_fd_sc_hd__decap_6
X_13559_ _06042_ _06361_ _06180_ VGND VGND VPWR VPWR _06445_ sky130_fd_sc_hd__or3b_1
XFILLER_73_3 VPWR VGND VPWR VGND sky130_ef_sc_hd__decap_12
X_07080_ _04156_ _04188_ _02380_ VGND VGND VPWR VPWR _04210_ sky130_fd_sc_hd__a21oi_1
XPHY_EDGE_ROW_57_Left_196 VGND VGND VPWR VPWR sky130_fd_sc_hd__decap_3
XTAP_TAPCELL_ROW_93_1644 VGND VPWR sky130_fd_sc_hd__tapvpwrvgnd_1
XFILLER_126_582 VGND VGND VPWR VPWR sky130_fd_sc_hd__decap_6
X_07982_ _00452_ _00457_ VGND VGND VPWR VPWR _00459_ sky130_fd_sc_hd__xnor2_1
X_09721_ net429 net330 net329 net438 VGND VGND VPWR VPWR _02264_ sky130_fd_sc_hd__a22oi_1
XFILLER_99_499 VGND VGND VPWR VPWR sky130_fd_sc_hd__decap_4
X_06933_ _02260_ _02282_ VGND VGND VPWR VPWR _02608_ sky130_fd_sc_hd__nor2_1
XFILLER_101_449 VGND VGND VPWR VPWR sky130_fd_sc_hd__decap_4
XFILLER_83_801 VGND VGND VPWR VPWR sky130_fd_sc_hd__decap_3
XFILLER_79_190 VPWR VGND VPWR VGND sky130_ef_sc_hd__decap_12
XFILLER_67_341 VGND VGND VPWR VPWR sky130_fd_sc_hd__fill_1
X_09652_ _02034_ net354 _00436_ VGND VGND VPWR VPWR _02188_ sky130_fd_sc_hd__and3b_1
XFILLER_103_15 VPWR VGND VPWR VGND sky130_ef_sc_hd__decap_12
XTAP_TAPCELL_ROW_2_326 VGND VPWR sky130_fd_sc_hd__tapvpwrvgnd_1
X_06864_ _01835_ _01846_ VGND VGND VPWR VPWR _01857_ sky130_fd_sc_hd__or2_1
X_08603_ _01060_ _01069_ VGND VGND VPWR VPWR _01071_ sky130_fd_sc_hd__xnor2_1
X_09583_ net418 net333 _02111_ _02112_ VGND VGND VPWR VPWR _02113_ sky130_fd_sc_hd__o2bb2a_1
X_08534_ _01001_ _01002_ net596 net366 VGND VGND VPWR VPWR _01004_ sky130_fd_sc_hd__a2bb2o_1
XFILLER_36_750 VGND VGND VPWR VPWR sky130_fd_sc_hd__decap_6
XFILLER_82_388 VPWR VGND VPWR VGND sky130_ef_sc_hd__decap_12
X_08465_ _00936_ _00937_ VGND VGND VPWR VPWR _00938_ sky130_fd_sc_hd__and2b_1
XFILLER_23_433 VGND VGND VPWR VPWR sky130_fd_sc_hd__decap_8
XFILLER_35_293 VPWR VGND VPWR VGND sky130_ef_sc_hd__decap_12
XTAP_TAPCELL_ROW_102_1773 VGND VPWR sky130_fd_sc_hd__tapvpwrvgnd_1
X_07416_ _06643_ _06644_ _06640_ VGND VGND VPWR VPWR _06646_ sky130_fd_sc_hd__a21o_1
XFILLER_51_797 VGND VGND VPWR VPWR sky130_fd_sc_hd__decap_4
X_08396_ _00860_ _00868_ VGND VGND VPWR VPWR _00870_ sky130_fd_sc_hd__xnor2_1
XFILLER_11_617 VGND VGND VPWR VPWR sky130_fd_sc_hd__fill_2
XTAP_TAPCELL_ROW_21_601 VGND VPWR sky130_fd_sc_hd__tapvpwrvgnd_1
XTAP_TAPCELL_ROW_102_1784 VGND VPWR sky130_fd_sc_hd__tapvpwrvgnd_1
X_07347_ _04969_ _06247_ _06269_ VGND VGND VPWR VPWR _06577_ sky130_fd_sc_hd__a21oi_1
XTAP_TAPCELL_ROW_135_2250 VGND VPWR sky130_fd_sc_hd__tapvpwrvgnd_1
XFILLER_109_538 VGND VGND VPWR VPWR sky130_fd_sc_hd__fill_2
XFILLER_136_335 VGND VGND VPWR VPWR sky130_fd_sc_hd__fill_1
XTAP_TAPCELL_ROW_135_2261 VGND VPWR sky130_fd_sc_hd__tapvpwrvgnd_1
X_09017_ _01493_ _01494_ _01337_ _01339_ VGND VGND VPWR VPWR _01496_ sky130_fd_sc_hd__a211o_1
X_07278_ net125 net444 VGND VGND VPWR VPWR _06367_ sky130_fd_sc_hd__nand2_1
XFILLER_88_27 VGND VGND VPWR VPWR sky130_fd_sc_hd__fill_1
XFILLER_132_530 VGND VGND VPWR VPWR sky130_fd_sc_hd__fill_2
XFILLER_105_777 VGND VGND VPWR VPWR sky130_fd_sc_hd__decap_6
Xfanout641 net132 VGND VGND VPWR VPWR net641 sky130_fd_sc_hd__clkbuf_4
Xfanout630 net635 VGND VGND VPWR VPWR net630 sky130_fd_sc_hd__clkbuf_2
X_09919_ _02057_ _02478_ VGND VGND VPWR VPWR _02479_ sky130_fd_sc_hd__xnor2_1
Xfanout652 net653 VGND VGND VPWR VPWR net652 sky130_fd_sc_hd__buf_4
Xfanout674 net122 VGND VGND VPWR VPWR net674 sky130_fd_sc_hd__buf_2
Xfanout663 net664 VGND VGND VPWR VPWR net663 sky130_fd_sc_hd__buf_2
Xfanout685 net117 VGND VGND VPWR VPWR net685 sky130_fd_sc_hd__clkbuf_2
X_12930_ _05588_ _05757_ VGND VGND VPWR VPWR _05758_ sky130_fd_sc_hd__xnor2_1
Xfanout696 net11 VGND VGND VPWR VPWR net696 sky130_fd_sc_hd__buf_1
XFILLER_73_300 VGND VGND VPWR VPWR sky130_fd_sc_hd__decap_3
XFILLER_58_363 VGND VGND VPWR VPWR sky130_fd_sc_hd__fill_1
X_12861_ _05681_ _05682_ VGND VGND VPWR VPWR _05683_ sky130_fd_sc_hd__xnor2_1
XFILLER_18_227 VGND VGND VPWR VPWR sky130_fd_sc_hd__fill_2
XTAP_TAPCELL_ROW_29_723 VGND VPWR sky130_fd_sc_hd__tapvpwrvgnd_1
XFILLER_61_517 VGND VGND VPWR VPWR sky130_fd_sc_hd__fill_1
X_11812_ _04296_ _04303_ _04425_ _04426_ VGND VGND VPWR VPWR _04542_ sky130_fd_sc_hd__o31a_1
X_12792_ _05598_ _05606_ VGND VGND VPWR VPWR _05607_ sky130_fd_sc_hd__nor2_1
XTAP_TAPCELL_ROW_64_1223 VGND VPWR sky130_fd_sc_hd__tapvpwrvgnd_1
XFILLER_61_528 VGND VGND VPWR VPWR sky130_fd_sc_hd__decap_4
XFILLER_26_260 VGND VGND VPWR VPWR sky130_fd_sc_hd__decap_6
XFILLER_27_783 VGND VGND VPWR VPWR sky130_fd_sc_hd__fill_1
XTAP_TAPCELL_ROW_64_1234 VGND VPWR sky130_fd_sc_hd__tapvpwrvgnd_1
X_11743_ net257 net286 _04382_ _04383_ VGND VGND VPWR VPWR _04466_ sky130_fd_sc_hd__o22a_2
XFILLER_41_274 VGND VGND VPWR VPWR sky130_fd_sc_hd__decap_6
XFILLER_14_466 VGND VGND VPWR VPWR sky130_fd_sc_hd__decap_8
XFILLER_14_477 VGND VGND VPWR VPWR sky130_fd_sc_hd__decap_6
X_11674_ _04265_ _04267_ _04263_ VGND VGND VPWR VPWR _04391_ sky130_fd_sc_hd__o21ba_1
X_13413_ _06284_ _06285_ VGND VGND VPWR VPWR _06286_ sky130_fd_sc_hd__nor2_1
X_10625_ _03208_ _03244_ VGND VGND VPWR VPWR _03245_ sky130_fd_sc_hd__xnor2_1
X_13344_ _06099_ _06101_ _06208_ VGND VGND VPWR VPWR _06210_ sky130_fd_sc_hd__or3b_1
XFILLER_10_683 VPWR VGND VPWR VGND sky130_ef_sc_hd__decap_12
X_10556_ _03167_ _03168_ _03159_ VGND VGND VPWR VPWR _03170_ sky130_fd_sc_hd__a21o_1
X_13275_ _06128_ _06134_ VGND VGND VPWR VPWR _06135_ sky130_fd_sc_hd__xnor2_1
X_10487_ _03091_ _03093_ VGND VGND VPWR VPWR _03094_ sky130_fd_sc_hd__nand2_1
XFILLER_5_153 VGND VGND VPWR VPWR sky130_fd_sc_hd__fill_1
X_12226_ _04817_ _04988_ VGND VGND VPWR VPWR _04989_ sky130_fd_sc_hd__or2_1
XFILLER_6_698 VGND VGND VPWR VPWR sky130_fd_sc_hd__fill_2
X_12157_ _04903_ _04905_ _04908_ _04912_ VGND VGND VPWR VPWR _04914_ sky130_fd_sc_hd__a211o_1
XTAP_TAPCELL_ROW_75_1385 VGND VPWR sky130_fd_sc_hd__tapvpwrvgnd_1
XFILLER_69_617 VPWR VGND VPWR VGND sky130_ef_sc_hd__decap_12
XFILLER_78_82 VGND VGND VPWR VPWR sky130_fd_sc_hd__fill_2
X_11108_ net502 net289 net287 net510 VGND VGND VPWR VPWR _03774_ sky130_fd_sc_hd__a22o_1
XFILLER_84_609 VGND VGND VPWR VPWR sky130_fd_sc_hd__decap_3
X_12088_ _04832_ _04837_ VGND VGND VPWR VPWR _04839_ sky130_fd_sc_hd__nand2_1
XFILLER_68_149 VGND VGND VPWR VPWR sky130_fd_sc_hd__fill_1
XFILLER_110_268 VPWR VGND VPWR VGND sky130_ef_sc_hd__decap_12
X_11039_ _03538_ _03696_ _03698_ VGND VGND VPWR VPWR _03699_ sky130_fd_sc_hd__nand3_1
XFILLER_64_322 VGND VGND VPWR VPWR sky130_fd_sc_hd__fill_2
XFILLER_80_804 VGND VGND VPWR VPWR sky130_fd_sc_hd__decap_8
XFILLER_64_377 VGND VGND VPWR VPWR sky130_fd_sc_hd__decap_8
XFILLER_91_196 VGND VGND VPWR VPWR sky130_fd_sc_hd__fill_2
X_08250_ _06658_ _00632_ _00631_ VGND VGND VPWR VPWR _00725_ sky130_fd_sc_hd__a21o_1
XFILLER_33_797 VPWR VGND VPWR VGND sky130_ef_sc_hd__decap_12
X_08181_ _00533_ _00534_ _00536_ VGND VGND VPWR VPWR _00657_ sky130_fd_sc_hd__o21a_1
X_07201_ _04177_ _04232_ _05505_ _05516_ VGND VGND VPWR VPWR _05527_ sky130_fd_sc_hd__and4_1
XPHY_EDGE_ROW_65_Left_204 VGND VGND VPWR VPWR sky130_fd_sc_hd__decap_3
X_07132_ _04675_ _04751_ VGND VGND VPWR VPWR _04772_ sky130_fd_sc_hd__xnor2_1
XFILLER_133_305 VPWR VGND VPWR VGND sky130_ef_sc_hd__decap_12
X_07063_ _03992_ _04003_ _02909_ VGND VGND VPWR VPWR _04024_ sky130_fd_sc_hd__a21bo_1
Xoutput200 net200 VGND VGND VPWR VPWR y2[13] sky130_fd_sc_hd__buf_2
XFILLER_114_530 VGND VGND VPWR VPWR sky130_fd_sc_hd__fill_2
Xoutput222 net222 VGND VGND VPWR VPWR y3[2] sky130_fd_sc_hd__buf_2
Xoutput211 net211 VGND VGND VPWR VPWR y2[8] sky130_fd_sc_hd__buf_2
XTAP_TAPCELL_ROW_130_2180 VGND VPWR sky130_fd_sc_hd__tapvpwrvgnd_1
XTAP_TAPCELL_ROW_7_407 VGND VPWR sky130_fd_sc_hd__tapvpwrvgnd_1
XTAP_TAPCELL_ROW_130_2191 VGND VPWR sky130_fd_sc_hd__tapvpwrvgnd_1
XFILLER_102_769 VPWR VGND VPWR VGND sky130_ef_sc_hd__decap_12
XFILLER_59_138 VGND VGND VPWR VPWR sky130_fd_sc_hd__fill_1
X_07965_ _00439_ _00440_ VGND VGND VPWR VPWR _00442_ sky130_fd_sc_hd__xnor2_1
X_09704_ _01768_ _02244_ VGND VGND VPWR VPWR _02245_ sky130_fd_sc_hd__xnor2_1
XPHY_EDGE_ROW_74_Left_213 VGND VGND VPWR VPWR sky130_fd_sc_hd__decap_3
X_06916_ _02402_ _02413_ VGND VGND VPWR VPWR _00008_ sky130_fd_sc_hd__and2_1
X_09635_ _02168_ _02169_ VGND VGND VPWR VPWR _02170_ sky130_fd_sc_hd__nor2_1
XFILLER_74_29 VPWR VGND VPWR VGND sky130_ef_sc_hd__decap_12
XFILLER_74_18 VGND VGND VPWR VPWR sky130_fd_sc_hd__decap_8
X_07896_ _00075_ _00232_ _00373_ VGND VGND VPWR VPWR _00374_ sky130_fd_sc_hd__or3_1
XFILLER_55_311 VGND VGND VPWR VPWR sky130_fd_sc_hd__decap_8
XFILLER_82_152 VGND VGND VPWR VPWR sky130_fd_sc_hd__decap_4
X_06847_ _01497_ _01649_ VGND VGND VPWR VPWR _01671_ sky130_fd_sc_hd__xor2_1
X_09566_ net255 _02092_ VGND VGND VPWR VPWR _02094_ sky130_fd_sc_hd__xnor2_1
XTAP_TAPCELL_ROW_104_1813 VGND VPWR sky130_fd_sc_hd__tapvpwrvgnd_1
XTAP_TAPCELL_ROW_104_1802 VGND VPWR sky130_fd_sc_hd__tapvpwrvgnd_1
XFILLER_83_697 VGND VGND VPWR VPWR sky130_fd_sc_hd__fill_2
XFILLER_15_219 VGND VGND VPWR VPWR sky130_fd_sc_hd__decap_4
X_09497_ _02016_ _02017_ VGND VGND VPWR VPWR _02019_ sky130_fd_sc_hd__xnor2_1
X_08517_ _00971_ _00988_ VGND VGND VPWR VPWR _00989_ sky130_fd_sc_hd__xnor2_1
XFILLER_51_561 VPWR VGND VPWR VGND sky130_ef_sc_hd__decap_12
X_08448_ _00819_ _00846_ VGND VGND VPWR VPWR _00921_ sky130_fd_sc_hd__nor2_1
XPHY_EDGE_ROW_83_Left_222 VGND VGND VPWR VPWR sky130_fd_sc_hd__decap_3
XFILLER_51_594 VGND VGND VPWR VPWR sky130_fd_sc_hd__decap_4
XFILLER_23_55 VGND VGND VPWR VPWR sky130_fd_sc_hd__fill_1
XTAP_TAPCELL_ROW_34_792 VGND VPWR sky130_fd_sc_hd__tapvpwrvgnd_1
X_10410_ _03000_ _03001_ _03009_ VGND VGND VPWR VPWR _03011_ sky130_fd_sc_hd__nand3_1
X_08379_ net534 net536 net688 VGND VGND VPWR VPWR _00853_ sky130_fd_sc_hd__mux2_1
XFILLER_136_121 VPWR VGND VPWR VGND sky130_ef_sc_hd__decap_12
X_11390_ _04078_ _04081_ VGND VGND VPWR VPWR _04082_ sky130_fd_sc_hd__nor2_1
XFILLER_136_165 VGND VGND VPWR VPWR sky130_fd_sc_hd__decap_6
XFILLER_125_817 VGND VGND VPWR VPWR sky130_fd_sc_hd__decap_3
XFILLER_124_316 VGND VGND VPWR VPWR sky130_fd_sc_hd__fill_1
XFILLER_3_602 VGND VGND VPWR VPWR sky130_fd_sc_hd__decap_4
X_10341_ _02934_ VGND VGND VPWR VPWR _02935_ sky130_fd_sc_hd__inv_2
XTAP_TAPCELL_ROW_115_1964 VGND VPWR sky130_fd_sc_hd__tapvpwrvgnd_1
X_13060_ _05898_ _05899_ VGND VGND VPWR VPWR _05900_ sky130_fd_sc_hd__nand2_1
X_10272_ net520 net297 _02798_ VGND VGND VPWR VPWR _02860_ sky130_fd_sc_hd__and3_1
X_12011_ net507 net18 net406 net516 VGND VGND VPWR VPWR _04754_ sky130_fd_sc_hd__a22oi_1
XFILLER_3_668 VGND VGND VPWR VPWR sky130_fd_sc_hd__fill_1
XFILLER_3_3 VPWR VGND VPWR VGND sky130_ef_sc_hd__decap_12
XPHY_EDGE_ROW_92_Left_231 VGND VGND VPWR VPWR sky130_fd_sc_hd__decap_3
XFILLER_120_555 VPWR VGND VPWR VGND sky130_ef_sc_hd__decap_12
XFILLER_66_609 VGND VGND VPWR VPWR sky130_fd_sc_hd__fill_1
XFILLER_48_41 VPWR VGND VPWR VGND sky130_ef_sc_hd__decap_12
Xfanout471 net473 VGND VGND VPWR VPWR net471 sky130_fd_sc_hd__clkbuf_4
Xfanout493 net499 VGND VGND VPWR VPWR net493 sky130_fd_sc_hd__clkbuf_4
XFILLER_48_85 VPWR VGND VPWR VGND sky130_ef_sc_hd__decap_12
Xfanout482 net152 VGND VGND VPWR VPWR net482 sky130_fd_sc_hd__buf_4
XFILLER_19_503 VGND VGND VPWR VPWR sky130_fd_sc_hd__fill_1
XFILLER_19_514 VGND VGND VPWR VPWR sky130_fd_sc_hd__fill_2
Xfanout460 net465 VGND VGND VPWR VPWR net460 sky130_fd_sc_hd__buf_4
XFILLER_86_491 VGND VGND VPWR VPWR sky130_fd_sc_hd__decap_8
X_12913_ _05620_ _05658_ _05656_ VGND VGND VPWR VPWR _05739_ sky130_fd_sc_hd__a21oi_1
XFILLER_0_15 VPWR VGND VPWR VGND sky130_ef_sc_hd__decap_12
X_12844_ _05662_ _05663_ VGND VGND VPWR VPWR _05664_ sky130_fd_sc_hd__nand2b_1
XFILLER_73_185 VPWR VGND VPWR VGND sky130_ef_sc_hd__decap_12
XFILLER_64_73 VGND VGND VPWR VPWR sky130_fd_sc_hd__fill_1
XFILLER_61_303 VGND VGND VPWR VPWR sky130_fd_sc_hd__fill_2
XFILLER_15_720 VGND VGND VPWR VPWR sky130_fd_sc_hd__fill_2
XFILLER_27_580 VPWR VGND VPWR VGND sky130_ef_sc_hd__decap_12
X_12775_ net680 net659 net541 net533 VGND VGND VPWR VPWR _05588_ sky130_fd_sc_hd__and4b_1
XFILLER_61_369 VGND VGND VPWR VPWR sky130_fd_sc_hd__fill_2
XFILLER_15_797 VPWR VGND VPWR VGND sky130_ef_sc_hd__decap_12
X_11726_ _04348_ _04359_ _04346_ VGND VGND VPWR VPWR _04447_ sky130_fd_sc_hd__a21oi_1
XFILLER_9_57 VPWR VGND VPWR VGND sky130_ef_sc_hd__decap_12
X_11657_ _04370_ _04371_ VGND VGND VPWR VPWR _04372_ sky130_fd_sc_hd__and2_1
XFILLER_127_132 VPWR VGND VPWR VGND sky130_ef_sc_hd__decap_12
XTAP_TAPCELL_ROW_77_1414 VGND VPWR sky130_fd_sc_hd__tapvpwrvgnd_1
X_10608_ net579 net301 VGND VGND VPWR VPWR _03227_ sky130_fd_sc_hd__nand2_1
X_11588_ _04294_ _04295_ VGND VGND VPWR VPWR _04298_ sky130_fd_sc_hd__xor2_4
XTAP_TAPCELL_ROW_12_475 VGND VPWR sky130_fd_sc_hd__tapvpwrvgnd_1
XFILLER_128_699 VGND VGND VPWR VPWR sky130_fd_sc_hd__fill_1
X_13327_ _06036_ _06190_ VGND VGND VPWR VPWR _06191_ sky130_fd_sc_hd__xnor2_1
XFILLER_10_491 VPWR VGND VPWR VGND sky130_ef_sc_hd__decap_12
X_10539_ net466 net275 _02983_ VGND VGND VPWR VPWR _03152_ sky130_fd_sc_hd__and3_1
XFILLER_127_187 VPWR VGND VPWR VGND sky130_ef_sc_hd__decap_12
XFILLER_115_349 VGND VGND VPWR VPWR sky130_fd_sc_hd__decap_4
XFILLER_131_809 VPWR VGND VPWR VGND sky130_ef_sc_hd__decap_12
XTAP_TAPCELL_ROW_90_1603 VGND VPWR sky130_fd_sc_hd__tapvpwrvgnd_1
XFILLER_89_81 VGND VGND VPWR VPWR sky130_fd_sc_hd__fill_1
X_13258_ _05315_ _06115_ VGND VGND VPWR VPWR _06117_ sky130_fd_sc_hd__nand2_1
X_13189_ _05894_ _06040_ VGND VGND VPWR VPWR _06041_ sky130_fd_sc_hd__xnor2_1
X_12209_ _04763_ _04818_ _04820_ _04814_ VGND VGND VPWR VPWR _04971_ sky130_fd_sc_hd__o22ai_1
XFILLER_36_3 VPWR VGND VPWR VGND sky130_ef_sc_hd__decap_12
XFILLER_69_447 VGND VGND VPWR VPWR sky130_fd_sc_hd__fill_1
XFILLER_84_417 VGND VGND VPWR VPWR sky130_fd_sc_hd__decap_3
X_07750_ _00226_ _00227_ net669 net415 VGND VGND VPWR VPWR _00229_ sky130_fd_sc_hd__and4bb_1
XFILLER_37_333 VGND VGND VPWR VPWR sky130_fd_sc_hd__decap_3
XTAP_TAPCELL_ROW_88_1576 VGND VPWR sky130_fd_sc_hd__tapvpwrvgnd_1
XFILLER_65_664 VGND VGND VPWR VPWR sky130_fd_sc_hd__decap_8
XFILLER_64_141 VPWR VGND VPWR VGND sky130_ef_sc_hd__decap_12
X_07681_ net700 net697 net538 net532 VGND VGND VPWR VPWR _00160_ sky130_fd_sc_hd__and4b_1
X_09420_ net336 net414 VGND VGND VPWR VPWR _01935_ sky130_fd_sc_hd__and2b_1
XFILLER_92_472 VGND VGND VPWR VPWR sky130_fd_sc_hd__decap_4
XFILLER_37_377 VGND VGND VPWR VPWR sky130_fd_sc_hd__fill_2
X_09351_ _01686_ _01685_ _01684_ VGND VGND VPWR VPWR _01861_ sky130_fd_sc_hd__a21oi_4
XFILLER_52_358 VGND VGND VPWR VPWR sky130_fd_sc_hd__decap_6
X_09282_ net438 net333 net335 net431 VGND VGND VPWR VPWR _01785_ sky130_fd_sc_hd__a22o_1
X_08302_ _00753_ _00776_ VGND VGND VPWR VPWR _00777_ sky130_fd_sc_hd__xnor2_1
XFILLER_33_561 VGND VGND VPWR VPWR sky130_fd_sc_hd__decap_3
XTAP_TAPCELL_ROW_119_2020 VGND VPWR sky130_fd_sc_hd__tapvpwrvgnd_1
XFILLER_60_391 VGND VGND VPWR VPWR sky130_fd_sc_hd__decap_3
X_08233_ _00707_ _00702_ VGND VGND VPWR VPWR _00708_ sky130_fd_sc_hd__and2b_1
XFILLER_20_222 VPWR VGND VPWR VGND sky130_ef_sc_hd__decap_12
XTAP_TAPCELL_ROW_119_2031 VGND VPWR sky130_fd_sc_hd__tapvpwrvgnd_1
XFILLER_119_611 VGND VGND VPWR VPWR sky130_fd_sc_hd__decap_4
XFILLER_20_266 VGND VGND VPWR VPWR sky130_fd_sc_hd__decap_3
XTAP_TAPCELL_ROW_31_751 VGND VPWR sky130_fd_sc_hd__tapvpwrvgnd_1
XFILLER_119_644 VPWR VGND VPWR VGND sky130_ef_sc_hd__decap_12
X_08164_ _00522_ _00532_ _00521_ VGND VGND VPWR VPWR _00640_ sky130_fd_sc_hd__a21oi_1
XTAP_TAPCELL_ROW_132_2220 VGND VPWR sky130_fd_sc_hd__tapvpwrvgnd_1
XFILLER_106_305 VGND VGND VPWR VPWR sky130_fd_sc_hd__decap_3
X_07115_ net116 net512 net685 net504 VGND VGND VPWR VPWR _04591_ sky130_fd_sc_hd__and4_1
X_08095_ _00568_ _00569_ _00564_ VGND VGND VPWR VPWR _00571_ sky130_fd_sc_hd__a21o_1
XFILLER_134_625 VGND VGND VPWR VPWR sky130_fd_sc_hd__fill_1
XFILLER_133_113 VPWR VGND VPWR VGND sky130_ef_sc_hd__decap_12
XFILLER_109_69 VGND VGND VPWR VPWR sky130_fd_sc_hd__decap_8
XFILLER_106_316 VPWR VGND VPWR VGND sky130_ef_sc_hd__decap_12
X_07046_ _03697_ _03784_ _02020_ VGND VGND VPWR VPWR _03839_ sky130_fd_sc_hd__a21oi_1
XFILLER_88_701 VPWR VGND VPWR VGND sky130_ef_sc_hd__decap_12
XFILLER_87_200 VGND VGND VPWR VPWR sky130_fd_sc_hd__decap_8
XFILLER_125_57 VPWR VGND VPWR VGND sky130_ef_sc_hd__decap_12
XFILLER_102_533 VPWR VGND VPWR VGND sky130_ef_sc_hd__decap_12
XTAP_TAPCELL_ROW_110_1894 VGND VPWR sky130_fd_sc_hd__tapvpwrvgnd_1
X_08997_ net639 net38 VGND VGND VPWR VPWR _01474_ sky130_fd_sc_hd__nand2_1
XFILLER_85_39 VPWR VGND VPWR VGND sky130_ef_sc_hd__decap_12
XFILLER_68_491 VPWR VGND VPWR VGND sky130_ef_sc_hd__decap_12
X_07948_ _00423_ _00424_ VGND VGND VPWR VPWR _00426_ sky130_fd_sc_hd__xnor2_1
X_07879_ _00350_ _00356_ VGND VGND VPWR VPWR _00357_ sky130_fd_sc_hd__xnor2_1
XTAP_TAPCELL_ROW_39_862 VGND VPWR sky130_fd_sc_hd__tapvpwrvgnd_1
X_09618_ _01982_ _01996_ _01995_ VGND VGND VPWR VPWR _02152_ sky130_fd_sc_hd__a21o_1
X_10890_ _03372_ _03389_ _03387_ VGND VGND VPWR VPWR _03535_ sky130_fd_sc_hd__o21a_1
XFILLER_28_377 VGND VGND VPWR VPWR sky130_fd_sc_hd__decap_4
X_09549_ _01951_ _01970_ _01969_ VGND VGND VPWR VPWR _02076_ sky130_fd_sc_hd__a21oi_1
X_12560_ _06694_ _05354_ VGND VGND VPWR VPWR _05355_ sky130_fd_sc_hd__and2_1
XFILLER_11_222 VGND VGND VPWR VPWR sky130_fd_sc_hd__fill_2
XFILLER_24_583 VGND VGND VPWR VPWR sky130_fd_sc_hd__decap_4
XFILLER_34_65 VPWR VGND VPWR VGND sky130_ef_sc_hd__decap_12
X_12491_ _05277_ _05278_ VGND VGND VPWR VPWR _05279_ sky130_fd_sc_hd__and2b_1
XFILLER_7_204 VGND VGND VPWR VPWR sky130_fd_sc_hd__fill_2
XFILLER_11_255 VGND VGND VPWR VPWR sky130_fd_sc_hd__fill_1
XFILLER_12_778 VPWR VGND VPWR VGND sky130_ef_sc_hd__decap_12
X_11511_ net474 net288 net286 net483 VGND VGND VPWR VPWR _04214_ sky130_fd_sc_hd__a22o_1
XFILLER_8_749 VGND VGND VPWR VPWR sky130_fd_sc_hd__decap_6
XFILLER_11_299 VGND VGND VPWR VPWR sky130_fd_sc_hd__fill_1
X_11442_ _03980_ _03991_ _03990_ VGND VGND VPWR VPWR _04139_ sky130_fd_sc_hd__a21oi_1
XFILLER_125_614 VGND VGND VPWR VPWR sky130_fd_sc_hd__fill_2
XFILLER_109_143 VPWR VGND VPWR VGND sky130_ef_sc_hd__decap_12
XFILLER_50_53 VPWR VGND VPWR VGND sky130_ef_sc_hd__decap_12
X_11373_ _04028_ _04062_ VGND VGND VPWR VPWR _04063_ sky130_fd_sc_hd__and2b_1
XFILLER_7_259 VGND VGND VPWR VPWR sky130_fd_sc_hd__decap_6
XFILLER_125_625 VPWR VGND VPWR VGND sky130_ef_sc_hd__decap_12
X_13112_ _05476_ _05956_ VGND VGND VPWR VPWR _05957_ sky130_fd_sc_hd__xnor2_1
XTAP_TAPCELL_ROW_59_1155 VGND VPWR sky130_fd_sc_hd__tapvpwrvgnd_1
XFILLER_50_97 VGND VGND VPWR VPWR sky130_fd_sc_hd__decap_3
X_10324_ net580 net76 net308 net589 VGND VGND VPWR VPWR _02916_ sky130_fd_sc_hd__a22o_1
XFILLER_3_410 VGND VGND VPWR VPWR sky130_fd_sc_hd__decap_3
XFILLER_113_809 VPWR VGND VPWR VGND sky130_ef_sc_hd__decap_12
XFILLER_133_680 VGND VGND VPWR VPWR sky130_fd_sc_hd__decap_6
X_13043_ _05564_ _05729_ VGND VGND VPWR VPWR _05882_ sky130_fd_sc_hd__nor2_1
XTAP_TAPCELL_ROW_72_1344 VGND VPWR sky130_fd_sc_hd__tapvpwrvgnd_1
X_10255_ _02837_ _02840_ VGND VGND VPWR VPWR _02841_ sky130_fd_sc_hd__xnor2_1
X_10186_ _02766_ _02768_ VGND VGND VPWR VPWR _02769_ sky130_fd_sc_hd__xnor2_1
XFILLER_78_222 VGND VGND VPWR VPWR sky130_fd_sc_hd__decap_4
XFILLER_94_737 VGND VGND VPWR VPWR sky130_fd_sc_hd__decap_8
XFILLER_93_225 VGND VGND VPWR VPWR sky130_fd_sc_hd__fill_2
XFILLER_78_288 VGND VGND VPWR VPWR sky130_fd_sc_hd__fill_2
Xfanout290 net87 VGND VGND VPWR VPWR net290 sky130_fd_sc_hd__clkbuf_4
XFILLER_46_141 VGND VGND VPWR VPWR sky130_fd_sc_hd__fill_2
XFILLER_19_366 VGND VGND VPWR VPWR sky130_fd_sc_hd__decap_8
XFILLER_75_83 VPWR VGND VPWR VGND sky130_ef_sc_hd__decap_12
XFILLER_62_601 VGND VGND VPWR VPWR sky130_fd_sc_hd__fill_2
XFILLER_46_185 VGND VGND VPWR VPWR sky130_fd_sc_hd__decap_8
X_12827_ net254 _05643_ VGND VGND VPWR VPWR _05645_ sky130_fd_sc_hd__xnor2_1
XFILLER_62_645 VGND VGND VPWR VPWR sky130_fd_sc_hd__decap_4
XFILLER_61_144 VGND VGND VPWR VPWR sky130_fd_sc_hd__fill_1
XFILLER_61_122 VGND VGND VPWR VPWR sky130_fd_sc_hd__fill_1
XTAP_TAPCELL_ROW_17_545 VGND VPWR sky130_fd_sc_hd__tapvpwrvgnd_1
X_12758_ _05568_ _05569_ VGND VGND VPWR VPWR _00038_ sky130_fd_sc_hd__nor2_1
X_12689_ _05493_ _05495_ VGND VGND VPWR VPWR _05496_ sky130_fd_sc_hd__xnor2_1
X_11709_ _04427_ _04429_ VGND VGND VPWR VPWR _00016_ sky130_fd_sc_hd__xnor2_1
XFILLER_30_586 VGND VGND VPWR VPWR sky130_fd_sc_hd__fill_2
XFILLER_116_625 VPWR VGND VPWR VGND sky130_ef_sc_hd__decap_12
XFILLER_116_669 VPWR VGND VPWR VGND sky130_ef_sc_hd__decap_12
XFILLER_131_617 VPWR VGND VPWR VGND sky130_ef_sc_hd__decap_12
X_08920_ net574 net359 VGND VGND VPWR VPWR _01390_ sky130_fd_sc_hd__nand2_1
XFILLER_69_200 VGND VGND VPWR VPWR sky130_fd_sc_hd__decap_4
XFILLER_123_190 VPWR VGND VPWR VGND sky130_ef_sc_hd__decap_12
X_08851_ net624 net375 net36 net634 VGND VGND VPWR VPWR _01317_ sky130_fd_sc_hd__a22o_1
XFILLER_85_704 VGND VGND VPWR VPWR sky130_fd_sc_hd__decap_6
X_07802_ _00279_ _00280_ VGND VGND VPWR VPWR _00281_ sky130_fd_sc_hd__and2b_1
X_08782_ _01246_ _01247_ VGND VGND VPWR VPWR _01248_ sky130_fd_sc_hd__nor2_1
XFILLER_57_428 VGND VGND VPWR VPWR sky130_fd_sc_hd__fill_1
XFILLER_38_631 VPWR VGND VPWR VGND sky130_ef_sc_hd__decap_12
X_07733_ _06804_ _00211_ VGND VGND VPWR VPWR _00212_ sky130_fd_sc_hd__xnor2_1
XFILLER_65_461 VPWR VGND VPWR VGND sky130_ef_sc_hd__decap_12
XFILLER_53_623 VGND VGND VPWR VPWR sky130_fd_sc_hd__decap_3
X_07664_ _00141_ _00142_ VGND VGND VPWR VPWR _00052_ sky130_fd_sc_hd__xnor2_1
XFILLER_25_325 VGND VGND VPWR VPWR sky130_fd_sc_hd__decap_6
XTAP_TAPCELL_ROW_36_821 VGND VPWR sky130_fd_sc_hd__tapvpwrvgnd_1
XFILLER_38_686 VGND VGND VPWR VPWR sky130_fd_sc_hd__decap_3
X_09403_ net260 net349 VGND VGND VPWR VPWR _01917_ sky130_fd_sc_hd__nor2_1
XFILLER_80_464 VGND VGND VPWR VPWR sky130_fd_sc_hd__fill_2
XFILLER_80_453 VGND VGND VPWR VPWR sky130_fd_sc_hd__decap_3
XFILLER_71_19 VPWR VGND VPWR VGND sky130_ef_sc_hd__decap_12
X_07595_ net457 net449 net662 VGND VGND VPWR VPWR _00075_ sky130_fd_sc_hd__and3_1
XFILLER_52_166 VGND VGND VPWR VPWR sky130_fd_sc_hd__decap_8
X_09334_ _01839_ _01840_ _01781_ VGND VGND VPWR VPWR _01842_ sky130_fd_sc_hd__o21a_1
XFILLER_21_520 VGND VGND VPWR VPWR sky130_fd_sc_hd__fill_1
XFILLER_138_216 VGND VGND VPWR VPWR sky130_fd_sc_hd__decap_8
X_09265_ _01581_ _01765_ VGND VGND VPWR VPWR _01766_ sky130_fd_sc_hd__and2_1
XFILLER_138_249 VGND VGND VPWR VPWR sky130_fd_sc_hd__decap_3
X_09196_ _01688_ _01689_ VGND VGND VPWR VPWR _01690_ sky130_fd_sc_hd__nor2_1
X_08216_ _00596_ _00619_ _00618_ VGND VGND VPWR VPWR _00691_ sky130_fd_sc_hd__a21o_1
X_08147_ _00393_ _00622_ VGND VGND VPWR VPWR _00623_ sky130_fd_sc_hd__xnor2_1
X_08078_ _00426_ _00428_ _00425_ VGND VGND VPWR VPWR _00555_ sky130_fd_sc_hd__o21a_1
XFILLER_134_477 VGND VGND VPWR VPWR sky130_fd_sc_hd__fill_2
XFILLER_122_639 VGND VGND VPWR VPWR sky130_fd_sc_hd__decap_4
XTAP_TAPCELL_ROW_112_1923 VGND VPWR sky130_fd_sc_hd__tapvpwrvgnd_1
X_07029_ _03565_ _03576_ _03347_ VGND VGND VPWR VPWR _03653_ sky130_fd_sc_hd__o21ai_1
XFILLER_20_78 VGND VGND VPWR VPWR sky130_fd_sc_hd__fill_2
X_10040_ net329 net413 VGND VGND VPWR VPWR _02611_ sky130_fd_sc_hd__and2b_1
XFILLER_96_27 VGND VGND VPWR VPWR sky130_fd_sc_hd__fill_1
XFILLER_88_531 VGND VGND VPWR VPWR sky130_fd_sc_hd__fill_1
XTAP_TAPCELL_ROW_54_1085 VGND VPWR sky130_fd_sc_hd__tapvpwrvgnd_1
XFILLER_75_225 VGND VGND VPWR VPWR sky130_fd_sc_hd__decap_8
XFILLER_29_631 VPWR VGND VPWR VGND sky130_ef_sc_hd__decap_12
X_11991_ _04723_ _04731_ VGND VGND VPWR VPWR _04733_ sky130_fd_sc_hd__xor2_1
XFILLER_28_141 VPWR VGND VPWR VGND sky130_ef_sc_hd__decap_12
XFILLER_84_770 VGND VGND VPWR VPWR sky130_fd_sc_hd__decap_4
X_10942_ _03539_ _03591_ VGND VGND VPWR VPWR _03592_ sky130_fd_sc_hd__xnor2_1
XFILLER_71_420 VGND VGND VPWR VPWR sky130_fd_sc_hd__fill_2
XFILLER_44_645 VGND VGND VPWR VPWR sky130_fd_sc_hd__decap_8
XFILLER_43_111 VGND VGND VPWR VPWR sky130_fd_sc_hd__fill_1
X_13661_ clknet_3_4__leaf_clk _00055_ net717 VGND VGND VPWR VPWR net180 sky130_fd_sc_hd__dfrtp_1
XTAP_TAPCELL_ROW_14_504 VGND VPWR sky130_fd_sc_hd__tapvpwrvgnd_1
X_10873_ _03514_ _03515_ VGND VGND VPWR VPWR _03517_ sky130_fd_sc_hd__xor2_1
X_12612_ net577 _05409_ _05410_ VGND VGND VPWR VPWR _05411_ sky130_fd_sc_hd__a21bo_1
X_13592_ _06399_ _06402_ _06479_ VGND VGND VPWR VPWR _06481_ sky130_fd_sc_hd__a21oi_1
XFILLER_101_81 VPWR VGND VPWR VGND sky130_ef_sc_hd__decap_12
X_12543_ _05171_ _05334_ VGND VGND VPWR VPWR _05336_ sky130_fd_sc_hd__xor2_1
XFILLER_61_30 VPWR VGND VPWR VGND sky130_ef_sc_hd__decap_12
XFILLER_8_546 VGND VGND VPWR VPWR sky130_fd_sc_hd__fill_1
X_12474_ _05254_ _05259_ VGND VGND VPWR VPWR _05260_ sky130_fd_sc_hd__xor2_2
XFILLER_8_557 VPWR VGND VPWR VGND sky130_ef_sc_hd__decap_12
XFILLER_137_260 VGND VGND VPWR VPWR sky130_fd_sc_hd__decap_3
XPHY_EDGE_ROW_20_Left_159 VGND VGND VPWR VPWR sky130_fd_sc_hd__decap_3
XANTENNA_7 net70 VGND VGND VPWR VPWR sky130_fd_sc_hd__diode_2
X_11425_ net609 net316 VGND VGND VPWR VPWR _04120_ sky130_fd_sc_hd__nand2_1
XFILLER_125_444 VGND VGND VPWR VPWR sky130_fd_sc_hd__decap_4
X_11356_ _04041_ _04042_ VGND VGND VPWR VPWR _04044_ sky130_fd_sc_hd__xnor2_1
XFILLER_113_617 VGND VGND VPWR VPWR sky130_fd_sc_hd__decap_3
X_10307_ net82 net295 _02818_ VGND VGND VPWR VPWR _02897_ sky130_fd_sc_hd__o21ai_1
X_13026_ _05813_ _05862_ VGND VGND VPWR VPWR _05863_ sky130_fd_sc_hd__xnor2_1
XFILLER_3_284 VPWR VGND VPWR VGND sky130_ef_sc_hd__decap_12
X_11287_ _03952_ _03968_ VGND VGND VPWR VPWR _03969_ sky130_fd_sc_hd__xor2_1
XFILLER_94_501 VPWR VGND VPWR VGND sky130_ef_sc_hd__decap_12
X_10238_ _02796_ _02797_ _02798_ _02822_ VGND VGND VPWR VPWR _02824_ sky130_fd_sc_hd__or4_1
X_10169_ _02749_ _02751_ VGND VGND VPWR VPWR _02752_ sky130_fd_sc_hd__nand2_1
XFILLER_94_545 VPWR VGND VPWR VGND sky130_ef_sc_hd__decap_12
XFILLER_79_597 VGND VGND VPWR VPWR sky130_fd_sc_hd__decap_6
XFILLER_66_247 VGND VGND VPWR VPWR sky130_fd_sc_hd__decap_4
XFILLER_94_589 VPWR VGND VPWR VGND sky130_ef_sc_hd__decap_12
XFILLER_35_612 VGND VGND VPWR VPWR sky130_fd_sc_hd__decap_4
XTAP_TAPCELL_ROW_85_1535 VGND VPWR sky130_fd_sc_hd__tapvpwrvgnd_1
XFILLER_22_306 VGND VGND VPWR VPWR sky130_fd_sc_hd__fill_2
X_07380_ _06602_ _06609_ VGND VGND VPWR VPWR _06610_ sky130_fd_sc_hd__nand2_1
XFILLER_15_391 VGND VGND VPWR VPWR sky130_fd_sc_hd__fill_1
X_09050_ _01530_ _01531_ VGND VGND VPWR VPWR _01532_ sky130_fd_sc_hd__and2b_1
XFILLER_129_772 VPWR VGND VPWR VGND sky130_ef_sc_hd__decap_12
X_08001_ net493 net677 _00343_ _00197_ VGND VGND VPWR VPWR _00478_ sky130_fd_sc_hd__a31oi_2
XTAP_TAPCELL_ROW_41_890 VGND VPWR sky130_fd_sc_hd__tapvpwrvgnd_1
XFILLER_116_433 VPWR VGND VPWR VGND sky130_ef_sc_hd__decap_12
XTAP_TAPCELL_ROW_96_1686 VGND VPWR sky130_fd_sc_hd__tapvpwrvgnd_1
Xmax_cap232 _05056_ VGND VGND VPWR VPWR net232 sky130_fd_sc_hd__clkbuf_1
Xmax_cap243 _04564_ VGND VGND VPWR VPWR net243 sky130_fd_sc_hd__clkbuf_1
XFILLER_116_499 VGND VGND VPWR VPWR sky130_fd_sc_hd__fill_1
XFILLER_116_477 VGND VGND VPWR VPWR sky130_fd_sc_hd__fill_2
X_09952_ _02262_ _02514_ VGND VGND VPWR VPWR _02515_ sky130_fd_sc_hd__xnor2_4
XFILLER_103_105 VGND VGND VPWR VPWR sky130_fd_sc_hd__decap_6
XTAP_TAPCELL_ROW_96_1697 VGND VPWR sky130_fd_sc_hd__tapvpwrvgnd_1
X_08903_ _01369_ _01370_ VGND VGND VPWR VPWR _01371_ sky130_fd_sc_hd__nor2_1
XFILLER_131_447 VGND VGND VPWR VPWR sky130_fd_sc_hd__fill_1
X_09883_ _02437_ _02438_ VGND VGND VPWR VPWR _02440_ sky130_fd_sc_hd__xor2_1
XFILLER_112_672 VPWR VGND VPWR VGND sky130_ef_sc_hd__decap_12
XFILLER_58_726 VGND VGND VPWR VPWR sky130_fd_sc_hd__decap_6
X_08834_ net463 net455 net334 net335 VGND VGND VPWR VPWR _01300_ sky130_fd_sc_hd__and4_1
XFILLER_66_19 VGND VGND VPWR VPWR sky130_fd_sc_hd__decap_8
XFILLER_57_225 VGND VGND VPWR VPWR sky130_fd_sc_hd__decap_8
XTAP_TAPCELL_ROW_127_2141 VGND VPWR sky130_fd_sc_hd__tapvpwrvgnd_1
X_08765_ _01228_ _01230_ _01231_ VGND VGND VPWR VPWR _01232_ sky130_fd_sc_hd__nand3_2
XFILLER_73_718 VGND VGND VPWR VPWR sky130_fd_sc_hd__fill_1
XFILLER_45_409 VGND VGND VPWR VPWR sky130_fd_sc_hd__decap_8
XFILLER_72_228 VGND VGND VPWR VPWR sky130_fd_sc_hd__fill_1
X_07716_ net686 net258 VGND VGND VPWR VPWR _00195_ sky130_fd_sc_hd__nor2_1
X_08696_ net633 net624 net377 net376 VGND VGND VPWR VPWR _01163_ sky130_fd_sc_hd__and4_1
XFILLER_82_29 VPWR VGND VPWR VGND sky130_ef_sc_hd__decap_12
XFILLER_65_291 VGND VGND VPWR VPWR sky130_fd_sc_hd__decap_3
XFILLER_26_645 VGND VGND VPWR VPWR sky130_fd_sc_hd__decap_4
XFILLER_81_762 VGND VGND VPWR VPWR sky130_fd_sc_hd__fill_1
X_07647_ _06710_ _06712_ _00125_ _00126_ VGND VGND VPWR VPWR _00127_ sky130_fd_sc_hd__o211ai_2
XFILLER_41_615 VGND VGND VPWR VPWR sky130_fd_sc_hd__fill_1
XTAP_TAPCELL_ROW_0_287 VGND VPWR sky130_fd_sc_hd__tapvpwrvgnd_1
XFILLER_26_667 VGND VGND VPWR VPWR sky130_fd_sc_hd__fill_1
XFILLER_26_678 VPWR VGND VPWR VGND sky130_ef_sc_hd__decap_12
X_07578_ _06799_ _06805_ VGND VGND VPWR VPWR _06807_ sky130_fd_sc_hd__xor2_1
XFILLER_53_497 VGND VGND VPWR VPWR sky130_fd_sc_hd__decap_6
XTAP_TAPCELL_ROW_0_298 VGND VPWR sky130_fd_sc_hd__tapvpwrvgnd_1
X_09317_ _01420_ _00104_ _01820_ _01821_ VGND VGND VPWR VPWR _01823_ sky130_fd_sc_hd__or4_4
XFILLER_21_350 VGND VGND VPWR VPWR sky130_fd_sc_hd__decap_8
X_09248_ net481 net349 net348 net490 VGND VGND VPWR VPWR _01748_ sky130_fd_sc_hd__a22o_1
XFILLER_5_505 VPWR VGND VPWR VGND sky130_ef_sc_hd__decap_12
X_09179_ _01569_ _01672_ VGND VGND VPWR VPWR _01673_ sky130_fd_sc_hd__nor2_1
XFILLER_31_55 VGND VGND VPWR VPWR sky130_fd_sc_hd__fill_1
XFILLER_135_753 VPWR VGND VPWR VGND sky130_ef_sc_hd__decap_12
X_12190_ _04948_ _04949_ VGND VGND VPWR VPWR _04950_ sky130_fd_sc_hd__nand2_1
XTAP_TAPCELL_ROW_56_1114 VGND VPWR sky130_fd_sc_hd__tapvpwrvgnd_1
X_11210_ net544 net304 _03884_ VGND VGND VPWR VPWR _03885_ sky130_fd_sc_hd__and3_1
XFILLER_135_797 VPWR VGND VPWR VGND sky130_ef_sc_hd__decap_12
XFILLER_134_263 VPWR VGND VPWR VGND sky130_ef_sc_hd__decap_12
XFILLER_103_3 VPWR VGND VPWR VGND sky130_ef_sc_hd__decap_12
X_11141_ net442 net272 VGND VGND VPWR VPWR _03810_ sky130_fd_sc_hd__nand2_1
XFILLER_110_609 VPWR VGND VPWR VGND sky130_ef_sc_hd__decap_12
XFILLER_95_309 VGND VGND VPWR VPWR sky130_fd_sc_hd__decap_6
XFILLER_76_501 VGND VGND VPWR VPWR sky130_fd_sc_hd__fill_2
Xinput100 w30[2] VGND VGND VPWR VPWR net100 sky130_fd_sc_hd__clkbuf_2
X_11072_ _03730_ _03733_ VGND VGND VPWR VPWR _03734_ sky130_fd_sc_hd__xnor2_1
Xinput111 w31[5] VGND VGND VPWR VPWR net111 sky130_fd_sc_hd__dlymetal6s2s_1
XFILLER_1_777 VGND VGND VPWR VPWR sky130_fd_sc_hd__decap_6
X_10023_ _02493_ _02505_ _02492_ VGND VGND VPWR VPWR _02592_ sky130_fd_sc_hd__a21bo_1
Xinput133 x0[3] VGND VGND VPWR VPWR net133 sky130_fd_sc_hd__buf_1
Xinput122 w33[0] VGND VGND VPWR VPWR net122 sky130_fd_sc_hd__clkbuf_2
Xinput144 x1[6] VGND VGND VPWR VPWR net144 sky130_fd_sc_hd__clkbuf_1
XFILLER_0_287 VGND VGND VPWR VPWR sky130_fd_sc_hd__decap_3
XFILLER_76_556 VPWR VGND VPWR VGND sky130_ef_sc_hd__decap_12
XFILLER_56_41 VPWR VGND VPWR VGND sky130_ef_sc_hd__decap_12
Xinput155 x3[1] VGND VGND VPWR VPWR net155 sky130_fd_sc_hd__buf_1
XFILLER_36_409 VGND VGND VPWR VPWR sky130_fd_sc_hd__decap_8
XFILLER_76_589 VGND VGND VPWR VPWR sky130_fd_sc_hd__fill_1
X_11974_ _04676_ _04713_ VGND VGND VPWR VPWR _04714_ sky130_fd_sc_hd__and2_1
XFILLER_57_792 VPWR VGND VPWR VGND sky130_ef_sc_hd__decap_12
XTAP_TAPCELL_ROW_67_1276 VGND VPWR sky130_fd_sc_hd__tapvpwrvgnd_1
XTAP_TAPCELL_ROW_67_1265 VGND VPWR sky130_fd_sc_hd__tapvpwrvgnd_1
X_10925_ _03570_ net300 net568 _06762_ VGND VGND VPWR VPWR _03573_ sky130_fd_sc_hd__and4b_1
XFILLER_32_604 VGND VGND VPWR VPWR sky130_fd_sc_hd__decap_4
X_13644_ clknet_3_4__leaf_clk _00027_ net718 VGND VGND VPWR VPWR net163 sky130_fd_sc_hd__dfrtp_1
XFILLER_71_272 VGND VGND VPWR VPWR sky130_fd_sc_hd__decap_8
XTAP_TAPCELL_ROW_27_684 VGND VPWR sky130_fd_sc_hd__tapvpwrvgnd_1
XTAP_TAPCELL_ROW_27_695 VGND VPWR sky130_fd_sc_hd__tapvpwrvgnd_1
X_10856_ _03316_ _03324_ _03323_ VGND VGND VPWR VPWR _03498_ sky130_fd_sc_hd__a21bo_1
XFILLER_32_648 VPWR VGND VPWR VGND sky130_ef_sc_hd__decap_12
XTAP_TAPCELL_ROW_80_1454 VGND VPWR sky130_fd_sc_hd__tapvpwrvgnd_1
X_13575_ _06460_ _06461_ VGND VGND VPWR VPWR _06462_ sky130_fd_sc_hd__nor2_1
XTAP_TAPCELL_ROW_80_1465 VGND VPWR sky130_fd_sc_hd__tapvpwrvgnd_1
X_10787_ net283 net410 VGND VGND VPWR VPWR _03422_ sky130_fd_sc_hd__and2b_1
X_12526_ net461 net382 VGND VGND VPWR VPWR _05317_ sky130_fd_sc_hd__nand2_1
XFILLER_75_7 VPWR VGND VPWR VGND sky130_ef_sc_hd__decap_12
X_12457_ _05238_ _05239_ VGND VGND VPWR VPWR _05241_ sky130_fd_sc_hd__xnor2_1
XFILLER_8_365 VGND VGND VPWR VPWR sky130_fd_sc_hd__decap_4
X_11408_ _04067_ _04099_ VGND VGND VPWR VPWR _04102_ sky130_fd_sc_hd__xnor2_1
XFILLER_99_615 VGND VGND VPWR VPWR sky130_fd_sc_hd__fill_1
X_12388_ net615 net404 _05021_ _05020_ VGND VGND VPWR VPWR _05167_ sky130_fd_sc_hd__a31o_1
XFILLER_125_296 VPWR VGND VPWR VGND sky130_ef_sc_hd__decap_12
XFILLER_113_425 VGND VGND VPWR VPWR sky130_fd_sc_hd__fill_1
X_11339_ _04023_ _04025_ VGND VGND VPWR VPWR _04026_ sky130_fd_sc_hd__nor2_1
XFILLER_97_81 VPWR VGND VPWR VGND sky130_ef_sc_hd__decap_12
XFILLER_86_309 VGND VGND VPWR VPWR sky130_fd_sc_hd__fill_1
XFILLER_67_501 VGND VGND VPWR VPWR sky130_fd_sc_hd__decap_3
X_13009_ net629 net620 net303 net284 VGND VGND VPWR VPWR _05845_ sky130_fd_sc_hd__and4_1
X_06880_ _01998_ _02009_ VGND VGND VPWR VPWR _02030_ sky130_fd_sc_hd__xnor2_1
XFILLER_39_225 VPWR VGND VPWR VGND sky130_ef_sc_hd__decap_12
XFILLER_94_342 VPWR VGND VPWR VGND sky130_ef_sc_hd__decap_12
XFILLER_39_269 VGND VGND VPWR VPWR sky130_fd_sc_hd__decap_4
X_08550_ _01015_ _01016_ _01018_ VGND VGND VPWR VPWR _01019_ sky130_fd_sc_hd__and3_1
XTAP_TAPCELL_ROW_46_971 VGND VPWR sky130_fd_sc_hd__tapvpwrvgnd_1
XTAP_TAPCELL_ROW_46_960 VGND VPWR sky130_fd_sc_hd__tapvpwrvgnd_1
XFILLER_23_615 VGND VGND VPWR VPWR sky130_fd_sc_hd__fill_1
X_08481_ _00952_ _00953_ VGND VGND VPWR VPWR _00954_ sky130_fd_sc_hd__nor2_1
X_07501_ _06583_ _06600_ _06598_ VGND VGND VPWR VPWR _06730_ sky130_fd_sc_hd__o21a_1
XTAP_TAPCELL_ROW_122_2071 VGND VPWR sky130_fd_sc_hd__tapvpwrvgnd_1
XFILLER_90_581 VGND VGND VPWR VPWR sky130_fd_sc_hd__decap_6
X_07432_ _06659_ _06660_ _06661_ VGND VGND VPWR VPWR _06662_ sky130_fd_sc_hd__a21oi_1
XFILLER_35_486 VGND VGND VPWR VPWR sky130_fd_sc_hd__decap_6
XFILLER_22_147 VGND VGND VPWR VPWR sky130_fd_sc_hd__fill_1
X_09102_ _01576_ _01587_ VGND VGND VPWR VPWR _01588_ sky130_fd_sc_hd__xnor2_1
XFILLER_10_309 VPWR VGND VPWR VGND sky130_ef_sc_hd__decap_12
XFILLER_22_169 VGND VGND VPWR VPWR sky130_fd_sc_hd__fill_1
X_07363_ _05602_ _05624_ _05591_ VGND VGND VPWR VPWR _06593_ sky130_fd_sc_hd__o21ba_1
XTAP_TAPCELL_ROW_98_1726 VGND VPWR sky130_fd_sc_hd__tapvpwrvgnd_1
XTAP_TAPCELL_ROW_98_1715 VGND VPWR sky130_fd_sc_hd__tapvpwrvgnd_1
X_07294_ net269 net604 net664 net466 VGND VGND VPWR VPWR _06525_ sky130_fd_sc_hd__a22oi_1
X_09033_ _01235_ _01237_ _01357_ _01358_ VGND VGND VPWR VPWR _01514_ sky130_fd_sc_hd__and4b_1
XFILLER_117_742 VGND VGND VPWR VPWR sky130_fd_sc_hd__decap_8
XFILLER_7_90 VGND VGND VPWR VPWR sky130_fd_sc_hd__decap_8
XFILLER_132_701 VPWR VGND VPWR VGND sky130_ef_sc_hd__decap_12
XFILLER_117_69 VGND VGND VPWR VPWR sky130_fd_sc_hd__decap_6
XFILLER_89_125 VPWR VGND VPWR VGND sky130_ef_sc_hd__decap_12
X_09935_ net614 _02274_ _02273_ VGND VGND VPWR VPWR _02496_ sky130_fd_sc_hd__a21o_1
XFILLER_89_169 VPWR VGND VPWR VGND sky130_ef_sc_hd__decap_12
XFILLER_89_158 VGND VGND VPWR VPWR sky130_fd_sc_hd__decap_8
XFILLER_77_309 VPWR VGND VPWR VGND sky130_ef_sc_hd__decap_12
XFILLER_131_277 VGND VGND VPWR VPWR sky130_fd_sc_hd__decap_3
X_09866_ _02411_ _02421_ VGND VGND VPWR VPWR _02422_ sky130_fd_sc_hd__xor2_1
XFILLER_100_620 VPWR VGND VPWR VGND sky130_ef_sc_hd__decap_12
XFILLER_98_681 VGND VGND VPWR VPWR sky130_fd_sc_hd__decap_8
XFILLER_86_810 VGND VGND VPWR VPWR sky130_fd_sc_hd__fill_2
XTAP_TAPCELL_ROW_51_1044 VGND VPWR sky130_fd_sc_hd__tapvpwrvgnd_1
XTAP_TAPCELL_ROW_51_1033 VGND VPWR sky130_fd_sc_hd__tapvpwrvgnd_1
XFILLER_133_57 VPWR VGND VPWR VGND sky130_ef_sc_hd__decap_12
X_08817_ _01273_ _01282_ VGND VGND VPWR VPWR _01283_ sky130_fd_sc_hd__xnor2_1
XTAP_TAPCELL_ROW_5_368 VGND VPWR sky130_fd_sc_hd__tapvpwrvgnd_1
X_09797_ _02057_ _02345_ VGND VGND VPWR VPWR _02346_ sky130_fd_sc_hd__xnor2_1
XFILLER_100_686 VPWR VGND VPWR VGND sky130_ef_sc_hd__decap_12
XFILLER_100_664 VGND VGND VPWR VPWR sky130_fd_sc_hd__decap_3
XFILLER_93_39 VPWR VGND VPWR VGND sky130_ef_sc_hd__decap_12
XFILLER_46_718 VPWR VGND VPWR VGND sky130_ef_sc_hd__decap_12
XFILLER_45_206 VGND VGND VPWR VPWR sky130_fd_sc_hd__fill_1
X_08748_ _01042_ _01045_ _01041_ VGND VGND VPWR VPWR _01215_ sky130_fd_sc_hd__a21o_1
XTAP_TAPCELL_ROW_107_1844 VGND VPWR sky130_fd_sc_hd__tapvpwrvgnd_1
X_08679_ net455 net336 net335 net463 VGND VGND VPWR VPWR _01146_ sky130_fd_sc_hd__a22o_1
XTAP_TAPCELL_ROW_107_1855 VGND VPWR sky130_fd_sc_hd__tapvpwrvgnd_1
X_10710_ _03335_ _03337_ _03179_ _03181_ VGND VGND VPWR VPWR _03339_ sky130_fd_sc_hd__a211o_1
XFILLER_26_475 VGND VGND VPWR VPWR sky130_fd_sc_hd__fill_1
XFILLER_13_125 VGND VGND VPWR VPWR sky130_fd_sc_hd__fill_2
X_11690_ _04380_ _04407_ VGND VGND VPWR VPWR _04409_ sky130_fd_sc_hd__xnor2_1
XTAP_TAPCELL_ROW_24_643 VGND VPWR sky130_fd_sc_hd__tapvpwrvgnd_1
XTAP_TAPCELL_ROW_24_654 VGND VPWR sky130_fd_sc_hd__tapvpwrvgnd_1
XFILLER_10_821 VGND VGND VPWR VPWR sky130_fd_sc_hd__decap_3
X_10641_ _03258_ _03260_ _03261_ VGND VGND VPWR VPWR _03263_ sky130_fd_sc_hd__a21o_1
X_13360_ _06219_ _06227_ VGND VGND VPWR VPWR _06228_ sky130_fd_sc_hd__and2b_1
XTAP_TAPCELL_ROW_62_1195 VGND VPWR sky130_fd_sc_hd__tapvpwrvgnd_1
XFILLER_42_65 VPWR VGND VPWR VGND sky130_ef_sc_hd__decap_12
XFILLER_21_180 VGND VGND VPWR VPWR sky130_fd_sc_hd__decap_3
X_10572_ _03184_ _03185_ _03133_ VGND VGND VPWR VPWR _03188_ sky130_fd_sc_hd__o21ai_1
XFILLER_127_517 VPWR VGND VPWR VGND sky130_ef_sc_hd__decap_12
X_12311_ _05079_ _05080_ VGND VGND VPWR VPWR _05082_ sky130_fd_sc_hd__xnor2_1
X_13291_ _06151_ _06152_ VGND VGND VPWR VPWR _06153_ sky130_fd_sc_hd__nor2_1
XFILLER_108_753 VGND VGND VPWR VPWR sky130_fd_sc_hd__decap_3
X_12242_ net446 net392 _04830_ _04829_ VGND VGND VPWR VPWR _05007_ sky130_fd_sc_hd__a31o_1
XFILLER_5_335 VGND VGND VPWR VPWR sky130_fd_sc_hd__fill_1
XFILLER_135_561 VPWR VGND VPWR VGND sky130_ef_sc_hd__decap_12
XFILLER_107_252 VGND VGND VPWR VPWR sky130_fd_sc_hd__decap_4
XFILLER_135_594 VGND VGND VPWR VPWR sky130_fd_sc_hd__fill_1
XFILLER_123_723 VGND VGND VPWR VPWR sky130_fd_sc_hd__decap_4
X_12173_ _04931_ VGND VGND VPWR VPWR _04932_ sky130_fd_sc_hd__inv_2
XFILLER_123_767 VPWR VGND VPWR VGND sky130_ef_sc_hd__decap_12
XFILLER_96_629 VGND VGND VPWR VPWR sky130_fd_sc_hd__decap_6
XFILLER_68_309 VPWR VGND VPWR VGND sky130_ef_sc_hd__decap_12
XFILLER_3_15 VPWR VGND VPWR VGND sky130_ef_sc_hd__decap_12
X_11124_ _03782_ _03790_ VGND VGND VPWR VPWR _03791_ sky130_fd_sc_hd__xor2_1
XFILLER_49_523 VGND VGND VPWR VPWR sky130_fd_sc_hd__fill_1
XFILLER_49_501 VGND VGND VPWR VPWR sky130_fd_sc_hd__decap_3
X_11055_ _03713_ _03714_ VGND VGND VPWR VPWR _03715_ sky130_fd_sc_hd__nor2_1
XFILLER_1_574 VGND VGND VPWR VPWR sky130_fd_sc_hd__fill_2
X_10006_ _02444_ _02454_ VGND VGND VPWR VPWR _02574_ sky130_fd_sc_hd__nor2_1
XFILLER_103_480 VPWR VGND VPWR VGND sky130_ef_sc_hd__decap_12
XFILLER_67_73 VGND VGND VPWR VPWR sky130_fd_sc_hd__fill_1
XFILLER_92_813 VGND VGND VPWR VPWR sky130_fd_sc_hd__decap_6
XTAP_TAPCELL_ROW_69_1305 VGND VPWR sky130_fd_sc_hd__tapvpwrvgnd_1
XFILLER_37_729 VGND VGND VPWR VPWR sky130_fd_sc_hd__decap_4
XFILLER_64_537 VGND VGND VPWR VPWR sky130_fd_sc_hd__fill_1
XPHY_EDGE_ROW_103_Left_242 VGND VGND VPWR VPWR sky130_fd_sc_hd__decap_3
X_11957_ _04692_ _04694_ _04695_ VGND VGND VPWR VPWR _04696_ sky130_fd_sc_hd__or3_1
X_10908_ _03552_ _03553_ VGND VGND VPWR VPWR _03555_ sky130_fd_sc_hd__xnor2_1
XFILLER_17_497 VGND VGND VPWR VPWR sky130_fd_sc_hd__decap_6
XFILLER_44_294 VGND VGND VPWR VPWR sky130_fd_sc_hd__decap_3
X_11888_ _04573_ _04574_ _04600_ VGND VGND VPWR VPWR _04624_ sky130_fd_sc_hd__o21a_1
X_13627_ _06513_ _06517_ VGND VGND VPWR VPWR _06518_ sky130_fd_sc_hd__xnor2_1
XFILLER_60_787 VGND VGND VPWR VPWR sky130_fd_sc_hd__decap_4
X_10839_ net636 net631 net70 net318 VGND VGND VPWR VPWR _03480_ sky130_fd_sc_hd__nand4_1
XFILLER_118_506 VGND VGND VPWR VPWR sky130_fd_sc_hd__decap_3
X_13558_ _06042_ _06361_ VGND VGND VPWR VPWR _06444_ sky130_fd_sc_hd__nand2_1
XFILLER_13_681 VGND VGND VPWR VPWR sky130_fd_sc_hd__decap_8
XPHY_EDGE_ROW_132_Right_132 VGND VGND VPWR VPWR sky130_fd_sc_hd__decap_3
X_12509_ net430 net389 _05295_ _05296_ VGND VGND VPWR VPWR _05299_ sky130_fd_sc_hd__nand4_1
XFILLER_9_663 VGND VGND VPWR VPWR sky130_fd_sc_hd__decap_3
X_13489_ _06196_ _06198_ VGND VGND VPWR VPWR _06369_ sky130_fd_sc_hd__nand2_1
XFILLER_126_550 VPWR VGND VPWR VGND sky130_ef_sc_hd__decap_12
XPHY_EDGE_ROW_112_Left_251 VGND VGND VPWR VPWR sky130_fd_sc_hd__decap_3
XFILLER_114_745 VGND VGND VPWR VPWR sky130_fd_sc_hd__fill_1
XTAP_TAPCELL_ROW_93_1645 VGND VPWR sky130_fd_sc_hd__tapvpwrvgnd_1
XFILLER_113_255 VGND VGND VPWR VPWR sky130_fd_sc_hd__decap_8
XFILLER_99_478 VGND VGND VPWR VPWR sky130_fd_sc_hd__fill_1
X_07981_ _00452_ _00457_ VGND VGND VPWR VPWR _00458_ sky130_fd_sc_hd__nand2b_1
X_09720_ net438 net429 net330 net329 VGND VGND VPWR VPWR _02263_ sky130_fd_sc_hd__and4_1
XFILLER_86_128 VPWR VGND VPWR VGND sky130_ef_sc_hd__decap_12
X_06932_ _02575_ _02586_ VGND VGND VPWR VPWR _02597_ sky130_fd_sc_hd__or2_1
XTAP_TAPCELL_ROW_124_2100 VGND VPWR sky130_fd_sc_hd__tapvpwrvgnd_1
X_09651_ _02075_ _02106_ _02105_ VGND VGND VPWR VPWR _02187_ sky130_fd_sc_hd__a21o_1
XFILLER_67_375 VPWR VGND VPWR VGND sky130_ef_sc_hd__decap_12
XTAP_TAPCELL_ROW_2_327 VGND VPWR sky130_fd_sc_hd__tapvpwrvgnd_1
X_06863_ net589 net703 net701 net580 VGND VGND VPWR VPWR _01846_ sky130_fd_sc_hd__and4_1
XPHY_EDGE_ROW_121_Left_260 VGND VGND VPWR VPWR sky130_fd_sc_hd__decap_3
X_08602_ _01060_ _01069_ VGND VGND VPWR VPWR _01070_ sky130_fd_sc_hd__nor2_1
X_09582_ net429 net331 net330 net438 VGND VGND VPWR VPWR _02112_ sky130_fd_sc_hd__a22oi_1
XFILLER_103_27 VPWR VGND VPWR VGND sky130_ef_sc_hd__decap_12
X_08533_ _01001_ _01002_ net596 net366 VGND VGND VPWR VPWR _01003_ sky130_fd_sc_hd__or4bb_2
XFILLER_82_356 VGND VGND VPWR VPWR sky130_fd_sc_hd__fill_1
XFILLER_70_518 VGND VGND VPWR VPWR sky130_fd_sc_hd__decap_6
XFILLER_42_209 VPWR VGND VPWR VGND sky130_ef_sc_hd__decap_12
XFILLER_51_732 VPWR VGND VPWR VGND sky130_ef_sc_hd__decap_12
X_08464_ _00866_ _00869_ _00935_ VGND VGND VPWR VPWR _00937_ sky130_fd_sc_hd__or3b_1
XTAP_TAPCELL_ROW_102_1774 VGND VPWR sky130_fd_sc_hd__tapvpwrvgnd_1
X_07415_ _06640_ _06643_ _06644_ VGND VGND VPWR VPWR _06645_ sky130_fd_sc_hd__nand3_1
XFILLER_51_776 VGND VGND VPWR VPWR sky130_fd_sc_hd__decap_8
XFILLER_50_253 VPWR VGND VPWR VGND sky130_ef_sc_hd__decap_12
X_08395_ _00868_ _00860_ VGND VGND VPWR VPWR _00869_ sky130_fd_sc_hd__and2b_1
XTAP_TAPCELL_ROW_21_602 VGND VPWR sky130_fd_sc_hd__tapvpwrvgnd_1
XTAP_TAPCELL_ROW_102_1785 VGND VPWR sky130_fd_sc_hd__tapvpwrvgnd_1
X_07346_ _05733_ _05919_ _05897_ VGND VGND VPWR VPWR _06576_ sky130_fd_sc_hd__o21bai_1
XFILLER_10_139 VGND VGND VPWR VPWR sky130_fd_sc_hd__fill_1
XTAP_TAPCELL_ROW_135_2262 VGND VPWR sky130_fd_sc_hd__tapvpwrvgnd_1
XTAP_TAPCELL_ROW_135_2251 VGND VPWR sky130_fd_sc_hd__tapvpwrvgnd_1
X_09016_ _01337_ _01339_ _01493_ _01494_ VGND VGND VPWR VPWR _01495_ sky130_fd_sc_hd__o211ai_2
X_07277_ _06312_ _06345_ VGND VGND VPWR VPWR _06356_ sky130_fd_sc_hd__xnor2_1
X_09918_ net250 _02475_ VGND VGND VPWR VPWR _02478_ sky130_fd_sc_hd__xor2_1
Xfanout620 net626 VGND VGND VPWR VPWR net620 sky130_fd_sc_hd__clkbuf_4
XFILLER_77_106 VGND VGND VPWR VPWR sky130_fd_sc_hd__decap_6
Xfanout642 net649 VGND VGND VPWR VPWR net642 sky130_fd_sc_hd__buf_2
Xfanout631 net635 VGND VGND VPWR VPWR net631 sky130_fd_sc_hd__buf_2
Xfanout664 net128 VGND VGND VPWR VPWR net664 sky130_fd_sc_hd__buf_2
Xfanout675 net121 VGND VGND VPWR VPWR net675 sky130_fd_sc_hd__clkbuf_4
Xfanout653 net130 VGND VGND VPWR VPWR net653 sky130_fd_sc_hd__clkbuf_4
X_09849_ _02397_ _02403_ VGND VGND VPWR VPWR _02404_ sky130_fd_sc_hd__nor2_1
XFILLER_92_109 VGND VGND VPWR VPWR sky130_fd_sc_hd__fill_2
XFILLER_74_813 VGND VGND VPWR VPWR sky130_fd_sc_hd__decap_4
Xfanout686 net116 VGND VGND VPWR VPWR net686 sky130_fd_sc_hd__buf_2
XFILLER_19_707 VGND VGND VPWR VPWR sky130_fd_sc_hd__decap_3
XFILLER_19_729 VGND VGND VPWR VPWR sky130_fd_sc_hd__decap_8
XTAP_TAPCELL_ROW_29_713 VGND VPWR sky130_fd_sc_hd__tapvpwrvgnd_1
Xfanout697 net109 VGND VGND VPWR VPWR net697 sky130_fd_sc_hd__buf_2
XFILLER_86_695 VGND VGND VPWR VPWR sky130_fd_sc_hd__decap_4
X_12860_ net369 net600 VGND VGND VPWR VPWR _05682_ sky130_fd_sc_hd__nand2b_1
XTAP_TAPCELL_ROW_29_724 VGND VPWR sky130_fd_sc_hd__tapvpwrvgnd_1
X_11811_ _04538_ _04539_ VGND VGND VPWR VPWR _04541_ sky130_fd_sc_hd__xor2_1
X_12791_ _05599_ _05604_ VGND VGND VPWR VPWR _05606_ sky130_fd_sc_hd__xor2_1
XTAP_TAPCELL_ROW_64_1224 VGND VPWR sky130_fd_sc_hd__tapvpwrvgnd_1
X_11742_ _04390_ _04403_ _04402_ VGND VGND VPWR VPWR _04465_ sky130_fd_sc_hd__a21o_1
X_11673_ _04388_ _04389_ VGND VGND VPWR VPWR _04390_ sky130_fd_sc_hd__nor2_1
X_13412_ _06073_ _06150_ _06148_ VGND VGND VPWR VPWR _06285_ sky130_fd_sc_hd__a21oi_1
X_10624_ _03224_ _03243_ VGND VGND VPWR VPWR _03244_ sky130_fd_sc_hd__xor2_1
X_13343_ _06099_ _06101_ _06208_ VGND VGND VPWR VPWR _06209_ sky130_fd_sc_hd__o21ba_1
XFILLER_10_640 VGND VGND VPWR VPWR sky130_fd_sc_hd__decap_4
XFILLER_127_325 VGND VGND VPWR VPWR sky130_fd_sc_hd__decap_8
XFILLER_10_695 VGND VGND VPWR VPWR sky130_fd_sc_hd__decap_4
X_10555_ _03159_ _03167_ _03168_ VGND VGND VPWR VPWR _03169_ sky130_fd_sc_hd__nand3_1
XFILLER_108_561 VGND VGND VPWR VPWR sky130_fd_sc_hd__decap_4
X_13274_ _05971_ _06133_ VGND VGND VPWR VPWR _06134_ sky130_fd_sc_hd__xor2_1
X_10486_ _02908_ _02911_ VGND VGND VPWR VPWR _03093_ sky130_fd_sc_hd__or2_1
X_12225_ _04725_ _04759_ _04817_ VGND VGND VPWR VPWR _04988_ sky130_fd_sc_hd__nor3_1
X_12156_ _04908_ _04912_ _04903_ _04905_ VGND VGND VPWR VPWR _04913_ sky130_fd_sc_hd__o211ai_4
XTAP_TAPCELL_ROW_75_1386 VGND VPWR sky130_fd_sc_hd__tapvpwrvgnd_1
XFILLER_69_629 VPWR VGND VPWR VGND sky130_ef_sc_hd__decap_12
X_11107_ _03771_ VGND VGND VPWR VPWR _03772_ sky130_fd_sc_hd__inv_2
X_12087_ net446 net26 _04835_ _04833_ VGND VGND VPWR VPWR _04837_ sky130_fd_sc_hd__a31o_1
XFILLER_49_320 VGND VGND VPWR VPWR sky130_fd_sc_hd__decap_4
XFILLER_1_393 VGND VGND VPWR VPWR sky130_fd_sc_hd__fill_2
X_11038_ _03694_ _03695_ _03516_ _03518_ VGND VGND VPWR VPWR _03698_ sky130_fd_sc_hd__a211o_1
XFILLER_91_120 VPWR VGND VPWR VGND sky130_ef_sc_hd__decap_12
XFILLER_37_559 VGND VGND VPWR VPWR sky130_fd_sc_hd__fill_1
X_12989_ net445 net381 _05667_ _05497_ VGND VGND VPWR VPWR _05823_ sky130_fd_sc_hd__a31o_1
XFILLER_17_272 VGND VGND VPWR VPWR sky130_fd_sc_hd__fill_1
XFILLER_60_573 VGND VGND VPWR VPWR sky130_fd_sc_hd__decap_8
XFILLER_32_253 VPWR VGND VPWR VGND sky130_ef_sc_hd__decap_12
X_08180_ _00641_ _00654_ VGND VGND VPWR VPWR _00656_ sky130_fd_sc_hd__xor2_2
X_07200_ _05461_ _05472_ _05494_ VGND VGND VPWR VPWR _05516_ sky130_fd_sc_hd__a21o_1
XFILLER_20_448 VGND VGND VPWR VPWR sky130_fd_sc_hd__decap_4
XFILLER_118_303 VGND VGND VPWR VPWR sky130_fd_sc_hd__decap_4
X_07131_ _04751_ _04675_ VGND VGND VPWR VPWR _04761_ sky130_fd_sc_hd__and2b_1
XFILLER_20_459 VGND VGND VPWR VPWR sky130_fd_sc_hd__decap_3
XFILLER_133_317 VGND VGND VPWR VPWR sky130_fd_sc_hd__fill_1
X_07062_ _02909_ _03992_ _04003_ VGND VGND VPWR VPWR _04014_ sky130_fd_sc_hd__nand3b_2
Xoutput201 net201 VGND VGND VPWR VPWR y2[14] sky130_fd_sc_hd__buf_2
Xoutput223 net223 VGND VGND VPWR VPWR y3[3] sky130_fd_sc_hd__buf_2
Xoutput212 net212 VGND VGND VPWR VPWR y2[9] sky130_fd_sc_hd__buf_2
XFILLER_126_391 VGND VGND VPWR VPWR sky130_fd_sc_hd__decap_8
XFILLER_0_809 VGND VGND VPWR VPWR sky130_fd_sc_hd__decap_3
XTAP_TAPCELL_ROW_130_2181 VGND VPWR sky130_fd_sc_hd__tapvpwrvgnd_1
XFILLER_114_597 VPWR VGND VPWR VGND sky130_ef_sc_hd__decap_12
XFILLER_102_726 VPWR VGND VPWR VGND sky130_ef_sc_hd__decap_12
XFILLER_99_264 VGND VGND VPWR VPWR sky130_fd_sc_hd__decap_8
XFILLER_87_437 VGND VGND VPWR VPWR sky130_fd_sc_hd__fill_1
XFILLER_101_225 VPWR VGND VPWR VGND sky130_ef_sc_hd__decap_12
X_07964_ _00439_ _00440_ VGND VGND VPWR VPWR _00441_ sky130_fd_sc_hd__and2b_1
X_09703_ net255 _02242_ VGND VGND VPWR VPWR _02244_ sky130_fd_sc_hd__xnor2_1
XFILLER_74_109 VPWR VGND VPWR VGND sky130_ef_sc_hd__decap_12
X_06915_ _02380_ _02391_ _01900_ VGND VGND VPWR VPWR _02413_ sky130_fd_sc_hd__o21bai_1
X_07895_ net448 net662 VGND VGND VPWR VPWR _00373_ sky130_fd_sc_hd__nand2_1
XFILLER_56_813 VGND VGND VPWR VPWR sky130_fd_sc_hd__decap_8
X_09634_ _01866_ _02015_ _02014_ VGND VGND VPWR VPWR _02169_ sky130_fd_sc_hd__a21oi_1
XFILLER_110_781 VPWR VGND VPWR VGND sky130_ef_sc_hd__decap_12
X_06846_ _01627_ _01638_ _01497_ VGND VGND VPWR VPWR _01660_ sky130_fd_sc_hd__or3b_1
X_09565_ net335 net255 VGND VGND VPWR VPWR _02093_ sky130_fd_sc_hd__nor2_1
XTAP_TAPCELL_ROW_104_1814 VGND VPWR sky130_fd_sc_hd__tapvpwrvgnd_1
XTAP_TAPCELL_ROW_104_1803 VGND VPWR sky130_fd_sc_hd__tapvpwrvgnd_1
X_09496_ _02016_ _02017_ VGND VGND VPWR VPWR _02018_ sky130_fd_sc_hd__and2b_1
X_08516_ _00970_ _00987_ VGND VGND VPWR VPWR _00988_ sky130_fd_sc_hd__xnor2_1
XFILLER_90_29 VPWR VGND VPWR VGND sky130_ef_sc_hd__decap_12
XFILLER_51_573 VGND VGND VPWR VPWR sky130_fd_sc_hd__decap_3
X_08447_ _00909_ _00919_ VGND VGND VPWR VPWR _00920_ sky130_fd_sc_hd__xor2_1
XTAP_TAPCELL_ROW_34_793 VGND VPWR sky130_fd_sc_hd__tapvpwrvgnd_1
X_08378_ _00753_ _00776_ _00775_ VGND VGND VPWR VPWR _00852_ sky130_fd_sc_hd__a21oi_1
XFILLER_136_133 VGND VGND VPWR VPWR sky130_fd_sc_hd__decap_6
X_07329_ _05963_ _06558_ _06559_ VGND VGND VPWR VPWR _06560_ sky130_fd_sc_hd__nor3_1
X_10340_ _02907_ _02932_ VGND VGND VPWR VPWR _02934_ sky130_fd_sc_hd__xor2_1
X_10271_ net527 net295 VGND VGND VPWR VPWR _02859_ sky130_fd_sc_hd__nand2_1
XTAP_TAPCELL_ROW_115_1965 VGND VPWR sky130_fd_sc_hd__tapvpwrvgnd_1
X_12010_ _04700_ _04752_ VGND VGND VPWR VPWR _00005_ sky130_fd_sc_hd__xnor2_1
XFILLER_59_640 VGND VGND VPWR VPWR sky130_fd_sc_hd__fill_1
Xfanout450 net452 VGND VGND VPWR VPWR net450 sky130_fd_sc_hd__buf_2
XFILLER_120_589 VPWR VGND VPWR VGND sky130_ef_sc_hd__decap_12
XFILLER_120_567 VGND VGND VPWR VPWR sky130_fd_sc_hd__decap_4
Xfanout461 net465 VGND VGND VPWR VPWR net461 sky130_fd_sc_hd__clkbuf_4
Xfanout472 net473 VGND VGND VPWR VPWR net472 sky130_fd_sc_hd__buf_4
XFILLER_59_673 VGND VGND VPWR VPWR sky130_fd_sc_hd__decap_3
XFILLER_48_53 VPWR VGND VPWR VGND sky130_ef_sc_hd__decap_12
XFILLER_47_813 VGND VGND VPWR VPWR sky130_fd_sc_hd__fill_1
Xfanout483 net486 VGND VGND VPWR VPWR net483 sky130_fd_sc_hd__buf_2
X_12912_ _05596_ _05612_ _05611_ VGND VGND VPWR VPWR _05738_ sky130_fd_sc_hd__o21a_1
XFILLER_48_97 VGND VGND VPWR VPWR sky130_fd_sc_hd__decap_4
Xfanout494 net499 VGND VGND VPWR VPWR net494 sky130_fd_sc_hd__clkbuf_4
XFILLER_73_142 VPWR VGND VPWR VGND sky130_ef_sc_hd__decap_12
XFILLER_0_27 VGND VGND VPWR VPWR sky130_fd_sc_hd__fill_1
X_12843_ net428 net384 net383 net437 VGND VGND VPWR VPWR _05663_ sky130_fd_sc_hd__a22o_1
XFILLER_64_41 VPWR VGND VPWR VGND sky130_ef_sc_hd__decap_12
X_12774_ _05585_ _05586_ VGND VGND VPWR VPWR _05587_ sky130_fd_sc_hd__nor2_1
XFILLER_73_197 VGND VGND VPWR VPWR sky130_fd_sc_hd__decap_8
XFILLER_64_85 VGND VGND VPWR VPWR sky130_fd_sc_hd__decap_8
XFILLER_61_337 VGND VGND VPWR VPWR sky130_fd_sc_hd__decap_8
XFILLER_27_592 VGND VGND VPWR VPWR sky130_fd_sc_hd__decap_4
XFILLER_14_253 VGND VGND VPWR VPWR sky130_fd_sc_hd__fill_1
X_11725_ _04348_ _04445_ VGND VGND VPWR VPWR _04446_ sky130_fd_sc_hd__xnor2_1
XFILLER_9_69 VGND VGND VPWR VPWR sky130_fd_sc_hd__decap_8
XFILLER_14_286 VGND VGND VPWR VPWR sky130_fd_sc_hd__fill_2
XFILLER_30_757 VPWR VGND VPWR VGND sky130_ef_sc_hd__decap_12
X_11656_ _04254_ _04256_ _04369_ VGND VGND VPWR VPWR _04371_ sky130_fd_sc_hd__or3_1
XFILLER_127_111 VGND VGND VPWR VPWR sky130_fd_sc_hd__fill_1
X_11587_ _04294_ _04295_ VGND VGND VPWR VPWR _04296_ sky130_fd_sc_hd__and2b_1
XTAP_TAPCELL_ROW_12_476 VGND VPWR sky130_fd_sc_hd__tapvpwrvgnd_1
X_10607_ net485 net298 _03116_ _03115_ VGND VGND VPWR VPWR _03225_ sky130_fd_sc_hd__a31o_1
XFILLER_127_144 VPWR VGND VPWR VGND sky130_ef_sc_hd__decap_12
X_13326_ _06188_ _06189_ VGND VGND VPWR VPWR _06190_ sky130_fd_sc_hd__nor2_1
XTAP_TAPCELL_ROW_77_1415 VGND VPWR sky130_fd_sc_hd__tapvpwrvgnd_1
X_10538_ _03148_ _03149_ VGND VGND VPWR VPWR _03151_ sky130_fd_sc_hd__nand2_1
XFILLER_127_199 VPWR VGND VPWR VGND sky130_ef_sc_hd__decap_12
XFILLER_127_177 VGND VGND VPWR VPWR sky130_fd_sc_hd__decap_6
XFILLER_108_380 VPWR VGND VPWR VGND sky130_ef_sc_hd__decap_12
X_13257_ _06113_ _06114_ VGND VGND VPWR VPWR _06115_ sky130_fd_sc_hd__xnor2_1
XTAP_TAPCELL_ROW_90_1604 VGND VPWR sky130_fd_sc_hd__tapvpwrvgnd_1
X_12208_ _04797_ _04799_ _04967_ VGND VGND VPWR VPWR _04970_ sky130_fd_sc_hd__and3_1
X_10469_ _02835_ _02885_ _03073_ _03072_ VGND VGND VPWR VPWR _03076_ sky130_fd_sc_hd__a31o_1
X_13188_ net548 net408 VGND VGND VPWR VPWR _06040_ sky130_fd_sc_hd__nand2_1
XFILLER_69_415 VGND VGND VPWR VPWR sky130_fd_sc_hd__decap_4
X_12139_ _04712_ _04885_ _04894_ VGND VGND VPWR VPWR _04895_ sky130_fd_sc_hd__nand3_2
XFILLER_29_3 VPWR VGND VPWR VGND sky130_ef_sc_hd__decap_12
XFILLER_38_813 VGND VGND VPWR VPWR sky130_fd_sc_hd__decap_6
XTAP_TAPCELL_ROW_88_1577 VGND VPWR sky130_fd_sc_hd__tapvpwrvgnd_1
X_07680_ _00156_ _00157_ VGND VGND VPWR VPWR _00159_ sky130_fd_sc_hd__xor2_1
XFILLER_92_495 VPWR VGND VPWR VGND sky130_ef_sc_hd__decap_12
XFILLER_92_484 VGND VGND VPWR VPWR sky130_fd_sc_hd__fill_2
XFILLER_64_153 VPWR VGND VPWR VGND sky130_ef_sc_hd__decap_12
XFILLER_52_304 VGND VGND VPWR VPWR sky130_fd_sc_hd__decap_4
X_09350_ _01858_ _01859_ VGND VGND VPWR VPWR _01860_ sky130_fd_sc_hd__or2_1
XFILLER_64_197 VGND VGND VPWR VPWR sky130_fd_sc_hd__decap_8
X_09281_ net438 net431 net333 net335 VGND VGND VPWR VPWR _01784_ sky130_fd_sc_hd__and4_1
X_08301_ _00754_ _00774_ VGND VGND VPWR VPWR _00776_ sky130_fd_sc_hd__xnor2_1
X_08232_ net251 _00705_ VGND VGND VPWR VPWR _00707_ sky130_fd_sc_hd__xor2_1
XFILLER_33_595 VGND VGND VPWR VPWR sky130_fd_sc_hd__decap_3
XTAP_TAPCELL_ROW_119_2021 VGND VPWR sky130_fd_sc_hd__tapvpwrvgnd_1
XFILLER_20_234 VGND VGND VPWR VPWR sky130_fd_sc_hd__fill_1
XTAP_TAPCELL_ROW_31_752 VGND VPWR sky130_fd_sc_hd__tapvpwrvgnd_1
XFILLER_119_656 VGND VGND VPWR VPWR sky130_fd_sc_hd__decap_8
X_08163_ _00627_ _00637_ VGND VGND VPWR VPWR _00639_ sky130_fd_sc_hd__xnor2_1
XFILLER_20_289 VGND VGND VPWR VPWR sky130_fd_sc_hd__decap_4
XTAP_TAPCELL_ROW_132_2210 VGND VPWR sky130_fd_sc_hd__tapvpwrvgnd_1
XFILLER_109_15 VPWR VGND VPWR VGND sky130_ef_sc_hd__decap_12
X_07114_ net115 net494 VGND VGND VPWR VPWR _04580_ sky130_fd_sc_hd__nand2_1
X_08094_ _00564_ _00568_ _00569_ VGND VGND VPWR VPWR _00570_ sky130_fd_sc_hd__and3_1
XFILLER_133_125 VGND VGND VPWR VPWR sky130_fd_sc_hd__fill_1
XFILLER_106_328 VGND VGND VPWR VPWR sky130_fd_sc_hd__decap_4
XFILLER_69_19 VPWR VGND VPWR VGND sky130_ef_sc_hd__decap_12
X_07045_ _03303_ _03817_ VGND VGND VPWR VPWR _03828_ sky130_fd_sc_hd__or2_1
XFILLER_133_169 VPWR VGND VPWR VGND sky130_ef_sc_hd__decap_12
XFILLER_130_821 VGND VGND VPWR VPWR sky130_fd_sc_hd__decap_3
XFILLER_102_501 VGND VGND VPWR VPWR sky130_fd_sc_hd__decap_8
XFILLER_88_713 VGND VGND VPWR VPWR sky130_fd_sc_hd__decap_4
XFILLER_0_617 VGND VGND VPWR VPWR sky130_fd_sc_hd__decap_8
X_08996_ _01469_ _01472_ VGND VGND VPWR VPWR _01473_ sky130_fd_sc_hd__xnor2_1
XFILLER_102_545 VPWR VGND VPWR VGND sky130_ef_sc_hd__decap_12
XFILLER_88_757 VGND VGND VPWR VPWR sky130_fd_sc_hd__decap_8
XFILLER_125_69 VPWR VGND VPWR VGND sky130_ef_sc_hd__decap_12
X_07947_ _00423_ _00424_ VGND VGND VPWR VPWR _00425_ sky130_fd_sc_hd__or2_1
XTAP_TAPCELL_ROW_110_1895 VGND VPWR sky130_fd_sc_hd__tapvpwrvgnd_1
XFILLER_87_289 VGND VGND VPWR VPWR sky130_fd_sc_hd__fill_2
XFILLER_28_301 VGND VGND VPWR VPWR sky130_fd_sc_hd__decap_6
XFILLER_56_643 VGND VGND VPWR VPWR sky130_fd_sc_hd__fill_1
X_07878_ _00351_ _00354_ VGND VGND VPWR VPWR _00356_ sky130_fd_sc_hd__xnor2_1
XFILLER_44_805 VGND VGND VPWR VPWR sky130_fd_sc_hd__decap_6
XTAP_TAPCELL_ROW_39_863 VGND VPWR sky130_fd_sc_hd__tapvpwrvgnd_1
X_09617_ _02138_ _02149_ VGND VGND VPWR VPWR _02150_ sky130_fd_sc_hd__xor2_2
X_06829_ net467 net674 net655 net269 VGND VGND VPWR VPWR _01475_ sky130_fd_sc_hd__a22o_1
X_09548_ _01931_ _01945_ _01944_ VGND VGND VPWR VPWR _02075_ sky130_fd_sc_hd__o21ai_2
XFILLER_70_112 VGND VGND VPWR VPWR sky130_fd_sc_hd__decap_8
XFILLER_43_337 VGND VGND VPWR VPWR sky130_fd_sc_hd__fill_2
XFILLER_24_540 VGND VGND VPWR VPWR sky130_fd_sc_hd__fill_1
X_09479_ _01814_ _01831_ _01830_ VGND VGND VPWR VPWR _02000_ sky130_fd_sc_hd__a21bo_1
XFILLER_12_724 VGND VGND VPWR VPWR sky130_fd_sc_hd__fill_1
X_11510_ net483 net474 net288 net286 VGND VGND VPWR VPWR _04213_ sky130_fd_sc_hd__and4_1
XFILLER_34_77 VGND VGND VPWR VPWR sky130_fd_sc_hd__decap_6
XFILLER_133_3 VPWR VGND VPWR VGND sky130_ef_sc_hd__decap_12
X_12490_ net514 net397 net396 net523 VGND VGND VPWR VPWR _05278_ sky130_fd_sc_hd__a22o_1
XFILLER_8_728 VGND VGND VPWR VPWR sky130_fd_sc_hd__fill_1
XFILLER_12_757 VGND VGND VPWR VPWR sky130_fd_sc_hd__fill_1
X_11441_ _04126_ _04137_ VGND VGND VPWR VPWR _04138_ sky130_fd_sc_hd__xnor2_1
XFILLER_109_155 VGND VGND VPWR VPWR sky130_fd_sc_hd__decap_8
XFILLER_50_65 VPWR VGND VPWR VGND sky130_ef_sc_hd__decap_12
X_11372_ _04045_ _04061_ VGND VGND VPWR VPWR _04062_ sky130_fd_sc_hd__xnor2_1
XFILLER_125_637 VGND VGND VPWR VPWR sky130_fd_sc_hd__decap_4
X_13111_ net254 _05954_ VGND VGND VPWR VPWR _05956_ sky130_fd_sc_hd__xnor2_1
XTAP_TAPCELL_ROW_59_1156 VGND VPWR sky130_fd_sc_hd__tapvpwrvgnd_1
X_10323_ net569 net312 VGND VGND VPWR VPWR _02915_ sky130_fd_sc_hd__nand2_1
XFILLER_3_433 VGND VGND VPWR VPWR sky130_fd_sc_hd__decap_4
XFILLER_112_309 VGND VGND VPWR VPWR sky130_fd_sc_hd__decap_3
X_13042_ _05879_ _05880_ VGND VGND VPWR VPWR _05881_ sky130_fd_sc_hd__and2b_1
XFILLER_59_30 VPWR VGND VPWR VGND sky130_ef_sc_hd__decap_12
X_10254_ _02838_ _02839_ VGND VGND VPWR VPWR _02840_ sky130_fd_sc_hd__and2b_1
XFILLER_132_180 VPWR VGND VPWR VGND sky130_ef_sc_hd__decap_12
X_10185_ _02583_ _02767_ VGND VGND VPWR VPWR _02768_ sky130_fd_sc_hd__xnor2_1
XFILLER_79_746 VGND VGND VPWR VPWR sky130_fd_sc_hd__fill_1
XTAP_TAPCELL_ROW_72_1345 VGND VPWR sky130_fd_sc_hd__tapvpwrvgnd_1
XFILLER_66_407 VGND VGND VPWR VPWR sky130_fd_sc_hd__decap_8
XFILLER_38_109 VPWR VGND VPWR VGND sky130_ef_sc_hd__decap_12
XFILLER_93_215 VGND VGND VPWR VPWR sky130_fd_sc_hd__decap_8
XFILLER_66_429 VGND VGND VPWR VPWR sky130_fd_sc_hd__fill_1
Xfanout291 net86 VGND VGND VPWR VPWR net291 sky130_fd_sc_hd__buf_2
XFILLER_19_323 VPWR VGND VPWR VGND sky130_ef_sc_hd__decap_12
Xfanout280 net92 VGND VGND VPWR VPWR net280 sky130_fd_sc_hd__dlymetal6s2s_1
XFILLER_19_356 VGND VGND VPWR VPWR sky130_fd_sc_hd__decap_3
XFILLER_75_95 VGND VGND VPWR VPWR sky130_fd_sc_hd__decap_4
XFILLER_61_101 VGND VGND VPWR VPWR sky130_fd_sc_hd__decap_4
X_12826_ net389 net254 VGND VGND VPWR VPWR _05644_ sky130_fd_sc_hd__nor2_1
XFILLER_46_197 VGND VGND VPWR VPWR sky130_fd_sc_hd__fill_1
XTAP_TAPCELL_ROW_17_546 VGND VPWR sky130_fd_sc_hd__tapvpwrvgnd_1
XFILLER_50_819 VGND VGND VPWR VPWR sky130_fd_sc_hd__fill_1
X_12757_ _05566_ _05567_ VGND VGND VPWR VPWR _05569_ sky130_fd_sc_hd__and2_1
XTAP_TAPCELL_ROW_83_1496 VGND VPWR sky130_fd_sc_hd__tapvpwrvgnd_1
XFILLER_30_510 VPWR VGND VPWR VGND sky130_ef_sc_hd__decap_12
X_12688_ net420 net389 VGND VGND VPWR VPWR _05495_ sky130_fd_sc_hd__nand2_1
X_11708_ _04296_ _04303_ VGND VGND VPWR VPWR _04429_ sky130_fd_sc_hd__nor2_1
X_11639_ net316 net314 net602 net598 VGND VGND VPWR VPWR _04353_ sky130_fd_sc_hd__and4b_1
X_13309_ _06167_ _06168_ _06172_ VGND VGND VPWR VPWR _06173_ sky130_fd_sc_hd__nor3_1
XFILLER_7_783 VGND VGND VPWR VPWR sky130_fd_sc_hd__fill_1
XFILLER_6_282 VGND VGND VPWR VPWR sky130_fd_sc_hd__fill_1
XFILLER_131_629 VPWR VGND VPWR VGND sky130_ef_sc_hd__decap_12
XFILLER_112_821 VGND VGND VPWR VPWR sky130_fd_sc_hd__decap_3
XFILLER_103_309 VPWR VGND VPWR VGND sky130_ef_sc_hd__decap_12
X_08850_ net634 net624 net375 net36 VGND VGND VPWR VPWR _01316_ sky130_fd_sc_hd__and4_1
XFILLER_69_223 VGND VGND VPWR VPWR sky130_fd_sc_hd__fill_1
X_07801_ _06781_ _00128_ _00127_ VGND VGND VPWR VPWR _00280_ sky130_fd_sc_hd__a21bo_1
XFILLER_29_109 VGND VGND VPWR VPWR sky130_fd_sc_hd__decap_3
X_08781_ net557 net365 net44 net566 VGND VGND VPWR VPWR _01247_ sky130_fd_sc_hd__a22oi_1
XFILLER_84_204 VGND VGND VPWR VPWR sky130_fd_sc_hd__decap_8
XFILLER_38_610 VGND VGND VPWR VPWR sky130_fd_sc_hd__decap_6
XFILLER_84_248 VGND VGND VPWR VPWR sky130_fd_sc_hd__decap_4
X_07732_ _06633_ _00210_ VGND VGND VPWR VPWR _00211_ sky130_fd_sc_hd__xnor2_1
XFILLER_38_643 VGND VGND VPWR VPWR sky130_fd_sc_hd__fill_1
XFILLER_65_473 VPWR VGND VPWR VGND sky130_ef_sc_hd__decap_12
XFILLER_53_613 VGND VGND VPWR VPWR sky130_fd_sc_hd__decap_3
XFILLER_52_101 VPWR VGND VPWR VGND sky130_ef_sc_hd__decap_12
X_07663_ _00139_ _00140_ _00142_ VGND VGND VPWR VPWR _00143_ sky130_fd_sc_hd__or3_1
XFILLER_1_81 VPWR VGND VPWR VGND sky130_ef_sc_hd__decap_12
XFILLER_37_153 VGND VGND VPWR VPWR sky130_fd_sc_hd__fill_1
X_09402_ _01914_ _01915_ VGND VGND VPWR VPWR _01916_ sky130_fd_sc_hd__nand2b_1
XFILLER_80_421 VPWR VGND VPWR VGND sky130_ef_sc_hd__decap_12
XTAP_TAPCELL_ROW_36_822 VGND VPWR sky130_fd_sc_hd__tapvpwrvgnd_1
X_09333_ _01781_ _01839_ _01840_ VGND VGND VPWR VPWR _01841_ sky130_fd_sc_hd__nor3_1
X_07594_ _00072_ _00073_ VGND VGND VPWR VPWR _00074_ sky130_fd_sc_hd__xnor2_1
XFILLER_53_679 VGND VGND VPWR VPWR sky130_fd_sc_hd__fill_1
XFILLER_40_329 VGND VGND VPWR VPWR sky130_fd_sc_hd__decap_8
X_09264_ net339 net414 VGND VGND VPWR VPWR _01765_ sky130_fd_sc_hd__and2b_1
X_09195_ _01566_ _01568_ _01687_ VGND VGND VPWR VPWR _01689_ sky130_fd_sc_hd__and3_1
XFILLER_119_420 VGND VGND VPWR VPWR sky130_fd_sc_hd__decap_8
X_08215_ _00576_ _00590_ _00589_ VGND VGND VPWR VPWR _00690_ sky130_fd_sc_hd__o21ba_1
X_08146_ net610 _00516_ _00621_ VGND VGND VPWR VPWR _00622_ sky130_fd_sc_hd__a21boi_1
XFILLER_119_497 VGND VGND VPWR VPWR sky130_fd_sc_hd__decap_6
X_08077_ _00429_ _00553_ VGND VGND VPWR VPWR _00554_ sky130_fd_sc_hd__xor2_1
XTAP_TAPCELL_ROW_112_1924 VGND VPWR sky130_fd_sc_hd__tapvpwrvgnd_1
X_07028_ net467 net667 _03609_ _03620_ VGND VGND VPWR VPWR _03642_ sky130_fd_sc_hd__a22o_1
XFILLER_114_180 VPWR VGND VPWR VGND sky130_ef_sc_hd__decap_12
XFILLER_103_821 VGND VGND VPWR VPWR sky130_fd_sc_hd__decap_3
XFILLER_102_353 VGND VGND VPWR VPWR sky130_fd_sc_hd__decap_8
XTAP_TAPCELL_ROW_54_1086 VGND VPWR sky130_fd_sc_hd__tapvpwrvgnd_1
XTAP_TAPCELL_ROW_54_1075 VGND VPWR sky130_fd_sc_hd__tapvpwrvgnd_1
XFILLER_0_447 VGND VGND VPWR VPWR sky130_fd_sc_hd__fill_1
X_08979_ _01450_ _01451_ _01452_ VGND VGND VPWR VPWR _01455_ sky130_fd_sc_hd__a21o_1
XFILLER_88_587 VGND VGND VPWR VPWR sky130_fd_sc_hd__fill_1
XFILLER_29_55 VGND VGND VPWR VPWR sky130_fd_sc_hd__fill_1
X_11990_ _04723_ _04731_ VGND VGND VPWR VPWR _04732_ sky130_fd_sc_hd__nand2_1
XFILLER_29_643 VGND VGND VPWR VPWR sky130_fd_sc_hd__fill_1
X_10941_ _03540_ _03589_ VGND VGND VPWR VPWR _03591_ sky130_fd_sc_hd__xnor2_1
XFILLER_16_315 VGND VGND VPWR VPWR sky130_fd_sc_hd__fill_1
XFILLER_28_153 VPWR VGND VPWR VGND sky130_ef_sc_hd__decap_12
X_13660_ clknet_3_7__leaf_clk _00067_ net717 VGND VGND VPWR VPWR net195 sky130_fd_sc_hd__dfrtp_1
XFILLER_83_281 VPWR VGND VPWR VGND sky130_ef_sc_hd__decap_12
XFILLER_71_432 VGND VGND VPWR VPWR sky130_fd_sc_hd__fill_1
XFILLER_16_348 VGND VGND VPWR VPWR sky130_fd_sc_hd__fill_1
XFILLER_28_186 VGND VGND VPWR VPWR sky130_fd_sc_hd__decap_8
XFILLER_28_197 VPWR VGND VPWR VGND sky130_ef_sc_hd__decap_12
X_12611_ net556 net577 net501 net565 VGND VGND VPWR VPWR _05410_ sky130_fd_sc_hd__a22o_1
X_10872_ _03514_ _03515_ VGND VGND VPWR VPWR _03516_ sky130_fd_sc_hd__and2b_1
XFILLER_32_819 VGND VGND VPWR VPWR sky130_fd_sc_hd__fill_1
X_13591_ _06399_ _06402_ _06479_ VGND VGND VPWR VPWR _06480_ sky130_fd_sc_hd__and3_1
XTAP_TAPCELL_ROW_14_505 VGND VPWR sky130_fd_sc_hd__tapvpwrvgnd_1
XFILLER_101_93 VPWR VGND VPWR VGND sky130_ef_sc_hd__decap_12
X_12542_ _05171_ _05334_ VGND VGND VPWR VPWR _05335_ sky130_fd_sc_hd__nor2_1
XFILLER_61_42 VPWR VGND VPWR VGND sky130_ef_sc_hd__decap_12
X_12473_ _05255_ _05258_ VGND VGND VPWR VPWR _05259_ sky130_fd_sc_hd__xnor2_2
XFILLER_61_75 VGND VGND VPWR VPWR sky130_fd_sc_hd__decap_4
XFILLER_138_751 VGND VGND VPWR VPWR sky130_fd_sc_hd__fill_1
XFILLER_8_569 VGND VGND VPWR VPWR sky130_fd_sc_hd__decap_8
XFILLER_6_15 VPWR VGND VPWR VGND sky130_ef_sc_hd__decap_12
X_11424_ _04117_ _04118_ VGND VGND VPWR VPWR _04119_ sky130_fd_sc_hd__nor2_1
XANTENNA_8 net88 VGND VGND VPWR VPWR sky130_fd_sc_hd__diode_2
X_11355_ _04042_ _04041_ VGND VGND VPWR VPWR _04043_ sky130_fd_sc_hd__and2b_1
X_10306_ net293 _02861_ net527 net297 VGND VGND VPWR VPWR _02896_ sky130_fd_sc_hd__or4bb_1
X_11286_ _03953_ _03966_ VGND VGND VPWR VPWR _03968_ sky130_fd_sc_hd__xor2_1
X_13025_ _05859_ _05860_ VGND VGND VPWR VPWR _05862_ sky130_fd_sc_hd__xnor2_1
XFILLER_3_296 VPWR VGND VPWR VGND sky130_ef_sc_hd__decap_12
X_10237_ _02820_ _02821_ VGND VGND VPWR VPWR _02822_ sky130_fd_sc_hd__or2_1
X_10168_ _02747_ _02748_ VGND VGND VPWR VPWR _02751_ sky130_fd_sc_hd__nand2_1
XFILLER_121_673 VGND VGND VPWR VPWR sky130_fd_sc_hd__decap_8
XFILLER_94_513 VGND VGND VPWR VPWR sky130_fd_sc_hd__decap_8
XFILLER_86_83 VGND VGND VPWR VPWR sky130_fd_sc_hd__fill_1
XFILLER_67_727 VGND VGND VPWR VPWR sky130_fd_sc_hd__fill_1
XFILLER_66_215 VGND VGND VPWR VPWR sky130_fd_sc_hd__decap_8
X_10099_ _02673_ _02675_ VGND VGND VPWR VPWR _02676_ sky130_fd_sc_hd__and2b_1
XFILLER_94_557 VPWR VGND VPWR VGND sky130_ef_sc_hd__decap_12
XTAP_TAPCELL_ROW_85_1536 VGND VPWR sky130_fd_sc_hd__tapvpwrvgnd_1
XTAP_TAPCELL_ROW_85_1525 VGND VPWR sky130_fd_sc_hd__tapvpwrvgnd_1
XFILLER_50_605 VGND VGND VPWR VPWR sky130_fd_sc_hd__fill_2
XFILLER_96_3 VPWR VGND VPWR VGND sky130_ef_sc_hd__decap_12
X_12809_ net259 net402 VGND VGND VPWR VPWR _05626_ sky130_fd_sc_hd__nor2_1
X_08000_ _00474_ _00475_ VGND VGND VPWR VPWR _00477_ sky130_fd_sc_hd__xnor2_1
XTAP_TAPCELL_ROW_41_891 VGND VPWR sky130_fd_sc_hd__tapvpwrvgnd_1
XFILLER_116_412 VGND VGND VPWR VPWR sky130_fd_sc_hd__fill_1
Xmax_cap244 _02046_ VGND VGND VPWR VPWR net244 sky130_fd_sc_hd__clkbuf_1
XFILLER_116_456 VGND VGND VPWR VPWR sky130_fd_sc_hd__decap_6
XFILLER_116_445 VGND VGND VPWR VPWR sky130_fd_sc_hd__decap_4
XTAP_TAPCELL_ROW_96_1687 VGND VPWR sky130_fd_sc_hd__tapvpwrvgnd_1
Xmax_cap233 net234 VGND VGND VPWR VPWR net233 sky130_fd_sc_hd__clkbuf_1
X_09951_ net419 _02416_ _02513_ VGND VGND VPWR VPWR _02514_ sky130_fd_sc_hd__a21boi_4
XTAP_TAPCELL_ROW_96_1698 VGND VPWR sky130_fd_sc_hd__tapvpwrvgnd_1
X_08902_ net557 net363 net362 net567 VGND VGND VPWR VPWR _01370_ sky130_fd_sc_hd__a22oi_1
X_09882_ _02437_ _02438_ VGND VGND VPWR VPWR _02439_ sky130_fd_sc_hd__or2_1
XFILLER_97_362 VGND VGND VPWR VPWR sky130_fd_sc_hd__fill_2
XFILLER_97_340 VGND VGND VPWR VPWR sky130_fd_sc_hd__decap_3
XFILLER_112_684 VPWR VGND VPWR VGND sky130_ef_sc_hd__decap_12
XFILLER_111_161 VGND VGND VPWR VPWR sky130_fd_sc_hd__fill_2
X_08833_ net447 net337 VGND VGND VPWR VPWR _01299_ sky130_fd_sc_hd__nand2_1
XFILLER_100_813 VGND VGND VPWR VPWR sky130_fd_sc_hd__decap_6
XTAP_TAPCELL_ROW_127_2142 VGND VPWR sky130_fd_sc_hd__tapvpwrvgnd_1
X_08764_ _01221_ _01227_ _01048_ _01057_ VGND VGND VPWR VPWR _01231_ sky130_fd_sc_hd__o211ai_2
XFILLER_111_194 VPWR VGND VPWR VGND sky130_ef_sc_hd__decap_12
XFILLER_111_183 VGND VGND VPWR VPWR sky130_fd_sc_hd__decap_8
XFILLER_122_15 VPWR VGND VPWR VGND sky130_ef_sc_hd__decap_12
X_07715_ _00192_ _00193_ VGND VGND VPWR VPWR _00194_ sky130_fd_sc_hd__nand2b_1
X_08695_ _01160_ _01161_ VGND VGND VPWR VPWR _01162_ sky130_fd_sc_hd__or2_1
XFILLER_93_590 VPWR VGND VPWR VGND sky130_ef_sc_hd__decap_12
XFILLER_65_281 VGND VGND VPWR VPWR sky130_fd_sc_hd__decap_3
XFILLER_25_101 VGND VGND VPWR VPWR sky130_fd_sc_hd__decap_8
XFILLER_81_785 VGND VGND VPWR VPWR sky130_fd_sc_hd__decap_6
X_07646_ _00123_ _00124_ _06816_ VGND VGND VPWR VPWR _00126_ sky130_fd_sc_hd__a21o_1
XTAP_TAPCELL_ROW_0_288 VGND VPWR sky130_fd_sc_hd__tapvpwrvgnd_1
X_07577_ _06799_ _06805_ VGND VGND VPWR VPWR _06806_ sky130_fd_sc_hd__and2_1
XTAP_TAPCELL_ROW_0_299 VGND VPWR sky130_fd_sc_hd__tapvpwrvgnd_1
XFILLER_15_57 VPWR VGND VPWR VGND sky130_ef_sc_hd__decap_12
X_09316_ _01420_ _00104_ _01820_ _01821_ VGND VGND VPWR VPWR _01822_ sky130_fd_sc_hd__o31ai_1
X_09247_ net490 net481 net349 net348 VGND VGND VPWR VPWR _01746_ sky130_fd_sc_hd__and4_1
XTAP_TAPCELL_ROW_138_2293 VGND VPWR sky130_fd_sc_hd__tapvpwrvgnd_1
X_09178_ _01668_ _01669_ VGND VGND VPWR VPWR _01672_ sky130_fd_sc_hd__xor2_1
XFILLER_119_261 VPWR VGND VPWR VGND sky130_ef_sc_hd__decap_12
XFILLER_5_517 VGND VGND VPWR VPWR sky130_fd_sc_hd__fill_1
XFILLER_135_765 VPWR VGND VPWR VGND sky130_ef_sc_hd__decap_12
XTAP_TAPCELL_ROW_56_1104 VGND VPWR sky130_fd_sc_hd__tapvpwrvgnd_1
X_08129_ _00598_ _00603_ VGND VGND VPWR VPWR _00605_ sky130_fd_sc_hd__xnor2_1
XFILLER_31_78 VGND VGND VPWR VPWR sky130_fd_sc_hd__decap_8
XFILLER_134_275 VGND VGND VPWR VPWR sky130_fd_sc_hd__decap_6
XFILLER_134_253 VGND VGND VPWR VPWR sky130_fd_sc_hd__fill_1
XFILLER_134_242 VGND VGND VPWR VPWR sky130_fd_sc_hd__decap_8
XFILLER_107_489 VPWR VGND VPWR VGND sky130_ef_sc_hd__decap_12
XTAP_TAPCELL_ROW_56_1115 VGND VPWR sky130_fd_sc_hd__tapvpwrvgnd_1
X_11140_ _03638_ net271 _00231_ VGND VGND VPWR VPWR _03809_ sky130_fd_sc_hd__and3b_1
Xinput101 w30[3] VGND VGND VPWR VPWR net101 sky130_fd_sc_hd__buf_2
X_11071_ _03731_ _03732_ VGND VGND VPWR VPWR _03733_ sky130_fd_sc_hd__nor2_1
XFILLER_0_244 VGND VGND VPWR VPWR sky130_fd_sc_hd__decap_4
X_10022_ _02494_ _02589_ VGND VGND VPWR VPWR _02591_ sky130_fd_sc_hd__xor2_1
XFILLER_103_673 VPWR VGND VPWR VGND sky130_ef_sc_hd__decap_12
Xinput134 x0[4] VGND VGND VPWR VPWR net134 sky130_fd_sc_hd__buf_1
XFILLER_88_395 VGND VGND VPWR VPWR sky130_fd_sc_hd__decap_3
Xinput123 w33[1] VGND VGND VPWR VPWR net123 sky130_fd_sc_hd__buf_1
Xinput112 w31[6] VGND VGND VPWR VPWR net112 sky130_fd_sc_hd__clkbuf_2
Xinput145 x1[7] VGND VGND VPWR VPWR net145 sky130_fd_sc_hd__clkbuf_1
XFILLER_76_568 VGND VGND VPWR VPWR sky130_fd_sc_hd__decap_8
XFILLER_48_259 VGND VGND VPWR VPWR sky130_fd_sc_hd__decap_4
Xinput156 x3[2] VGND VGND VPWR VPWR net156 sky130_fd_sc_hd__clkbuf_2
XFILLER_91_505 VPWR VGND VPWR VGND sky130_ef_sc_hd__decap_12
XFILLER_56_53 VPWR VGND VPWR VGND sky130_ef_sc_hd__decap_12
X_11973_ _04710_ _04711_ VGND VGND VPWR VPWR _04713_ sky130_fd_sc_hd__xnor2_1
XPHY_EDGE_ROW_113_Right_113 VGND VGND VPWR VPWR sky130_fd_sc_hd__decap_3
XTAP_TAPCELL_ROW_67_1277 VGND VPWR sky130_fd_sc_hd__tapvpwrvgnd_1
XTAP_TAPCELL_ROW_67_1266 VGND VPWR sky130_fd_sc_hd__tapvpwrvgnd_1
X_10924_ net568 net302 VGND VGND VPWR VPWR _03572_ sky130_fd_sc_hd__nand2_1
X_13643_ clknet_3_4__leaf_clk _00039_ net716 VGND VGND VPWR VPWR net178 sky130_fd_sc_hd__dfrtp_1
XFILLER_72_41 VPWR VGND VPWR VGND sky130_ef_sc_hd__decap_12
XTAP_TAPCELL_ROW_27_685 VGND VPWR sky130_fd_sc_hd__tapvpwrvgnd_1
XTAP_TAPCELL_ROW_27_696 VGND VPWR sky130_fd_sc_hd__tapvpwrvgnd_1
X_10855_ _03493_ _03496_ VGND VGND VPWR VPWR _03497_ sky130_fd_sc_hd__xnor2_1
X_13574_ _06351_ _06353_ _06459_ VGND VGND VPWR VPWR _06461_ sky130_fd_sc_hd__nor3_1
XTAP_TAPCELL_ROW_80_1466 VGND VPWR sky130_fd_sc_hd__tapvpwrvgnd_1
XTAP_TAPCELL_ROW_80_1455 VGND VPWR sky130_fd_sc_hd__tapvpwrvgnd_1
X_12525_ net472 net379 VGND VGND VPWR VPWR _05316_ sky130_fd_sc_hd__nand2_4
X_10786_ net416 net281 VGND VGND VPWR VPWR _03421_ sky130_fd_sc_hd__nand2_1
XFILLER_138_581 VGND VGND VPWR VPWR sky130_fd_sc_hd__decap_3
X_12456_ net593 net409 _05238_ VGND VGND VPWR VPWR _05240_ sky130_fd_sc_hd__and3_1
XFILLER_126_754 VGND VGND VPWR VPWR sky130_fd_sc_hd__fill_2
X_12387_ _05143_ _05164_ VGND VGND VPWR VPWR _05165_ sky130_fd_sc_hd__xor2_1
X_11407_ _04067_ _04099_ VGND VGND VPWR VPWR _04100_ sky130_fd_sc_hd__and2b_1
X_11338_ _03914_ _03917_ _04022_ VGND VGND VPWR VPWR _04025_ sky130_fd_sc_hd__and3_1
XFILLER_98_126 VGND VGND VPWR VPWR sky130_fd_sc_hd__fill_2
X_11269_ _03920_ _03947_ VGND VGND VPWR VPWR _03950_ sky130_fd_sc_hd__xnor2_1
XFILLER_100_109 VPWR VGND VPWR VGND sky130_ef_sc_hd__decap_12
XFILLER_97_93 VGND VGND VPWR VPWR sky130_fd_sc_hd__decap_4
X_13008_ _05695_ _01464_ _00259_ VGND VGND VPWR VPWR _05844_ sky130_fd_sc_hd__or3b_2
XFILLER_121_481 VGND VGND VPWR VPWR sky130_fd_sc_hd__decap_6
XFILLER_67_535 VPWR VGND VPWR VGND sky130_ef_sc_hd__decap_12
XFILLER_11_3 VPWR VGND VPWR VGND sky130_ef_sc_hd__decap_12
XFILLER_39_248 VGND VGND VPWR VPWR sky130_fd_sc_hd__decap_8
XFILLER_39_237 VGND VGND VPWR VPWR sky130_fd_sc_hd__fill_1
XFILLER_94_354 VGND VGND VPWR VPWR sky130_fd_sc_hd__decap_8
XFILLER_82_527 VGND VGND VPWR VPWR sky130_fd_sc_hd__decap_4
XFILLER_82_549 VGND VGND VPWR VPWR sky130_fd_sc_hd__fill_2
X_07500_ _06728_ _06729_ VGND VGND VPWR VPWR _00051_ sky130_fd_sc_hd__xor2_1
XFILLER_48_793 VPWR VGND VPWR VGND sky130_ef_sc_hd__decap_12
XFILLER_47_281 VPWR VGND VPWR VGND sky130_ef_sc_hd__decap_12
XFILLER_62_251 VGND VGND VPWR VPWR sky130_fd_sc_hd__fill_1
XTAP_TAPCELL_ROW_46_961 VGND VPWR sky130_fd_sc_hd__tapvpwrvgnd_1
X_08480_ _00876_ _00878_ _00951_ VGND VGND VPWR VPWR _00953_ sky130_fd_sc_hd__and3_1
XTAP_TAPCELL_ROW_122_2072 VGND VPWR sky130_fd_sc_hd__tapvpwrvgnd_1
XTAP_TAPCELL_ROW_122_2061 VGND VPWR sky130_fd_sc_hd__tapvpwrvgnd_1
XFILLER_63_785 VGND VGND VPWR VPWR sky130_fd_sc_hd__decap_3
X_07431_ net469 net457 net664 net661 VGND VGND VPWR VPWR _06661_ sky130_fd_sc_hd__and4_1
XFILLER_50_424 VGND VGND VPWR VPWR sky130_fd_sc_hd__decap_8
XTAP_TAPCELL_ROW_46_972 VGND VPWR sky130_fd_sc_hd__tapvpwrvgnd_1
XFILLER_50_457 VPWR VGND VPWR VGND sky130_ef_sc_hd__decap_12
X_07362_ _05755_ _06591_ VGND VGND VPWR VPWR _06592_ sky130_fd_sc_hd__xnor2_1
X_09101_ _01583_ _01584_ VGND VGND VPWR VPWR _01587_ sky130_fd_sc_hd__xnor2_1
XFILLER_136_507 VGND VGND VPWR VPWR sky130_fd_sc_hd__fill_1
XTAP_TAPCELL_ROW_98_1727 VGND VPWR sky130_fd_sc_hd__tapvpwrvgnd_1
XTAP_TAPCELL_ROW_98_1716 VGND VPWR sky130_fd_sc_hd__tapvpwrvgnd_1
X_07293_ _05024_ _05046_ _05035_ VGND VGND VPWR VPWR _06524_ sky130_fd_sc_hd__o21ba_1
X_09032_ _01511_ _01512_ VGND VGND VPWR VPWR _01513_ sky130_fd_sc_hd__and2b_1
XFILLER_117_754 VGND VGND VPWR VPWR sky130_fd_sc_hd__fill_2
XFILLER_132_713 VGND VGND VPWR VPWR sky130_fd_sc_hd__fill_2
XFILLER_117_15 VPWR VGND VPWR VGND sky130_ef_sc_hd__decap_12
XFILLER_131_212 VPWR VGND VPWR VGND sky130_ef_sc_hd__decap_12
XFILLER_89_137 VGND VGND VPWR VPWR sky130_fd_sc_hd__decap_3
XFILLER_132_757 VPWR VGND VPWR VGND sky130_ef_sc_hd__decap_12
X_09934_ net262 net370 _02398_ _02401_ VGND VGND VPWR VPWR _02495_ sky130_fd_sc_hd__o31ai_2
XFILLER_98_660 VGND VGND VPWR VPWR sky130_fd_sc_hd__decap_3
X_09865_ _02412_ _02419_ VGND VGND VPWR VPWR _02421_ sky130_fd_sc_hd__xor2_1
XTAP_TAPCELL_ROW_51_1034 VGND VPWR sky130_fd_sc_hd__tapvpwrvgnd_1
X_08816_ _01280_ _01281_ VGND VGND VPWR VPWR _01282_ sky130_fd_sc_hd__and2b_1
XFILLER_100_632 VGND VGND VPWR VPWR sky130_fd_sc_hd__decap_8
XFILLER_97_181 VPWR VGND VPWR VGND sky130_ef_sc_hd__decap_12
XTAP_TAPCELL_ROW_51_1045 VGND VPWR sky130_fd_sc_hd__tapvpwrvgnd_1
XTAP_TAPCELL_ROW_5_369 VGND VPWR sky130_fd_sc_hd__tapvpwrvgnd_1
XFILLER_133_69 VPWR VGND VPWR VGND sky130_ef_sc_hd__decap_12
X_09796_ net250 _02343_ VGND VGND VPWR VPWR _02345_ sky130_fd_sc_hd__xnor2_1
XFILLER_85_354 VPWR VGND VPWR VGND sky130_ef_sc_hd__decap_12
XFILLER_73_505 VPWR VGND VPWR VGND sky130_ef_sc_hd__decap_12
X_08747_ _01210_ _01211_ _01142_ VGND VGND VPWR VPWR _01214_ sky130_fd_sc_hd__o21ai_2
XFILLER_100_698 VGND VGND VPWR VPWR sky130_fd_sc_hd__fill_2
XFILLER_26_421 VGND VGND VPWR VPWR sky130_fd_sc_hd__decap_4
X_08678_ net463 net455 net336 net335 VGND VGND VPWR VPWR _01145_ sky130_fd_sc_hd__and4_1
XTAP_TAPCELL_ROW_107_1856 VGND VPWR sky130_fd_sc_hd__tapvpwrvgnd_1
XTAP_TAPCELL_ROW_107_1845 VGND VPWR sky130_fd_sc_hd__tapvpwrvgnd_1
XFILLER_53_240 VPWR VGND VPWR VGND sky130_ef_sc_hd__decap_12
X_07629_ _00106_ _00107_ _00108_ VGND VGND VPWR VPWR _00109_ sky130_fd_sc_hd__nand3_1
XFILLER_14_616 VGND VGND VPWR VPWR sky130_fd_sc_hd__fill_1
X_10640_ _03258_ _03260_ _03261_ VGND VGND VPWR VPWR _03262_ sky130_fd_sc_hd__and3_1
XTAP_TAPCELL_ROW_24_644 VGND VPWR sky130_fd_sc_hd__tapvpwrvgnd_1
XFILLER_9_119 VGND VGND VPWR VPWR sky130_fd_sc_hd__fill_1
XFILLER_10_811 VGND VGND VPWR VPWR sky130_fd_sc_hd__fill_1
XTAP_TAPCELL_ROW_62_1196 VGND VPWR sky130_fd_sc_hd__tapvpwrvgnd_1
XFILLER_42_77 VGND VGND VPWR VPWR sky130_fd_sc_hd__decap_6
X_10571_ _03133_ _03184_ _03185_ VGND VGND VPWR VPWR _03187_ sky130_fd_sc_hd__or3_1
XFILLER_127_529 VPWR VGND VPWR VGND sky130_ef_sc_hd__decap_12
X_12310_ _05080_ _05079_ VGND VGND VPWR VPWR _05081_ sky130_fd_sc_hd__nand2b_1
X_13290_ _05933_ _06016_ _06015_ VGND VGND VPWR VPWR _06152_ sky130_fd_sc_hd__a21oi_2
X_12241_ _05003_ _05004_ _05001_ VGND VGND VPWR VPWR _05006_ sky130_fd_sc_hd__o21ai_1
XFILLER_135_573 VGND VGND VPWR VPWR sky130_fd_sc_hd__decap_8
XFILLER_135_540 VGND VGND VPWR VPWR sky130_fd_sc_hd__fill_1
XFILLER_123_735 VGND VGND VPWR VPWR sky130_fd_sc_hd__fill_1
X_12172_ _04734_ _04746_ VGND VGND VPWR VPWR _04931_ sky130_fd_sc_hd__nor2_1
XFILLER_123_779 VGND VGND VPWR VPWR sky130_fd_sc_hd__decap_4
XFILLER_3_27 VPWR VGND VPWR VGND sky130_ef_sc_hd__decap_12
X_11123_ _03783_ _03788_ VGND VGND VPWR VPWR _03790_ sky130_fd_sc_hd__xor2_1
XFILLER_110_407 VGND VGND VPWR VPWR sky130_fd_sc_hd__fill_2
XFILLER_107_81 VPWR VGND VPWR VGND sky130_ef_sc_hd__decap_12
XFILLER_89_693 VGND VGND VPWR VPWR sky130_fd_sc_hd__fill_2
XFILLER_89_671 VGND VGND VPWR VPWR sky130_fd_sc_hd__fill_1
X_11054_ _03546_ _03564_ _03563_ VGND VGND VPWR VPWR _03714_ sky130_fd_sc_hd__o21a_1
X_10005_ _02571_ _02572_ VGND VGND VPWR VPWR _02573_ sky130_fd_sc_hd__and2b_1
XFILLER_103_492 VPWR VGND VPWR VGND sky130_ef_sc_hd__decap_12
XFILLER_76_332 VGND VGND VPWR VPWR sky130_fd_sc_hd__decap_4
XFILLER_49_557 VGND VGND VPWR VPWR sky130_fd_sc_hd__decap_3
XFILLER_76_365 VGND VGND VPWR VPWR sky130_fd_sc_hd__decap_3
XTAP_TAPCELL_ROW_69_1306 VGND VPWR sky130_fd_sc_hd__tapvpwrvgnd_1
XFILLER_17_410 VGND VGND VPWR VPWR sky130_fd_sc_hd__fill_2
XFILLER_29_281 VPWR VGND VPWR VGND sky130_ef_sc_hd__decap_12
X_11956_ net593 net583 net711 net695 VGND VGND VPWR VPWR _04695_ sky130_fd_sc_hd__and4_1
XFILLER_83_51 VGND VGND VPWR VPWR sky130_fd_sc_hd__decap_4
XFILLER_45_741 VGND VGND VPWR VPWR sky130_fd_sc_hd__fill_1
XFILLER_60_733 VGND VGND VPWR VPWR sky130_fd_sc_hd__fill_2
XFILLER_60_711 VGND VGND VPWR VPWR sky130_fd_sc_hd__fill_1
XFILLER_45_785 VPWR VGND VPWR VGND sky130_ef_sc_hd__decap_12
XTAP_TAPCELL_ROW_43_920 VGND VPWR sky130_fd_sc_hd__tapvpwrvgnd_1
X_10907_ net546 net308 VGND VGND VPWR VPWR _03553_ sky130_fd_sc_hd__nand2_1
XFILLER_17_465 VGND VGND VPWR VPWR sky130_fd_sc_hd__fill_1
XFILLER_60_755 VGND VGND VPWR VPWR sky130_fd_sc_hd__fill_1
X_11887_ _04431_ _04614_ _04612_ VGND VGND VPWR VPWR _04622_ sky130_fd_sc_hd__a21bo_1
X_13626_ _06514_ _06516_ VGND VGND VPWR VPWR _06517_ sky130_fd_sc_hd__xnor2_1
XFILLER_13_671 VGND VGND VPWR VPWR sky130_fd_sc_hd__fill_1
X_10838_ net611 net325 _03313_ _03312_ VGND VGND VPWR VPWR _03479_ sky130_fd_sc_hd__a31o_1
X_13557_ _06381_ _06383_ VGND VGND VPWR VPWR _06442_ sky130_fd_sc_hd__nand2b_1
X_10769_ _03400_ _03402_ VGND VGND VPWR VPWR _03403_ sky130_fd_sc_hd__nand2_1
XFILLER_118_529 VGND VGND VPWR VPWR sky130_fd_sc_hd__decap_3
X_13488_ _06365_ _06366_ VGND VGND VPWR VPWR _06368_ sky130_fd_sc_hd__or2_1
X_12508_ net430 net389 _05295_ _05296_ VGND VGND VPWR VPWR _05298_ sky130_fd_sc_hd__a22o_1
XFILLER_8_141 VGND VGND VPWR VPWR sky130_fd_sc_hd__fill_1
X_12439_ _04948_ _05085_ _05221_ VGND VGND VPWR VPWR _05222_ sky130_fd_sc_hd__or3_1
XFILLER_126_562 VGND VGND VPWR VPWR sky130_fd_sc_hd__decap_4
XFILLER_126_573 VGND VGND VPWR VPWR sky130_fd_sc_hd__fill_2
XFILLER_113_223 VGND VGND VPWR VPWR sky130_fd_sc_hd__fill_1
XTAP_TAPCELL_ROW_93_1646 VGND VPWR sky130_fd_sc_hd__tapvpwrvgnd_1
XFILLER_114_757 VPWR VGND VPWR VGND sky130_ef_sc_hd__decap_12
X_07980_ _00319_ _00455_ VGND VGND VPWR VPWR _00457_ sky130_fd_sc_hd__xnor2_1
XFILLER_4_380 VPWR VGND VPWR VGND sky130_ef_sc_hd__decap_12
XFILLER_86_107 VGND VGND VPWR VPWR sky130_fd_sc_hd__decap_8
XFILLER_68_811 VGND VGND VPWR VPWR sky130_fd_sc_hd__fill_1
X_06931_ net703 net701 net562 net554 VGND VGND VPWR VPWR _02586_ sky130_fd_sc_hd__and4_1
X_09650_ _02053_ _02068_ _02067_ VGND VGND VPWR VPWR _02186_ sky130_fd_sc_hd__o21a_1
X_08601_ _01067_ _01068_ VGND VGND VPWR VPWR _01069_ sky130_fd_sc_hd__nand2_1
XTAP_TAPCELL_ROW_124_2101 VGND VPWR sky130_fd_sc_hd__tapvpwrvgnd_1
XTAP_TAPCELL_ROW_2_328 VGND VPWR sky130_fd_sc_hd__tapvpwrvgnd_1
X_06862_ net589 net701 net580 net703 VGND VGND VPWR VPWR _01835_ sky130_fd_sc_hd__a22oi_1
X_09581_ net438 net429 net331 net330 VGND VGND VPWR VPWR _02111_ sky130_fd_sc_hd__and4_1
XFILLER_103_39 VPWR VGND VPWR VGND sky130_ef_sc_hd__decap_12
XFILLER_94_195 VGND VGND VPWR VPWR sky130_fd_sc_hd__fill_1
XFILLER_82_324 VGND VGND VPWR VPWR sky130_fd_sc_hd__decap_4
XFILLER_67_387 VGND VGND VPWR VPWR sky130_fd_sc_hd__decap_4
X_08532_ _00998_ _00999_ _01000_ VGND VGND VPWR VPWR _01002_ sky130_fd_sc_hd__o21a_1
X_08463_ _00866_ _00869_ _00935_ VGND VGND VPWR VPWR _00936_ sky130_fd_sc_hd__o21ba_1
XFILLER_63_593 VGND VGND VPWR VPWR sky130_fd_sc_hd__decap_8
X_07414_ net670 net427 _06641_ _06642_ VGND VGND VPWR VPWR _06644_ sky130_fd_sc_hd__nand4_1
XFILLER_51_744 VPWR VGND VPWR VGND sky130_ef_sc_hd__decap_12
XFILLER_23_424 VGND VGND VPWR VPWR sky130_fd_sc_hd__fill_1
XFILLER_50_265 VGND VGND VPWR VPWR sky130_fd_sc_hd__decap_8
X_08394_ _00866_ _00867_ VGND VGND VPWR VPWR _00868_ sky130_fd_sc_hd__or2_1
XFILLER_11_608 VGND VGND VPWR VPWR sky130_fd_sc_hd__decap_8
XTAP_TAPCELL_ROW_21_603 VGND VPWR sky130_fd_sc_hd__tapvpwrvgnd_1
XTAP_TAPCELL_ROW_102_1775 VGND VPWR sky130_fd_sc_hd__tapvpwrvgnd_1
X_07345_ _05712_ _06573_ VGND VGND VPWR VPWR _06575_ sky130_fd_sc_hd__xnor2_1
X_07276_ _06323_ _06334_ VGND VGND VPWR VPWR _06345_ sky130_fd_sc_hd__and2b_1
XTAP_TAPCELL_ROW_135_2263 VGND VPWR sky130_fd_sc_hd__tapvpwrvgnd_1
XTAP_TAPCELL_ROW_135_2252 VGND VPWR sky130_fd_sc_hd__tapvpwrvgnd_1
X_09015_ _01491_ _01492_ _01461_ VGND VGND VPWR VPWR _01494_ sky130_fd_sc_hd__a21o_1
XFILLER_117_551 VGND VGND VPWR VPWR sky130_fd_sc_hd__fill_2
XFILLER_132_521 VGND VGND VPWR VPWR sky130_fd_sc_hd__fill_2
XFILLER_88_29 VPWR VGND VPWR VGND sky130_ef_sc_hd__decap_12
X_09917_ _01726_ _01893_ _02475_ VGND VGND VPWR VPWR _02476_ sky130_fd_sc_hd__or3_1
Xfanout621 net626 VGND VGND VPWR VPWR net621 sky130_fd_sc_hd__clkbuf_2
Xfanout610 net612 VGND VGND VPWR VPWR net610 sky130_fd_sc_hd__buf_2
Xfanout632 net635 VGND VGND VPWR VPWR net632 sky130_fd_sc_hd__buf_2
XFILLER_59_800 VPWR VGND VPWR VGND sky130_ef_sc_hd__decap_12
Xfanout665 net666 VGND VGND VPWR VPWR net665 sky130_fd_sc_hd__buf_2
Xfanout676 net121 VGND VGND VPWR VPWR net676 sky130_fd_sc_hd__clkbuf_2
Xfanout654 net655 VGND VGND VPWR VPWR net654 sky130_fd_sc_hd__clkbuf_4
Xfanout643 net649 VGND VGND VPWR VPWR net643 sky130_fd_sc_hd__buf_2
X_09848_ _01610_ _02400_ VGND VGND VPWR VPWR _02403_ sky130_fd_sc_hd__xnor2_1
XFILLER_86_663 VGND VGND VPWR VPWR sky130_fd_sc_hd__decap_6
XFILLER_58_365 VPWR VGND VPWR VGND sky130_ef_sc_hd__decap_12
Xfanout687 net115 VGND VGND VPWR VPWR net687 sky130_fd_sc_hd__buf_2
Xfanout698 net109 VGND VGND VPWR VPWR net698 sky130_fd_sc_hd__clkbuf_2
X_09779_ net357 net356 net540 net534 VGND VGND VPWR VPWR _02327_ sky130_fd_sc_hd__and4b_1
XFILLER_58_398 VPWR VGND VPWR VGND sky130_ef_sc_hd__decap_12
XTAP_TAPCELL_ROW_29_714 VGND VPWR sky130_fd_sc_hd__tapvpwrvgnd_1
XTAP_TAPCELL_ROW_29_725 VGND VPWR sky130_fd_sc_hd__tapvpwrvgnd_1
XFILLER_37_55 VGND VGND VPWR VPWR sky130_fd_sc_hd__fill_1
XFILLER_39_590 VPWR VGND VPWR VGND sky130_ef_sc_hd__decap_12
X_12790_ _05599_ _05604_ VGND VGND VPWR VPWR _05605_ sky130_fd_sc_hd__and2b_1
X_11810_ _04538_ _04539_ VGND VGND VPWR VPWR _04540_ sky130_fd_sc_hd__nor2_1
X_11741_ _04462_ _04463_ VGND VGND VPWR VPWR _04464_ sky130_fd_sc_hd__nor2_1
XFILLER_26_251 VGND VGND VPWR VPWR sky130_fd_sc_hd__fill_1
XFILLER_26_273 VGND VGND VPWR VPWR sky130_fd_sc_hd__fill_2
XFILLER_27_785 VPWR VGND VPWR VGND sky130_ef_sc_hd__decap_12
XTAP_TAPCELL_ROW_64_1225 VGND VPWR sky130_fd_sc_hd__tapvpwrvgnd_1
XFILLER_42_755 VGND VGND VPWR VPWR sky130_fd_sc_hd__fill_1
XFILLER_41_221 VGND VGND VPWR VPWR sky130_fd_sc_hd__decap_3
X_11672_ _04212_ _04387_ VGND VGND VPWR VPWR _04389_ sky130_fd_sc_hd__nor2_1
XFILLER_128_805 VGND VGND VPWR VPWR sky130_fd_sc_hd__decap_6
X_13411_ _06213_ _06283_ VGND VGND VPWR VPWR _06284_ sky130_fd_sc_hd__xnor2_1
X_10623_ _03241_ _03242_ VGND VGND VPWR VPWR _03243_ sky130_fd_sc_hd__or2_1
X_13342_ _06191_ _06207_ VGND VGND VPWR VPWR _06208_ sky130_fd_sc_hd__xnor2_1
XFILLER_6_601 VGND VGND VPWR VPWR sky130_fd_sc_hd__decap_4
X_10554_ _03164_ _03165_ _03166_ VGND VGND VPWR VPWR _03168_ sky130_fd_sc_hd__a21o_1
XFILLER_127_348 VPWR VGND VPWR VGND sky130_ef_sc_hd__decap_12
XFILLER_6_645 VGND VGND VPWR VPWR sky130_fd_sc_hd__fill_1
XFILLER_5_111 VGND VGND VPWR VPWR sky130_fd_sc_hd__fill_1
X_13273_ _06131_ _06132_ VGND VGND VPWR VPWR _06133_ sky130_fd_sc_hd__xor2_1
X_10485_ _02908_ _02911_ VGND VGND VPWR VPWR _03092_ sky130_fd_sc_hd__nor2_1
XFILLER_5_133 VPWR VGND VPWR VGND sky130_ef_sc_hd__decap_12
X_12224_ _04984_ _04986_ VGND VGND VPWR VPWR _04987_ sky130_fd_sc_hd__nor2_1
XFILLER_5_166 VGND VGND VPWR VPWR sky130_fd_sc_hd__fill_2
X_12155_ _04908_ _04911_ _04910_ VGND VGND VPWR VPWR _04912_ sky130_fd_sc_hd__nor3b_2
XTAP_TAPCELL_ROW_75_1387 VGND VPWR sky130_fd_sc_hd__tapvpwrvgnd_1
XFILLER_5_199 VGND VGND VPWR VPWR sky130_fd_sc_hd__decap_3
X_11106_ net510 net502 net289 net287 VGND VGND VPWR VPWR _03771_ sky130_fd_sc_hd__and4_1
XFILLER_77_641 VGND VGND VPWR VPWR sky130_fd_sc_hd__decap_4
X_12086_ _04833_ _04835_ VGND VGND VPWR VPWR _04836_ sky130_fd_sc_hd__and2b_1
X_11037_ _03516_ _03518_ _03694_ _03695_ VGND VGND VPWR VPWR _03696_ sky130_fd_sc_hd__o211ai_2
XFILLER_37_505 VGND VGND VPWR VPWR sky130_fd_sc_hd__decap_4
XFILLER_92_622 VGND VGND VPWR VPWR sky130_fd_sc_hd__decap_3
XFILLER_64_302 VGND VGND VPWR VPWR sky130_fd_sc_hd__decap_6
XFILLER_94_83 VGND VGND VPWR VPWR sky130_fd_sc_hd__fill_1
XFILLER_92_666 VPWR VGND VPWR VGND sky130_ef_sc_hd__decap_12
XFILLER_91_132 VGND VGND VPWR VPWR sky130_fd_sc_hd__decap_6
XFILLER_92_699 VGND VGND VPWR VPWR sky130_fd_sc_hd__fill_1
XFILLER_91_187 VGND VGND VPWR VPWR sky130_fd_sc_hd__fill_1
XFILLER_91_165 VGND VGND VPWR VPWR sky130_fd_sc_hd__decap_3
X_12988_ _05820_ VGND VGND VPWR VPWR _05822_ sky130_fd_sc_hd__inv_2
XFILLER_45_582 VGND VGND VPWR VPWR sky130_fd_sc_hd__fill_2
XFILLER_17_240 VGND VGND VPWR VPWR sky130_fd_sc_hd__decap_8
XFILLER_33_711 VGND VGND VPWR VPWR sky130_fd_sc_hd__decap_8
X_11939_ _04673_ _04674_ VGND VGND VPWR VPWR _04677_ sky130_fd_sc_hd__xor2_1
XFILLER_60_563 VGND VGND VPWR VPWR sky130_fd_sc_hd__fill_1
XFILLER_32_265 VGND VGND VPWR VPWR sky130_fd_sc_hd__decap_3
X_13609_ _06496_ _06498_ VGND VGND VPWR VPWR _06499_ sky130_fd_sc_hd__xnor2_1
XFILLER_60_596 VGND VGND VPWR VPWR sky130_fd_sc_hd__fill_2
XFILLER_32_298 VGND VGND VPWR VPWR sky130_fd_sc_hd__decap_8
X_07130_ _04718_ _04740_ VGND VGND VPWR VPWR _04751_ sky130_fd_sc_hd__xnor2_1
XFILLER_9_461 VGND VGND VPWR VPWR sky130_fd_sc_hd__decap_6
X_07061_ _03893_ _03904_ _03937_ _03970_ VGND VGND VPWR VPWR _04003_ sky130_fd_sc_hd__a211o_1
Xoutput213 net213 VGND VGND VPWR VPWR y3[0] sky130_fd_sc_hd__buf_2
Xoutput224 net224 VGND VGND VPWR VPWR y3[4] sky130_fd_sc_hd__buf_2
Xoutput202 net202 VGND VGND VPWR VPWR y2[15] sky130_fd_sc_hd__buf_2
XFILLER_114_543 VPWR VGND VPWR VGND sky130_ef_sc_hd__decap_12
XTAP_TAPCELL_ROW_130_2182 VGND VPWR sky130_fd_sc_hd__tapvpwrvgnd_1
XFILLER_114_587 VGND VGND VPWR VPWR sky130_fd_sc_hd__fill_1
XFILLER_102_738 VPWR VGND VPWR VGND sky130_ef_sc_hd__decap_12
XFILLER_101_248 VPWR VGND VPWR VGND sky130_ef_sc_hd__decap_12
XFILLER_101_237 VGND VGND VPWR VPWR sky130_fd_sc_hd__fill_1
XFILLER_87_449 VPWR VGND VPWR VGND sky130_ef_sc_hd__decap_12
XFILLER_68_630 VPWR VGND VPWR VGND sky130_ef_sc_hd__decap_12
X_07963_ net691 net545 _00301_ _00300_ VGND VGND VPWR VPWR _00440_ sky130_fd_sc_hd__a31o_1
X_09702_ net333 net255 VGND VGND VPWR VPWR _02243_ sky130_fd_sc_hd__nor2_1
XFILLER_114_27 VGND VGND VPWR VPWR sky130_fd_sc_hd__fill_1
X_06914_ _02380_ _02391_ _01900_ VGND VGND VPWR VPWR _02402_ sky130_fd_sc_hd__or3b_2
X_07894_ _00232_ _00234_ _00075_ VGND VGND VPWR VPWR _00372_ sky130_fd_sc_hd__o21bai_1
X_09633_ _02031_ _02167_ VGND VGND VPWR VPWR _02168_ sky130_fd_sc_hd__xnor2_1
XFILLER_110_793 VPWR VGND VPWR VGND sky130_ef_sc_hd__decap_12
X_06845_ _01627_ _01638_ VGND VGND VPWR VPWR _01649_ sky130_fd_sc_hd__or2_1
X_09564_ net335 net413 VGND VGND VPWR VPWR _02092_ sky130_fd_sc_hd__and2b_1
XFILLER_55_335 VGND VGND VPWR VPWR sky130_fd_sc_hd__fill_1
XFILLER_130_15 VPWR VGND VPWR VGND sky130_ef_sc_hd__decap_12
XTAP_TAPCELL_ROW_104_1804 VGND VPWR sky130_fd_sc_hd__tapvpwrvgnd_1
XFILLER_82_176 VGND VGND VPWR VPWR sky130_fd_sc_hd__fill_2
X_08515_ _00983_ _00986_ VGND VGND VPWR VPWR _00987_ sky130_fd_sc_hd__xnor2_1
X_09495_ _01690_ _01849_ _01848_ VGND VGND VPWR VPWR _02017_ sky130_fd_sc_hd__a21bo_1
XFILLER_36_582 VGND VGND VPWR VPWR sky130_fd_sc_hd__decap_6
X_08446_ _00910_ _00917_ VGND VGND VPWR VPWR _00919_ sky130_fd_sc_hd__xnor2_1
XFILLER_11_405 VPWR VGND VPWR VGND sky130_ef_sc_hd__decap_12
X_08377_ _00701_ _00716_ _00714_ VGND VGND VPWR VPWR _00851_ sky130_fd_sc_hd__o21ai_2
XFILLER_23_298 VPWR VGND VPWR VGND sky130_ef_sc_hd__decap_12
XTAP_TAPCELL_ROW_34_794 VGND VPWR sky130_fd_sc_hd__tapvpwrvgnd_1
X_07328_ _06556_ _06557_ _05308_ _05330_ VGND VGND VPWR VPWR _06559_ sky130_fd_sc_hd__a211oi_2
XFILLER_7_409 VGND VGND VPWR VPWR sky130_fd_sc_hd__fill_1
XFILLER_23_57 VGND VGND VPWR VPWR sky130_fd_sc_hd__decap_4
XFILLER_137_657 VPWR VGND VPWR VGND sky130_ef_sc_hd__decap_12
XFILLER_109_337 VGND VGND VPWR VPWR sky130_fd_sc_hd__fill_1
XFILLER_124_307 VGND VGND VPWR VPWR sky130_fd_sc_hd__fill_1
X_07259_ net526 net519 net119 net677 VGND VGND VPWR VPWR _06160_ sky130_fd_sc_hd__nand4_1
XFILLER_3_615 VGND VGND VPWR VPWR sky130_fd_sc_hd__fill_1
X_10270_ net511 net298 VGND VGND VPWR VPWR _02858_ sky130_fd_sc_hd__nand2_1
XTAP_TAPCELL_ROW_115_1966 VGND VPWR sky130_fd_sc_hd__tapvpwrvgnd_1
XFILLER_105_554 VGND VGND VPWR VPWR sky130_fd_sc_hd__fill_1
XFILLER_105_543 VGND VGND VPWR VPWR sky130_fd_sc_hd__decap_4
XFILLER_132_373 VPWR VGND VPWR VGND sky130_ef_sc_hd__decap_12
XFILLER_105_565 VGND VGND VPWR VPWR sky130_fd_sc_hd__fill_1
Xfanout440 net441 VGND VGND VPWR VPWR net440 sky130_fd_sc_hd__clkbuf_4
Xfanout462 net464 VGND VGND VPWR VPWR net462 sky130_fd_sc_hd__buf_2
Xfanout451 net452 VGND VGND VPWR VPWR net451 sky130_fd_sc_hd__buf_2
Xfanout484 net486 VGND VGND VPWR VPWR net484 sky130_fd_sc_hd__buf_2
XFILLER_48_65 VPWR VGND VPWR VGND sky130_ef_sc_hd__decap_12
XFILLER_19_505 VGND VGND VPWR VPWR sky130_fd_sc_hd__decap_6
Xfanout473 net154 VGND VGND VPWR VPWR net473 sky130_fd_sc_hd__clkbuf_4
X_12911_ _05735_ _05736_ VGND VGND VPWR VPWR _05737_ sky130_fd_sc_hd__nor2_1
Xfanout495 net498 VGND VGND VPWR VPWR net495 sky130_fd_sc_hd__clkbuf_4
XFILLER_74_633 VGND VGND VPWR VPWR sky130_fd_sc_hd__decap_8
XFILLER_58_195 VGND VGND VPWR VPWR sky130_fd_sc_hd__fill_1
XFILLER_104_93 VGND VGND VPWR VPWR sky130_fd_sc_hd__fill_2
X_12842_ net437 net428 net384 net383 VGND VGND VPWR VPWR _05662_ sky130_fd_sc_hd__and4_1
XFILLER_74_699 VGND VGND VPWR VPWR sky130_fd_sc_hd__fill_1
XFILLER_74_688 VGND VGND VPWR VPWR sky130_fd_sc_hd__fill_2
XFILLER_73_165 VGND VGND VPWR VPWR sky130_fd_sc_hd__decap_3
XFILLER_64_53 VPWR VGND VPWR VGND sky130_ef_sc_hd__decap_12
XFILLER_46_379 VGND VGND VPWR VPWR sky130_fd_sc_hd__decap_8
X_12773_ _05583_ _05584_ VGND VGND VPWR VPWR _05586_ sky130_fd_sc_hd__nor2_1
XFILLER_54_390 VGND VGND VPWR VPWR sky130_fd_sc_hd__decap_8
XFILLER_14_210 VGND VGND VPWR VPWR sky130_fd_sc_hd__decap_3
XFILLER_9_15 VPWR VGND VPWR VGND sky130_ef_sc_hd__decap_12
XFILLER_14_243 VGND VGND VPWR VPWR sky130_fd_sc_hd__fill_1
XFILLER_14_265 VGND VGND VPWR VPWR sky130_fd_sc_hd__fill_2
X_11724_ _04434_ _04443_ VGND VGND VPWR VPWR _04445_ sky130_fd_sc_hd__xnor2_1
XFILLER_80_41 VPWR VGND VPWR VGND sky130_ef_sc_hd__decap_12
X_11655_ _04254_ _04256_ _04369_ VGND VGND VPWR VPWR _04370_ sky130_fd_sc_hd__o21ai_1
XFILLER_30_769 VPWR VGND VPWR VGND sky130_ef_sc_hd__decap_12
X_10606_ _03222_ _03223_ VGND VGND VPWR VPWR _03224_ sky130_fd_sc_hd__or2_1
X_11586_ _03875_ _04159_ _04158_ VGND VGND VPWR VPWR _04295_ sky130_fd_sc_hd__a21o_1
XTAP_TAPCELL_ROW_12_466 VGND VPWR sky130_fd_sc_hd__tapvpwrvgnd_1
XTAP_TAPCELL_ROW_12_477 VGND VPWR sky130_fd_sc_hd__tapvpwrvgnd_1
XFILLER_127_156 VGND VGND VPWR VPWR sky130_fd_sc_hd__decap_8
XFILLER_116_819 VGND VGND VPWR VPWR sky130_fd_sc_hd__fill_1
X_13325_ _06186_ _06187_ VGND VGND VPWR VPWR _06189_ sky130_fd_sc_hd__and2_1
XTAP_TAPCELL_ROW_77_1416 VGND VPWR sky130_fd_sc_hd__tapvpwrvgnd_1
X_10537_ _02973_ _02976_ _03147_ VGND VGND VPWR VPWR _03149_ sky130_fd_sc_hd__nand3_1
X_13256_ net320 net601 VGND VGND VPWR VPWR _06114_ sky130_fd_sc_hd__and2b_1
X_10468_ _03072_ _03073_ VGND VGND VPWR VPWR _03075_ sky130_fd_sc_hd__nand2b_1
XFILLER_108_392 VGND VGND VPWR VPWR sky130_fd_sc_hd__decap_6
XTAP_TAPCELL_ROW_90_1605 VGND VPWR sky130_fd_sc_hd__tapvpwrvgnd_1
X_12207_ _04797_ _04799_ _04967_ VGND VGND VPWR VPWR _04968_ sky130_fd_sc_hd__a21oi_2
X_13187_ _06036_ _06037_ VGND VGND VPWR VPWR _06038_ sky130_fd_sc_hd__nor2_1
X_10399_ _02990_ _02991_ _02996_ VGND VGND VPWR VPWR _02999_ sky130_fd_sc_hd__a21o_1
X_12138_ _04881_ _04884_ _04883_ VGND VGND VPWR VPWR _04894_ sky130_fd_sc_hd__a21o_1
XFILLER_69_449 VPWR VGND VPWR VGND sky130_ef_sc_hd__decap_12
XFILLER_96_268 VPWR VGND VPWR VGND sky130_ef_sc_hd__decap_12
X_12069_ _04759_ _04815_ _04817_ VGND VGND VPWR VPWR _04818_ sky130_fd_sc_hd__a21o_1
XFILLER_1_191 VGND VGND VPWR VPWR sky130_fd_sc_hd__decap_4
XFILLER_38_803 VGND VGND VPWR VPWR sky130_fd_sc_hd__decap_8
XFILLER_37_313 VGND VGND VPWR VPWR sky130_fd_sc_hd__decap_8
XTAP_TAPCELL_ROW_88_1578 VGND VPWR sky130_fd_sc_hd__tapvpwrvgnd_1
XFILLER_64_165 VGND VGND VPWR VPWR sky130_fd_sc_hd__decap_8
XFILLER_53_817 VGND VGND VPWR VPWR sky130_fd_sc_hd__decap_3
XFILLER_25_508 VPWR VGND VPWR VGND sky130_ef_sc_hd__decap_12
X_09280_ _01465_ _01640_ _01639_ VGND VGND VPWR VPWR _01783_ sky130_fd_sc_hd__a21o_1
XFILLER_100_18 VGND VGND VPWR VPWR sky130_fd_sc_hd__decap_8
X_08300_ _00774_ _00754_ VGND VGND VPWR VPWR _00775_ sky130_fd_sc_hd__and2b_1
XFILLER_33_541 VGND VGND VPWR VPWR sky130_fd_sc_hd__decap_8
XFILLER_100_29 VPWR VGND VPWR VGND sky130_ef_sc_hd__decap_12
X_08231_ net251 _00705_ VGND VGND VPWR VPWR _00706_ sky130_fd_sc_hd__nand2b_1
XTAP_TAPCELL_ROW_119_2022 VGND VPWR sky130_fd_sc_hd__tapvpwrvgnd_1
XFILLER_20_246 VGND VGND VPWR VPWR sky130_fd_sc_hd__decap_6
XTAP_TAPCELL_ROW_31_742 VGND VPWR sky130_fd_sc_hd__tapvpwrvgnd_1
XTAP_TAPCELL_ROW_31_753 VGND VPWR sky130_fd_sc_hd__tapvpwrvgnd_1
XFILLER_118_112 VGND VGND VPWR VPWR sky130_fd_sc_hd__fill_1
X_08162_ _00627_ _00637_ VGND VGND VPWR VPWR _00638_ sky130_fd_sc_hd__nor2_1
XTAP_TAPCELL_ROW_132_2211 VGND VPWR sky130_fd_sc_hd__tapvpwrvgnd_1
XFILLER_118_145 VGND VGND VPWR VPWR sky130_fd_sc_hd__fill_1
XFILLER_109_27 VPWR VGND VPWR VGND sky130_ef_sc_hd__decap_12
X_07113_ net114 net485 VGND VGND VPWR VPWR _04569_ sky130_fd_sc_hd__nand2_1
X_08093_ net545 net689 _00437_ _00566_ _00299_ VGND VGND VPWR VPWR _00569_ sky130_fd_sc_hd__a311o_1
X_07044_ _02063_ _03292_ VGND VGND VPWR VPWR _03817_ sky130_fd_sc_hd__nor2_1
XFILLER_130_811 VGND VGND VPWR VPWR sky130_fd_sc_hd__fill_1
XFILLER_125_15 VPWR VGND VPWR VGND sky130_ef_sc_hd__decap_12
XFILLER_114_351 VPWR VGND VPWR VGND sky130_ef_sc_hd__decap_12
XFILLER_0_607 VGND VGND VPWR VPWR sky130_fd_sc_hd__decap_8
XFILLER_114_373 VGND VGND VPWR VPWR sky130_fd_sc_hd__fill_1
X_08995_ _01470_ _01471_ VGND VGND VPWR VPWR _01472_ sky130_fd_sc_hd__and2b_1
XFILLER_102_524 VGND VGND VPWR VPWR sky130_fd_sc_hd__decap_8
XFILLER_87_235 VPWR VGND VPWR VGND sky130_ef_sc_hd__decap_12
XFILLER_102_557 VPWR VGND VPWR VGND sky130_ef_sc_hd__decap_12
XFILLER_87_257 VGND VGND VPWR VPWR sky130_fd_sc_hd__fill_1
XFILLER_75_408 VGND VGND VPWR VPWR sky130_fd_sc_hd__fill_1
X_07946_ _06731_ _00286_ _00285_ VGND VGND VPWR VPWR _00424_ sky130_fd_sc_hd__a21oi_1
XTAP_TAPCELL_ROW_110_1896 VGND VPWR sky130_fd_sc_hd__tapvpwrvgnd_1
XFILLER_95_290 VPWR VGND VPWR VGND sky130_ef_sc_hd__decap_12
X_07877_ _00351_ _00354_ VGND VGND VPWR VPWR _00355_ sky130_fd_sc_hd__and2b_1
X_09616_ _02146_ _02147_ VGND VGND VPWR VPWR _02149_ sky130_fd_sc_hd__xnor2_2
X_06828_ net285 VGND VGND VPWR VPWR _01464_ sky130_fd_sc_hd__inv_2
XFILLER_43_316 VGND VGND VPWR VPWR sky130_fd_sc_hd__fill_1
XFILLER_16_519 VGND VGND VPWR VPWR sky130_fd_sc_hd__fill_1
XTAP_TAPCELL_ROW_39_864 VGND VPWR sky130_fd_sc_hd__tapvpwrvgnd_1
X_09547_ _02032_ _02071_ VGND VGND VPWR VPWR _02073_ sky130_fd_sc_hd__xnor2_1
XFILLER_43_349 VPWR VGND VPWR VGND sky130_ef_sc_hd__decap_12
XFILLER_43_327 VGND VGND VPWR VPWR sky130_fd_sc_hd__fill_2
X_09478_ _01982_ _01997_ VGND VGND VPWR VPWR _01999_ sky130_fd_sc_hd__xnor2_1
X_08429_ _00743_ _00900_ VGND VGND VPWR VPWR _00902_ sky130_fd_sc_hd__xnor2_1
XFILLER_11_235 VGND VGND VPWR VPWR sky130_fd_sc_hd__fill_1
XFILLER_126_3 VPWR VGND VPWR VGND sky130_ef_sc_hd__decap_12
XFILLER_109_101 VGND VGND VPWR VPWR sky130_fd_sc_hd__decap_4
XFILLER_11_279 VGND VGND VPWR VPWR sky130_fd_sc_hd__fill_1
Xclkload0 clknet_3_0__leaf_clk VGND VGND VPWR VPWR clkload0/X sky130_fd_sc_hd__clkbuf_8
X_11440_ _04127_ _04136_ VGND VGND VPWR VPWR _04137_ sky130_fd_sc_hd__xor2_1
X_11371_ _04056_ _04058_ VGND VGND VPWR VPWR _04061_ sky130_fd_sc_hd__xor2_1
XFILLER_109_189 VGND VGND VPWR VPWR sky130_fd_sc_hd__decap_3
XFILLER_109_167 VGND VGND VPWR VPWR sky130_fd_sc_hd__fill_1
X_13110_ _05285_ _05954_ VGND VGND VPWR VPWR _05955_ sky130_fd_sc_hd__and2_1
XTAP_TAPCELL_ROW_59_1157 VGND VPWR sky130_fd_sc_hd__tapvpwrvgnd_1
XFILLER_50_77 VGND VGND VPWR VPWR sky130_fd_sc_hd__decap_6
X_10322_ net589 net580 net310 net308 VGND VGND VPWR VPWR _02914_ sky130_fd_sc_hd__and4_1
X_13041_ _05877_ _05878_ VGND VGND VPWR VPWR _05880_ sky130_fd_sc_hd__nand2_1
XFILLER_133_671 VGND VGND VPWR VPWR sky130_fd_sc_hd__fill_1
XFILLER_59_42 VPWR VGND VPWR VGND sky130_ef_sc_hd__decap_12
X_10253_ net643 net326 net323 net654 VGND VGND VPWR VPWR _02839_ sky130_fd_sc_hd__a22o_1
X_10184_ _02492_ _02493_ _02587_ VGND VGND VPWR VPWR _02767_ sky130_fd_sc_hd__mux2_1
XTAP_TAPCELL_ROW_72_1346 VGND VPWR sky130_fd_sc_hd__tapvpwrvgnd_1
XFILLER_132_192 VGND VGND VPWR VPWR sky130_fd_sc_hd__decap_4
XFILLER_120_365 VPWR VGND VPWR VGND sky130_ef_sc_hd__decap_12
XFILLER_78_268 VPWR VGND VPWR VGND sky130_ef_sc_hd__decap_12
XFILLER_115_81 VPWR VGND VPWR VGND sky130_ef_sc_hd__decap_12
XFILLER_87_780 VGND VGND VPWR VPWR sky130_fd_sc_hd__decap_4
XFILLER_47_622 VPWR VGND VPWR VGND sky130_ef_sc_hd__decap_12
Xfanout292 net86 VGND VGND VPWR VPWR net292 sky130_fd_sc_hd__dlymetal6s2s_1
Xfanout270 net97 VGND VGND VPWR VPWR net270 sky130_fd_sc_hd__clkbuf_4
Xfanout281 net91 VGND VGND VPWR VPWR net281 sky130_fd_sc_hd__buf_2
XFILLER_93_249 VGND VGND VPWR VPWR sky130_fd_sc_hd__fill_1
XFILLER_74_441 VGND VGND VPWR VPWR sky130_fd_sc_hd__fill_2
XFILLER_19_335 VGND VGND VPWR VPWR sky130_fd_sc_hd__fill_1
XFILLER_74_485 VGND VGND VPWR VPWR sky130_fd_sc_hd__fill_1
XFILLER_35_817 VGND VGND VPWR VPWR sky130_fd_sc_hd__decap_3
X_12825_ net389 net412 VGND VGND VPWR VPWR _05643_ sky130_fd_sc_hd__and2b_1
XFILLER_74_496 VGND VGND VPWR VPWR sky130_fd_sc_hd__fill_1
XFILLER_62_658 VGND VGND VPWR VPWR sky130_fd_sc_hd__fill_1
XFILLER_34_349 VPWR VGND VPWR VGND sky130_ef_sc_hd__decap_12
XFILLER_91_51 VGND VGND VPWR VPWR sky130_fd_sc_hd__decap_4
XFILLER_61_157 VGND VGND VPWR VPWR sky130_fd_sc_hd__decap_8
XFILLER_50_809 VGND VGND VPWR VPWR sky130_fd_sc_hd__decap_3
XTAP_TAPCELL_ROW_17_547 VGND VPWR sky130_fd_sc_hd__tapvpwrvgnd_1
X_12756_ _05566_ _05567_ VGND VGND VPWR VPWR _05568_ sky130_fd_sc_hd__nor2_1
XTAP_TAPCELL_ROW_83_1497 VGND VPWR sky130_fd_sc_hd__tapvpwrvgnd_1
XFILLER_30_522 VGND VGND VPWR VPWR sky130_fd_sc_hd__decap_8
X_12687_ _05491_ _05492_ VGND VGND VPWR VPWR _05493_ sky130_fd_sc_hd__and2b_1
X_11707_ _04425_ _04426_ VGND VGND VPWR VPWR _04427_ sky130_fd_sc_hd__and2b_1
XFILLER_30_533 VGND VGND VPWR VPWR sky130_fd_sc_hd__decap_8
XFILLER_128_421 VPWR VGND VPWR VGND sky130_ef_sc_hd__decap_12
X_11638_ net602 net314 net316 net261 VGND VGND VPWR VPWR _04352_ sky130_fd_sc_hd__o2bb2a_1
XFILLER_11_780 VGND VGND VPWR VPWR sky130_fd_sc_hd__decap_4
X_13308_ _06170_ VGND VGND VPWR VPWR _06172_ sky130_fd_sc_hd__inv_2
X_11569_ _04276_ _04274_ VGND VGND VPWR VPWR _04277_ sky130_fd_sc_hd__nand2b_1
XFILLER_112_811 VGND VGND VPWR VPWR sky130_fd_sc_hd__fill_1
X_13239_ _06093_ _06095_ VGND VGND VPWR VPWR _06096_ sky130_fd_sc_hd__nor2_1
XFILLER_41_3 VPWR VGND VPWR VGND sky130_ef_sc_hd__decap_12
X_08780_ net566 net557 net365 net44 VGND VGND VPWR VPWR _01246_ sky130_fd_sc_hd__and4_1
X_07800_ _00189_ _00278_ VGND VGND VPWR VPWR _00279_ sky130_fd_sc_hd__xnor2_1
XPHY_EDGE_ROW_127_Right_127 VGND VGND VPWR VPWR sky130_fd_sc_hd__decap_3
XFILLER_69_279 VGND VGND VPWR VPWR sky130_fd_sc_hd__fill_1
X_07731_ net671 net411 VGND VGND VPWR VPWR _00210_ sky130_fd_sc_hd__and2b_1
XFILLER_65_430 VGND VGND VPWR VPWR sky130_fd_sc_hd__fill_2
XFILLER_93_783 VGND VGND VPWR VPWR sky130_fd_sc_hd__fill_1
X_07662_ _06729_ _06728_ _06727_ VGND VGND VPWR VPWR _00142_ sky130_fd_sc_hd__a21oi_2
X_09401_ net490 net347 net348 net481 VGND VGND VPWR VPWR _01915_ sky130_fd_sc_hd__a22o_1
XFILLER_80_433 VPWR VGND VPWR VGND sky130_ef_sc_hd__decap_12
XFILLER_65_485 VPWR VGND VPWR VGND sky130_ef_sc_hd__decap_12
X_07593_ net671 net417 VGND VGND VPWR VPWR _00073_ sky130_fd_sc_hd__nand2_1
XFILLER_52_124 VGND VGND VPWR VPWR sky130_fd_sc_hd__fill_2
XFILLER_52_113 VGND VGND VPWR VPWR sky130_fd_sc_hd__fill_1
XFILLER_1_93 VPWR VGND VPWR VGND sky130_ef_sc_hd__decap_12
XTAP_TAPCELL_ROW_36_823 VGND VPWR sky130_fd_sc_hd__tapvpwrvgnd_1
X_09332_ _01838_ _01837_ _01659_ _01662_ VGND VGND VPWR VPWR _01840_ sky130_fd_sc_hd__a211oi_2
X_09263_ net453 net331 _01613_ _01614_ VGND VGND VPWR VPWR _01764_ sky130_fd_sc_hd__a31o_1
XFILLER_33_393 VPWR VGND VPWR VGND sky130_ef_sc_hd__decap_12
X_09194_ _01566_ _01568_ _01687_ VGND VGND VPWR VPWR _01688_ sky130_fd_sc_hd__a21oi_1
X_08214_ _00687_ _00688_ VGND VGND VPWR VPWR _00689_ sky130_fd_sc_hd__and2b_1
X_08145_ _00514_ _00515_ net610 net704 VGND VGND VPWR VPWR _00621_ sky130_fd_sc_hd__a2bb2o_1
XFILLER_107_638 VGND VGND VPWR VPWR sky130_fd_sc_hd__fill_2
X_08076_ _00294_ _00552_ VGND VGND VPWR VPWR _00553_ sky130_fd_sc_hd__xnor2_2
XFILLER_115_671 VGND VGND VPWR VPWR sky130_fd_sc_hd__fill_1
XTAP_TAPCELL_ROW_112_1925 VGND VPWR sky130_fd_sc_hd__tapvpwrvgnd_1
X_07027_ net467 net667 _03609_ _03620_ VGND VGND VPWR VPWR _03631_ sky130_fd_sc_hd__nand4_2
XFILLER_102_321 VPWR VGND VPWR VGND sky130_ef_sc_hd__decap_12
XFILLER_96_29 VPWR VGND VPWR VGND sky130_ef_sc_hd__decap_12
XFILLER_88_533 VPWR VGND VPWR VGND sky130_ef_sc_hd__decap_12
XFILLER_114_192 VGND VGND VPWR VPWR sky130_fd_sc_hd__decap_4
XTAP_TAPCELL_ROW_54_1087 VGND VPWR sky130_fd_sc_hd__tapvpwrvgnd_1
XTAP_TAPCELL_ROW_54_1076 VGND VPWR sky130_fd_sc_hd__tapvpwrvgnd_1
XFILLER_0_459 VGND VGND VPWR VPWR sky130_fd_sc_hd__fill_2
XFILLER_130_674 VGND VGND VPWR VPWR sky130_fd_sc_hd__fill_2
X_08978_ _01450_ _01451_ _01452_ VGND VGND VPWR VPWR _01454_ sky130_fd_sc_hd__nand3_1
XFILLER_102_365 VPWR VGND VPWR VGND sky130_ef_sc_hd__decap_12
XFILLER_48_419 VGND VGND VPWR VPWR sky130_fd_sc_hd__fill_1
X_07929_ _00382_ _00406_ VGND VGND VPWR VPWR _00407_ sky130_fd_sc_hd__xnor2_2
XFILLER_29_89 VGND VGND VPWR VPWR sky130_fd_sc_hd__fill_1
X_10940_ _03540_ _03589_ VGND VGND VPWR VPWR _03590_ sky130_fd_sc_hd__and2b_1
XFILLER_28_165 VGND VGND VPWR VPWR sky130_fd_sc_hd__decap_8
XFILLER_83_293 VGND VGND VPWR VPWR sky130_fd_sc_hd__decap_6
XFILLER_45_55 VGND VGND VPWR VPWR sky130_fd_sc_hd__fill_1
XFILLER_43_113 VPWR VGND VPWR VGND sky130_ef_sc_hd__decap_12
X_12610_ net565 net556 net501 VGND VGND VPWR VPWR _05409_ sky130_fd_sc_hd__and3_1
XFILLER_71_466 VGND VGND VPWR VPWR sky130_fd_sc_hd__decap_8
XFILLER_71_455 VGND VGND VPWR VPWR sky130_fd_sc_hd__fill_1
XFILLER_43_157 VGND VGND VPWR VPWR sky130_fd_sc_hd__decap_8
X_10871_ _03280_ _03339_ _03338_ VGND VGND VPWR VPWR _03515_ sky130_fd_sc_hd__a21bo_1
XFILLER_31_308 VGND VGND VPWR VPWR sky130_fd_sc_hd__decap_6
X_13590_ _06300_ _06478_ VGND VGND VPWR VPWR _06479_ sky130_fd_sc_hd__xnor2_1
XTAP_TAPCELL_ROW_14_506 VGND VPWR sky130_fd_sc_hd__tapvpwrvgnd_1
X_12541_ _05322_ _05333_ VGND VGND VPWR VPWR _05334_ sky130_fd_sc_hd__xnor2_1
XFILLER_51_190 VGND VGND VPWR VPWR sky130_fd_sc_hd__fill_1
X_12472_ _05256_ _05257_ VGND VGND VPWR VPWR _05258_ sky130_fd_sc_hd__nand2b_1
XFILLER_61_65 VGND VGND VPWR VPWR sky130_fd_sc_hd__decap_3
XFILLER_61_54 VGND VGND VPWR VPWR sky130_fd_sc_hd__fill_2
XFILLER_12_566 VGND VGND VPWR VPWR sky130_fd_sc_hd__decap_6
X_11423_ net627 net618 net314 VGND VGND VPWR VPWR _04118_ sky130_fd_sc_hd__o21ai_1
XFILLER_138_785 VPWR VGND VPWR VGND sky130_ef_sc_hd__decap_12
XFILLER_6_27 VGND VGND VPWR VPWR sky130_fd_sc_hd__fill_1
XANTENNA_9 net92 VGND VGND VPWR VPWR sky130_fd_sc_hd__diode_2
XFILLER_99_809 VGND VGND VPWR VPWR sky130_fd_sc_hd__decap_8
X_11354_ _03889_ _03890_ _03891_ _03888_ _03887_ VGND VGND VPWR VPWR _04042_ sky130_fd_sc_hd__o32a_1
XFILLER_3_253 VPWR VGND VPWR VGND sky130_ef_sc_hd__decap_12
X_10305_ _02861_ _02892_ _02894_ VGND VGND VPWR VPWR _02895_ sky130_fd_sc_hd__a21o_1
X_11285_ _03953_ _03966_ VGND VGND VPWR VPWR _03967_ sky130_fd_sc_hd__nor2_1
XFILLER_79_511 VPWR VGND VPWR VGND sky130_ef_sc_hd__decap_12
X_13024_ _05859_ _05860_ VGND VGND VPWR VPWR _05861_ sky130_fd_sc_hd__and2b_1
X_10236_ _02817_ _02819_ _02816_ VGND VGND VPWR VPWR _02821_ sky130_fd_sc_hd__a21oi_1
X_10167_ _02747_ _02748_ VGND VGND VPWR VPWR _02749_ sky130_fd_sc_hd__or2_1
XFILLER_39_419 VPWR VGND VPWR VGND sky130_ef_sc_hd__decap_12
X_10098_ _02671_ _02672_ VGND VGND VPWR VPWR _02675_ sky130_fd_sc_hd__nand2_1
XFILLER_94_569 VPWR VGND VPWR VGND sky130_ef_sc_hd__decap_12
XFILLER_90_731 VGND VGND VPWR VPWR sky130_fd_sc_hd__decap_4
XTAP_TAPCELL_ROW_85_1537 VGND VPWR sky130_fd_sc_hd__tapvpwrvgnd_1
XTAP_TAPCELL_ROW_85_1526 VGND VPWR sky130_fd_sc_hd__tapvpwrvgnd_1
XFILLER_34_135 VGND VGND VPWR VPWR sky130_fd_sc_hd__decap_4
X_12808_ _05622_ _05623_ VGND VGND VPWR VPWR _05625_ sky130_fd_sc_hd__nand2b_1
XFILLER_62_477 VGND VGND VPWR VPWR sky130_fd_sc_hd__decap_6
XFILLER_50_639 VGND VGND VPWR VPWR sky130_fd_sc_hd__decap_4
X_12739_ _05370_ _05372_ _05548_ _05549_ VGND VGND VPWR VPWR _05550_ sky130_fd_sc_hd__a211oi_1
XFILLER_15_393 VGND VGND VPWR VPWR sky130_fd_sc_hd__fill_2
XFILLER_30_341 VGND VGND VPWR VPWR sky130_fd_sc_hd__decap_4
XFILLER_30_352 VPWR VGND VPWR VGND sky130_ef_sc_hd__decap_12
XFILLER_129_741 VGND VGND VPWR VPWR sky130_fd_sc_hd__decap_4
XTAP_TAPCELL_ROW_41_892 VGND VPWR sky130_fd_sc_hd__tapvpwrvgnd_1
XFILLER_30_396 VGND VGND VPWR VPWR sky130_fd_sc_hd__decap_4
XFILLER_129_785 VPWR VGND VPWR VGND sky130_ef_sc_hd__decap_12
XFILLER_131_405 VPWR VGND VPWR VGND sky130_ef_sc_hd__decap_12
X_09950_ net419 net329 _02416_ VGND VGND VPWR VPWR _02513_ sky130_fd_sc_hd__a21o_1
XTAP_TAPCELL_ROW_96_1688 VGND VPWR sky130_fd_sc_hd__tapvpwrvgnd_1
Xmax_cap245 _00310_ VGND VGND VPWR VPWR net245 sky130_fd_sc_hd__clkbuf_1
X_08901_ net566 net557 net363 net362 VGND VGND VPWR VPWR _01369_ sky130_fd_sc_hd__and4_1
X_09881_ _02185_ _02311_ _02310_ VGND VGND VPWR VPWR _02438_ sky130_fd_sc_hd__a21oi_1
XFILLER_124_490 VGND VGND VPWR VPWR sky130_fd_sc_hd__decap_4
XFILLER_112_696 VGND VGND VPWR VPWR sky130_fd_sc_hd__decap_4
X_08832_ _01296_ _01297_ VGND VGND VPWR VPWR _01298_ sky130_fd_sc_hd__nor2_1
XFILLER_85_503 VGND VGND VPWR VPWR sky130_fd_sc_hd__fill_1
XTAP_TAPCELL_ROW_127_2143 VGND VPWR sky130_fd_sc_hd__tapvpwrvgnd_1
X_08763_ _01122_ _01229_ VGND VGND VPWR VPWR _01230_ sky130_fd_sc_hd__and2_1
XFILLER_111_173 VGND VGND VPWR VPWR sky130_fd_sc_hd__fill_1
XFILLER_122_27 VGND VGND VPWR VPWR sky130_fd_sc_hd__fill_1
X_07714_ net682 net484 net477 net684 VGND VGND VPWR VPWR _00193_ sky130_fd_sc_hd__a22o_1
X_08694_ _01157_ _01159_ VGND VGND VPWR VPWR _01161_ sky130_fd_sc_hd__nor2_1
X_07645_ _06816_ _00123_ _00124_ VGND VGND VPWR VPWR _00125_ sky130_fd_sc_hd__nand3_1
XTAP_TAPCELL_ROW_0_278 VGND VPWR sky130_fd_sc_hd__tapvpwrvgnd_1
XFILLER_25_157 VGND VGND VPWR VPWR sky130_fd_sc_hd__decap_8
X_07576_ _06802_ _06804_ VGND VGND VPWR VPWR _06805_ sky130_fd_sc_hd__xnor2_1
XFILLER_41_639 VPWR VGND VPWR VGND sky130_ef_sc_hd__decap_12
XTAP_TAPCELL_ROW_0_289 VGND VPWR sky130_fd_sc_hd__tapvpwrvgnd_1
X_09315_ net636 net368 VGND VGND VPWR VPWR _01821_ sky130_fd_sc_hd__nand2_1
X_09246_ _01609_ _01631_ _01630_ VGND VGND VPWR VPWR _01745_ sky130_fd_sc_hd__a21o_1
XTAP_TAPCELL_ROW_138_2294 VGND VPWR sky130_fd_sc_hd__tapvpwrvgnd_1
XFILLER_135_722 VGND VGND VPWR VPWR sky130_fd_sc_hd__decap_6
XFILLER_135_700 VGND VGND VPWR VPWR sky130_fd_sc_hd__fill_2
X_09177_ _01668_ _01669_ VGND VGND VPWR VPWR _01670_ sky130_fd_sc_hd__and2b_1
XFILLER_119_273 VGND VGND VPWR VPWR sky130_fd_sc_hd__decap_6
XFILLER_31_57 VGND VGND VPWR VPWR sky130_fd_sc_hd__fill_2
XTAP_TAPCELL_ROW_56_1105 VGND VPWR sky130_fd_sc_hd__tapvpwrvgnd_1
X_08128_ _00598_ _00603_ VGND VGND VPWR VPWR _00604_ sky130_fd_sc_hd__nand2b_1
XFILLER_135_777 VGND VGND VPWR VPWR sky130_fd_sc_hd__decap_6
X_08059_ _00513_ _00535_ VGND VGND VPWR VPWR _00536_ sky130_fd_sc_hd__or2_1
XTAP_TAPCELL_ROW_56_1116 VGND VPWR sky130_fd_sc_hd__tapvpwrvgnd_1
X_11070_ net537 net308 net310 net264 VGND VGND VPWR VPWR _03732_ sky130_fd_sc_hd__o2bb2a_1
X_10021_ _02494_ _02589_ VGND VGND VPWR VPWR _02590_ sky130_fd_sc_hd__or2_1
XFILLER_103_641 VGND VGND VPWR VPWR sky130_fd_sc_hd__fill_2
Xinput102 w30[4] VGND VGND VPWR VPWR net102 sky130_fd_sc_hd__buf_2
XFILLER_0_223 VGND VGND VPWR VPWR sky130_fd_sc_hd__fill_1
XFILLER_103_685 VGND VGND VPWR VPWR sky130_fd_sc_hd__decap_6
Xinput135 x0[5] VGND VGND VPWR VPWR net135 sky130_fd_sc_hd__buf_1
XFILLER_88_385 VGND VGND VPWR VPWR sky130_fd_sc_hd__decap_3
XFILLER_88_374 VGND VGND VPWR VPWR sky130_fd_sc_hd__decap_4
Xinput124 w33[2] VGND VGND VPWR VPWR net124 sky130_fd_sc_hd__buf_1
XFILLER_49_739 VGND VGND VPWR VPWR sky130_fd_sc_hd__decap_3
XFILLER_48_205 VGND VGND VPWR VPWR sky130_fd_sc_hd__fill_1
XFILLER_0_267 VGND VGND VPWR VPWR sky130_fd_sc_hd__fill_2
Xinput113 w31[7] VGND VGND VPWR VPWR net113 sky130_fd_sc_hd__clkbuf_2
Xinput146 x2[0] VGND VGND VPWR VPWR net146 sky130_fd_sc_hd__clkbuf_4
Xinput157 x3[3] VGND VGND VPWR VPWR net157 sky130_fd_sc_hd__buf_1
XFILLER_91_517 VGND VGND VPWR VPWR sky130_fd_sc_hd__decap_6
XFILLER_56_65 VPWR VGND VPWR VGND sky130_ef_sc_hd__decap_12
XFILLER_29_441 VGND VGND VPWR VPWR sky130_fd_sc_hd__decap_6
XFILLER_29_452 VPWR VGND VPWR VGND sky130_ef_sc_hd__decap_12
XFILLER_84_580 VGND VGND VPWR VPWR sky130_fd_sc_hd__decap_8
X_11972_ net471 net389 _04710_ VGND VGND VPWR VPWR _04712_ sky130_fd_sc_hd__and3_1
XFILLER_57_783 VGND VGND VPWR VPWR sky130_fd_sc_hd__fill_1
XFILLER_56_282 VGND VGND VPWR VPWR sky130_fd_sc_hd__fill_1
XFILLER_16_102 VGND VGND VPWR VPWR sky130_fd_sc_hd__decap_4
XFILLER_17_614 VGND VGND VPWR VPWR sky130_fd_sc_hd__fill_2
XFILLER_17_625 VGND VGND VPWR VPWR sky130_fd_sc_hd__fill_2
XFILLER_17_647 VPWR VGND VPWR VGND sky130_ef_sc_hd__decap_12
XTAP_TAPCELL_ROW_67_1267 VGND VPWR sky130_fd_sc_hd__tapvpwrvgnd_1
X_10923_ _03570_ net300 _06762_ VGND VGND VPWR VPWR _03571_ sky130_fd_sc_hd__and3b_1
XFILLER_16_124 VPWR VGND VPWR VGND sky130_ef_sc_hd__decap_12
XPHY_EDGE_ROW_19_Right_19 VGND VGND VPWR VPWR sky130_fd_sc_hd__decap_3
X_13642_ clknet_3_6__leaf_clk _00038_ net716 VGND VGND VPWR VPWR net177 sky130_fd_sc_hd__dfrtp_1
XFILLER_72_53 VPWR VGND VPWR VGND sky130_ef_sc_hd__decap_12
XTAP_TAPCELL_ROW_27_686 VGND VPWR sky130_fd_sc_hd__tapvpwrvgnd_1
X_10854_ _06694_ _03494_ VGND VGND VPWR VPWR _03496_ sky130_fd_sc_hd__xor2_1
X_13573_ _06351_ _06353_ _06459_ VGND VGND VPWR VPWR _06460_ sky130_fd_sc_hd__o21a_1
XTAP_TAPCELL_ROW_27_697 VGND VPWR sky130_fd_sc_hd__tapvpwrvgnd_1
XTAP_TAPCELL_ROW_80_1456 VGND VPWR sky130_fd_sc_hd__tapvpwrvgnd_1
X_12524_ net472 net379 VGND VGND VPWR VPWR _05315_ sky130_fd_sc_hd__and2_4
X_10785_ _03255_ _03419_ VGND VGND VPWR VPWR _03420_ sky130_fd_sc_hd__xnor2_1
XFILLER_40_661 VGND VGND VPWR VPWR sky130_fd_sc_hd__decap_4
X_12455_ net593 net408 VGND VGND VPWR VPWR _05239_ sky130_fd_sc_hd__nand2_1
Xclkbuf_3_1__f_clk clknet_0_clk VGND VGND VPWR VPWR clknet_3_1__leaf_clk sky130_fd_sc_hd__clkbuf_16
X_12386_ _05162_ _05163_ VGND VGND VPWR VPWR _05164_ sky130_fd_sc_hd__nor2_1
X_11406_ _04069_ _04097_ VGND VGND VPWR VPWR _04099_ sky130_fd_sc_hd__xnor2_1
XFILLER_113_405 VPWR VGND VPWR VGND sky130_ef_sc_hd__decap_12
XFILLER_99_617 VPWR VGND VPWR VGND sky130_ef_sc_hd__decap_12
X_11337_ _03914_ _03917_ _04022_ VGND VGND VPWR VPWR _04023_ sky130_fd_sc_hd__a21oi_4
XPHY_EDGE_ROW_28_Right_28 VGND VGND VPWR VPWR sky130_fd_sc_hd__decap_3
X_11268_ _03920_ _03947_ VGND VGND VPWR VPWR _03949_ sky130_fd_sc_hd__and2b_1
XFILLER_79_363 VPWR VGND VPWR VGND sky130_ef_sc_hd__decap_12
X_13007_ _05833_ _05841_ VGND VGND VPWR VPWR _05842_ sky130_fd_sc_hd__xor2_1
X_11199_ _03544_ _03716_ _03715_ VGND VGND VPWR VPWR _03873_ sky130_fd_sc_hd__a21o_1
X_10219_ _02799_ _02800_ _02801_ VGND VGND VPWR VPWR _02804_ sky130_fd_sc_hd__o21ai_1
XFILLER_48_772 VGND VGND VPWR VPWR sky130_fd_sc_hd__fill_1
XPHY_EDGE_ROW_37_Right_37 VGND VGND VPWR VPWR sky130_fd_sc_hd__decap_3
XFILLER_47_293 VPWR VGND VPWR VGND sky130_ef_sc_hd__decap_12
XTAP_TAPCELL_ROW_46_962 VGND VPWR sky130_fd_sc_hd__tapvpwrvgnd_1
XTAP_TAPCELL_ROW_122_2073 VGND VPWR sky130_fd_sc_hd__tapvpwrvgnd_1
XTAP_TAPCELL_ROW_122_2062 VGND VPWR sky130_fd_sc_hd__tapvpwrvgnd_1
X_07430_ net457 net664 VGND VGND VPWR VPWR _06660_ sky130_fd_sc_hd__nand2_1
XTAP_TAPCELL_ROW_46_973 VGND VPWR sky130_fd_sc_hd__tapvpwrvgnd_1
XFILLER_23_617 VPWR VGND VPWR VGND sky130_ef_sc_hd__decap_12
X_07361_ _06588_ _06589_ VGND VGND VPWR VPWR _06591_ sky130_fd_sc_hd__xnor2_1
X_09100_ _01583_ _01584_ VGND VGND VPWR VPWR _01586_ sky130_fd_sc_hd__or2_1
XFILLER_50_469 VGND VGND VPWR VPWR sky130_fd_sc_hd__decap_6
X_09031_ _01233_ _01359_ _01509_ _01510_ VGND VGND VPWR VPWR _01512_ sky130_fd_sc_hd__a2bb2o_4
XTAP_TAPCELL_ROW_98_1717 VGND VPWR sky130_fd_sc_hd__tapvpwrvgnd_1
X_07292_ _06301_ _06508_ VGND VGND VPWR VPWR _06519_ sky130_fd_sc_hd__xnor2_1
XFILLER_30_171 VGND VGND VPWR VPWR sky130_fd_sc_hd__decap_6
XPHY_EDGE_ROW_46_Right_46 VGND VGND VPWR VPWR sky130_fd_sc_hd__decap_3
XFILLER_7_81 VGND VGND VPWR VPWR sky130_fd_sc_hd__fill_2
XFILLER_117_27 VPWR VGND VPWR VGND sky130_ef_sc_hd__decap_12
XFILLER_116_243 VGND VGND VPWR VPWR sky130_fd_sc_hd__fill_2
XFILLER_116_287 VGND VGND VPWR VPWR sky130_fd_sc_hd__fill_1
XFILLER_132_769 VPWR VGND VPWR VGND sky130_ef_sc_hd__decap_12
X_09933_ _02492_ _02493_ VGND VGND VPWR VPWR _02494_ sky130_fd_sc_hd__nand2_2
XFILLER_104_449 VGND VGND VPWR VPWR sky130_fd_sc_hd__decap_6
XFILLER_112_460 VGND VGND VPWR VPWR sky130_fd_sc_hd__decap_3
X_09864_ _02412_ _02419_ VGND VGND VPWR VPWR _02420_ sky130_fd_sc_hd__nor2_1
XTAP_TAPCELL_ROW_51_1035 VGND VPWR sky130_fd_sc_hd__tapvpwrvgnd_1
XFILLER_133_15 VPWR VGND VPWR VGND sky130_ef_sc_hd__decap_12
X_08815_ _01277_ _01278_ _01279_ VGND VGND VPWR VPWR _01281_ sky130_fd_sc_hd__a21o_1
XFILLER_97_193 VPWR VGND VPWR VGND sky130_ef_sc_hd__decap_12
XFILLER_58_558 VGND VGND VPWR VPWR sky130_fd_sc_hd__fill_1
X_09795_ net250 _02343_ VGND VGND VPWR VPWR _02344_ sky130_fd_sc_hd__nand2_1
XFILLER_100_677 VGND VGND VPWR VPWR sky130_fd_sc_hd__decap_6
XFILLER_85_366 VGND VGND VPWR VPWR sky130_fd_sc_hd__decap_8
XFILLER_73_517 VPWR VGND VPWR VGND sky130_ef_sc_hd__decap_12
XPHY_EDGE_ROW_55_Right_55 VGND VGND VPWR VPWR sky130_fd_sc_hd__decap_3
X_08746_ _01142_ _01210_ _01211_ VGND VGND VPWR VPWR _01213_ sky130_fd_sc_hd__or3_2
XFILLER_39_783 VGND VGND VPWR VPWR sky130_fd_sc_hd__fill_1
X_08677_ net446 net340 VGND VGND VPWR VPWR _01144_ sky130_fd_sc_hd__nand2_1
XTAP_TAPCELL_ROW_107_1857 VGND VPWR sky130_fd_sc_hd__tapvpwrvgnd_1
XTAP_TAPCELL_ROW_107_1846 VGND VPWR sky130_fd_sc_hd__tapvpwrvgnd_1
X_07628_ net259 _06693_ _06692_ VGND VGND VPWR VPWR _00108_ sky130_fd_sc_hd__o21ai_4
XFILLER_54_775 VPWR VGND VPWR VGND sky130_ef_sc_hd__decap_12
XFILLER_53_274 VGND VGND VPWR VPWR sky130_fd_sc_hd__decap_6
XFILLER_53_252 VGND VGND VPWR VPWR sky130_fd_sc_hd__decap_4
XFILLER_26_477 VGND VGND VPWR VPWR sky130_fd_sc_hd__decap_8
XFILLER_26_499 VGND VGND VPWR VPWR sky130_fd_sc_hd__decap_3
XFILLER_41_458 VGND VGND VPWR VPWR sky130_fd_sc_hd__fill_2
XFILLER_41_447 VGND VGND VPWR VPWR sky130_fd_sc_hd__fill_1
XTAP_TAPCELL_ROW_24_645 VGND VPWR sky130_fd_sc_hd__tapvpwrvgnd_1
X_07559_ _06786_ _06787_ VGND VGND VPWR VPWR _06788_ sky130_fd_sc_hd__xnor2_1
XPHY_EDGE_ROW_64_Right_64 VGND VGND VPWR VPWR sky130_fd_sc_hd__decap_3
XTAP_TAPCELL_ROW_62_1197 VGND VPWR sky130_fd_sc_hd__tapvpwrvgnd_1
XFILLER_22_694 VGND VGND VPWR VPWR sky130_fd_sc_hd__fill_1
X_10570_ _03133_ _03184_ _03185_ VGND VGND VPWR VPWR _03186_ sky130_fd_sc_hd__nor3_1
X_09229_ net356 _01726_ _01724_ VGND VGND VPWR VPWR _01727_ sky130_fd_sc_hd__a21bo_1
XFILLER_6_805 VGND VGND VPWR VPWR sky130_fd_sc_hd__decap_6
X_12240_ _05001_ _05003_ _05004_ VGND VGND VPWR VPWR _05005_ sky130_fd_sc_hd__or3_1
XFILLER_5_315 VPWR VGND VPWR VGND sky130_ef_sc_hd__decap_12
X_12171_ _04924_ _04929_ VGND VGND VPWR VPWR _04930_ sky130_fd_sc_hd__and2_1
X_11122_ _03783_ _03788_ VGND VGND VPWR VPWR _03789_ sky130_fd_sc_hd__and2_1
XFILLER_110_419 VGND VGND VPWR VPWR sky130_fd_sc_hd__fill_1
XFILLER_107_93 VGND VGND VPWR VPWR sky130_fd_sc_hd__decap_4
XFILLER_67_31 VPWR VGND VPWR VGND sky130_ef_sc_hd__decap_12
XFILLER_3_39 VPWR VGND VPWR VGND sky130_ef_sc_hd__decap_12
XFILLER_1_587 VPWR VGND VPWR VGND sky130_ef_sc_hd__decap_12
X_11053_ _03539_ _03591_ _03590_ VGND VGND VPWR VPWR _03713_ sky130_fd_sc_hd__a21oi_1
X_10004_ _02439_ _02441_ _02570_ VGND VGND VPWR VPWR _02572_ sky130_fd_sc_hd__nand3_1
XPHY_EDGE_ROW_73_Right_73 VGND VGND VPWR VPWR sky130_fd_sc_hd__decap_3
XFILLER_37_709 VPWR VGND VPWR VGND sky130_ef_sc_hd__decap_12
XFILLER_123_81 VPWR VGND VPWR VGND sky130_ef_sc_hd__decap_12
XFILLER_91_369 VGND VGND VPWR VPWR sky130_fd_sc_hd__fill_2
X_11955_ _04693_ VGND VGND VPWR VPWR _04694_ sky130_fd_sc_hd__inv_2
XFILLER_44_230 VGND VGND VPWR VPWR sky130_fd_sc_hd__fill_2
XFILLER_29_293 VPWR VGND VPWR VGND sky130_ef_sc_hd__decap_12
XFILLER_72_561 VGND VGND VPWR VPWR sky130_fd_sc_hd__decap_8
XFILLER_60_701 VGND VGND VPWR VPWR sky130_fd_sc_hd__decap_3
XFILLER_45_797 VPWR VGND VPWR VGND sky130_ef_sc_hd__decap_12
X_10906_ net306 _03550_ _03551_ VGND VGND VPWR VPWR _03552_ sky130_fd_sc_hd__a21bo_1
X_13625_ _06444_ _06515_ VGND VGND VPWR VPWR _06516_ sky130_fd_sc_hd__xnor2_1
XTAP_TAPCELL_ROW_43_921 VGND VPWR sky130_fd_sc_hd__tapvpwrvgnd_1
X_11886_ _04540_ _04543_ _04618_ _04617_ VGND VGND VPWR VPWR _04621_ sky130_fd_sc_hd__o31a_1
XFILLER_32_447 VGND VGND VPWR VPWR sky130_fd_sc_hd__fill_1
XPHY_EDGE_ROW_82_Right_82 VGND VGND VPWR VPWR sky130_fd_sc_hd__decap_3
XFILLER_16_90 VPWR VGND VPWR VGND sky130_ef_sc_hd__decap_12
XPHY_EDGE_ROW_17_Left_156 VGND VGND VPWR VPWR sky130_fd_sc_hd__decap_3
X_10837_ _03453_ _03476_ VGND VGND VPWR VPWR _03477_ sky130_fd_sc_hd__xnor2_1
X_13556_ _06438_ _06439_ VGND VGND VPWR VPWR _06441_ sky130_fd_sc_hd__xor2_1
XFILLER_80_7 VPWR VGND VPWR VGND sky130_ef_sc_hd__decap_12
XFILLER_9_643 VPWR VGND VPWR VGND sky130_ef_sc_hd__decap_12
XFILLER_8_120 VGND VGND VPWR VPWR sky130_fd_sc_hd__fill_1
X_10768_ _03392_ _03399_ VGND VGND VPWR VPWR _03402_ sky130_fd_sc_hd__or2_1
X_13487_ _06182_ _06363_ _06364_ VGND VGND VPWR VPWR _06366_ sky130_fd_sc_hd__and3_1
X_12507_ net446 net385 net388 net439 VGND VGND VPWR VPWR _05296_ sky130_fd_sc_hd__a22o_1
XFILLER_8_153 VPWR VGND VPWR VGND sky130_ef_sc_hd__decap_12
XFILLER_138_390 VGND VGND VPWR VPWR sky130_fd_sc_hd__fill_2
X_12438_ _05072_ _05108_ _05110_ VGND VGND VPWR VPWR _05221_ sky130_fd_sc_hd__a21oi_1
XFILLER_8_197 VPWR VGND VPWR VGND sky130_ef_sc_hd__decap_12
X_10699_ _03323_ _03324_ _03316_ VGND VGND VPWR VPWR _03327_ sky130_fd_sc_hd__a21o_1
XTAP_TAPCELL_ROW_93_1647 VGND VPWR sky130_fd_sc_hd__tapvpwrvgnd_1
X_12369_ net439 net430 net391 net389 VGND VGND VPWR VPWR _05146_ sky130_fd_sc_hd__and4_1
XFILLER_114_769 VGND VGND VPWR VPWR sky130_fd_sc_hd__decap_4
XFILLER_99_447 VGND VGND VPWR VPWR sky130_fd_sc_hd__fill_1
XFILLER_4_392 VGND VGND VPWR VPWR sky130_fd_sc_hd__decap_4
XFILLER_113_279 VGND VGND VPWR VPWR sky130_fd_sc_hd__fill_1
XPHY_EDGE_ROW_91_Right_91 VGND VGND VPWR VPWR sky130_fd_sc_hd__decap_3
XPHY_EDGE_ROW_26_Left_165 VGND VGND VPWR VPWR sky130_fd_sc_hd__decap_3
X_06930_ net702 net562 net554 net703 VGND VGND VPWR VPWR _02575_ sky130_fd_sc_hd__a22oi_1
XFILLER_79_182 VGND VGND VPWR VPWR sky130_fd_sc_hd__fill_2
X_08600_ _01027_ _01066_ VGND VGND VPWR VPWR _01068_ sky130_fd_sc_hd__or2_1
XTAP_TAPCELL_ROW_124_2102 VGND VPWR sky130_fd_sc_hd__tapvpwrvgnd_1
XFILLER_67_355 VGND VGND VPWR VPWR sky130_fd_sc_hd__decap_3
X_06861_ _01802_ _01813_ VGND VGND VPWR VPWR _01824_ sky130_fd_sc_hd__nand2_1
XTAP_TAPCELL_ROW_2_329 VGND VPWR sky130_fd_sc_hd__tapvpwrvgnd_1
X_09580_ _01972_ _01981_ _01980_ VGND VGND VPWR VPWR _02110_ sky130_fd_sc_hd__a21o_1
XFILLER_95_686 VGND VGND VPWR VPWR sky130_fd_sc_hd__fill_1
X_08531_ _00998_ _00999_ _01000_ VGND VGND VPWR VPWR _01001_ sky130_fd_sc_hd__nor3_1
X_08462_ _00933_ _00934_ VGND VGND VPWR VPWR _00935_ sky130_fd_sc_hd__xor2_1
X_07413_ net670 net427 _06641_ _06642_ VGND VGND VPWR VPWR _06643_ sky130_fd_sc_hd__a22o_1
XPHY_EDGE_ROW_35_Left_174 VGND VGND VPWR VPWR sky130_fd_sc_hd__decap_3
X_08393_ _00481_ _00760_ _00865_ VGND VGND VPWR VPWR _00867_ sky130_fd_sc_hd__nor3_1
XTAP_TAPCELL_ROW_102_1776 VGND VPWR sky130_fd_sc_hd__tapvpwrvgnd_1
X_07344_ _04329_ _05701_ _06573_ VGND VGND VPWR VPWR _06574_ sky130_fd_sc_hd__or3_1
XTAP_TAPCELL_ROW_21_604 VGND VPWR sky130_fd_sc_hd__tapvpwrvgnd_1
XFILLER_136_305 VGND VGND VPWR VPWR sky130_fd_sc_hd__decap_3
X_07275_ net670 net436 net426 net672 VGND VGND VPWR VPWR _06334_ sky130_fd_sc_hd__a22o_1
XFILLER_12_15 VPWR VGND VPWR VGND sky130_ef_sc_hd__decap_12
XTAP_TAPCELL_ROW_135_2253 VGND VPWR sky130_fd_sc_hd__tapvpwrvgnd_1
XFILLER_128_15 VPWR VGND VPWR VGND sky130_ef_sc_hd__decap_12
X_09014_ _01461_ _01491_ _01492_ VGND VGND VPWR VPWR _01493_ sky130_fd_sc_hd__nand3_1
XPHY_EDGE_ROW_44_Left_183 VGND VGND VPWR VPWR sky130_fd_sc_hd__decap_3
XFILLER_132_555 VGND VGND VPWR VPWR sky130_fd_sc_hd__decap_4
X_09916_ _02365_ _02367_ _02364_ VGND VGND VPWR VPWR _02475_ sky130_fd_sc_hd__a21oi_1
Xfanout600 net601 VGND VGND VPWR VPWR net600 sky130_fd_sc_hd__buf_4
Xfanout633 net635 VGND VGND VPWR VPWR net633 sky130_fd_sc_hd__buf_2
Xfanout622 net626 VGND VGND VPWR VPWR net622 sky130_fd_sc_hd__clkbuf_4
Xfanout611 net612 VGND VGND VPWR VPWR net611 sky130_fd_sc_hd__clkbuf_4
XFILLER_59_812 VGND VGND VPWR VPWR sky130_fd_sc_hd__decap_8
XFILLER_86_620 VPWR VGND VPWR VGND sky130_ef_sc_hd__decap_12
Xfanout666 net127 VGND VGND VPWR VPWR net666 sky130_fd_sc_hd__buf_2
Xfanout655 net658 VGND VGND VPWR VPWR net655 sky130_fd_sc_hd__buf_6
Xfanout644 net649 VGND VGND VPWR VPWR net644 sky130_fd_sc_hd__clkbuf_4
X_09847_ _01610_ _02400_ VGND VGND VPWR VPWR _02401_ sky130_fd_sc_hd__nand2_1
XFILLER_58_344 VGND VGND VPWR VPWR sky130_fd_sc_hd__fill_2
Xfanout677 net120 VGND VGND VPWR VPWR net677 sky130_fd_sc_hd__clkbuf_4
XFILLER_46_506 VGND VGND VPWR VPWR sky130_fd_sc_hd__decap_4
Xfanout688 net113 VGND VGND VPWR VPWR net688 sky130_fd_sc_hd__clkbuf_4
Xfanout699 net700 VGND VGND VPWR VPWR net699 sky130_fd_sc_hd__clkbuf_2
X_09778_ _02224_ _02256_ _02255_ VGND VGND VPWR VPWR _02326_ sky130_fd_sc_hd__a21oi_1
XFILLER_58_377 VPWR VGND VPWR VGND sky130_ef_sc_hd__decap_12
XFILLER_18_219 VGND VGND VPWR VPWR sky130_fd_sc_hd__decap_8
XTAP_TAPCELL_ROW_29_715 VGND VPWR sky130_fd_sc_hd__tapvpwrvgnd_1
XTAP_TAPCELL_ROW_29_726 VGND VPWR sky130_fd_sc_hd__tapvpwrvgnd_1
X_08729_ _01193_ _01194_ _01195_ VGND VGND VPWR VPWR _01196_ sky130_fd_sc_hd__nand3_1
XFILLER_73_347 VPWR VGND VPWR VGND sky130_ef_sc_hd__decap_12
XPHY_EDGE_ROW_53_Left_192 VGND VGND VPWR VPWR sky130_fd_sc_hd__decap_3
XFILLER_42_701 VGND VGND VPWR VPWR sky130_fd_sc_hd__decap_8
X_11740_ _04459_ _04461_ VGND VGND VPWR VPWR _04463_ sky130_fd_sc_hd__and2b_1
XFILLER_14_403 VGND VGND VPWR VPWR sky130_fd_sc_hd__fill_2
XFILLER_27_797 VPWR VGND VPWR VGND sky130_ef_sc_hd__decap_12
XTAP_TAPCELL_ROW_64_1226 VGND VPWR sky130_fd_sc_hd__tapvpwrvgnd_1
XFILLER_53_88 VPWR VGND VPWR VGND sky130_ef_sc_hd__decap_12
XFILLER_53_55 VGND VGND VPWR VPWR sky130_fd_sc_hd__fill_1
X_11671_ _04212_ _04387_ VGND VGND VPWR VPWR _04388_ sky130_fd_sc_hd__and2_1
XFILLER_14_458 VGND VGND VPWR VPWR sky130_fd_sc_hd__fill_1
X_13410_ _06281_ _06282_ VGND VGND VPWR VPWR _06283_ sky130_fd_sc_hd__nor2_1
X_10622_ _03238_ _03240_ VGND VGND VPWR VPWR _03242_ sky130_fd_sc_hd__and2b_1
X_13341_ _06205_ _06206_ VGND VGND VPWR VPWR _06207_ sky130_fd_sc_hd__or2_1
X_10553_ _03164_ _03165_ _03166_ VGND VGND VPWR VPWR _03167_ sky130_fd_sc_hd__nand3_1
X_13272_ net418 net381 VGND VGND VPWR VPWR _06132_ sky130_fd_sc_hd__nand2_1
X_10484_ _03089_ _03090_ VGND VGND VPWR VPWR _03091_ sky130_fd_sc_hd__xnor2_2
XFILLER_5_145 VGND VGND VPWR VPWR sky130_fd_sc_hd__decap_8
XFILLER_108_574 VGND VGND VPWR VPWR sky130_fd_sc_hd__decap_3
X_12223_ net531 net399 _04985_ VGND VGND VPWR VPWR _04986_ sky130_fd_sc_hd__and3_1
XFILLER_123_544 VPWR VGND VPWR VGND sky130_ef_sc_hd__decap_12
XFILLER_78_41 VPWR VGND VPWR VGND sky130_ef_sc_hd__decap_12
X_12154_ _04899_ _04907_ _04906_ VGND VGND VPWR VPWR _04911_ sky130_fd_sc_hd__a21oi_1
XFILLER_69_609 VGND VGND VPWR VPWR sky130_fd_sc_hd__decap_6
XFILLER_78_85 VPWR VGND VPWR VGND sky130_ef_sc_hd__decap_12
XTAP_TAPCELL_ROW_75_1388 VGND VPWR sky130_fd_sc_hd__tapvpwrvgnd_1
XFILLER_68_108 VPWR VGND VPWR VGND sky130_ef_sc_hd__decap_12
X_11105_ net510 net502 net287 VGND VGND VPWR VPWR _03770_ sky130_fd_sc_hd__and3_1
X_12085_ net454 net392 net390 net464 VGND VGND VPWR VPWR _04835_ sky130_fd_sc_hd__a22o_1
XFILLER_76_141 VGND VGND VPWR VPWR sky130_fd_sc_hd__decap_3
X_11036_ _03692_ _03693_ _03592_ VGND VGND VPWR VPWR _03695_ sky130_fd_sc_hd__o21ai_1
XFILLER_77_697 VGND VGND VPWR VPWR sky130_fd_sc_hd__decap_4
XFILLER_49_399 VPWR VGND VPWR VGND sky130_ef_sc_hd__decap_12
XFILLER_37_539 VGND VGND VPWR VPWR sky130_fd_sc_hd__fill_1
XFILLER_92_645 VPWR VGND VPWR VGND sky130_ef_sc_hd__decap_12
XFILLER_92_678 VGND VGND VPWR VPWR sky130_fd_sc_hd__decap_6
X_12987_ _05818_ _05819_ VGND VGND VPWR VPWR _05820_ sky130_fd_sc_hd__nor2_1
XFILLER_45_572 VGND VGND VPWR VPWR sky130_fd_sc_hd__decap_3
XFILLER_45_561 VGND VGND VPWR VPWR sky130_fd_sc_hd__fill_1
X_11938_ net470 net391 _04673_ VGND VGND VPWR VPWR _04676_ sky130_fd_sc_hd__and3_1
XFILLER_60_520 VPWR VGND VPWR VGND sky130_ef_sc_hd__decap_12
X_11869_ _04601_ _04603_ VGND VGND VPWR VPWR _04604_ sky130_fd_sc_hd__nor2_1
X_13608_ _06333_ _06428_ _06429_ VGND VGND VPWR VPWR _06498_ sky130_fd_sc_hd__o21a_1
X_13539_ _06422_ _06420_ VGND VGND VPWR VPWR _06423_ sky130_fd_sc_hd__and2b_1
X_07060_ _03937_ net239 _03893_ _03904_ VGND VGND VPWR VPWR _03992_ sky130_fd_sc_hd__o211ai_4
XFILLER_9_473 VPWR VGND VPWR VGND sky130_ef_sc_hd__decap_12
Xoutput225 net225 VGND VGND VPWR VPWR y3[5] sky130_fd_sc_hd__buf_2
Xoutput203 net203 VGND VGND VPWR VPWR y2[16] sky130_fd_sc_hd__buf_2
Xoutput214 net214 VGND VGND VPWR VPWR y3[10] sky130_fd_sc_hd__buf_2
XFILLER_114_555 VPWR VGND VPWR VGND sky130_ef_sc_hd__decap_12
XFILLER_5_690 VGND VGND VPWR VPWR sky130_fd_sc_hd__fill_1
XTAP_TAPCELL_ROW_130_2183 VGND VPWR sky130_fd_sc_hd__tapvpwrvgnd_1
XFILLER_101_205 VPWR VGND VPWR VGND sky130_ef_sc_hd__decap_12
X_09701_ net333 net413 VGND VGND VPWR VPWR _02242_ sky130_fd_sc_hd__and2b_1
X_07962_ _00437_ _00438_ VGND VGND VPWR VPWR _00439_ sky130_fd_sc_hd__xor2_1
XFILLER_68_642 VGND VGND VPWR VPWR sky130_fd_sc_hd__fill_2
X_06913_ _01802_ _01867_ _02369_ VGND VGND VPWR VPWR _02391_ sky130_fd_sc_hd__and3_1
X_07893_ _00369_ _00370_ VGND VGND VPWR VPWR _00371_ sky130_fd_sc_hd__xnor2_1
XFILLER_56_804 VGND VGND VPWR VPWR sky130_fd_sc_hd__decap_8
X_09632_ _02164_ _02165_ VGND VGND VPWR VPWR _02167_ sky130_fd_sc_hd__xor2_1
X_06844_ net467 net672 _01616_ VGND VGND VPWR VPWR _01638_ sky130_fd_sc_hd__a21oi_1
X_09563_ net418 net335 _01955_ _01953_ VGND VGND VPWR VPWR _02091_ sky130_fd_sc_hd__a31o_1
XFILLER_130_27 VGND VGND VPWR VPWR sky130_fd_sc_hd__fill_1
XTAP_TAPCELL_ROW_104_1805 VGND VPWR sky130_fd_sc_hd__tapvpwrvgnd_1
X_08514_ _00984_ _00985_ VGND VGND VPWR VPWR _00986_ sky130_fd_sc_hd__xnor2_1
X_09494_ _01866_ _02015_ VGND VGND VPWR VPWR _02016_ sky130_fd_sc_hd__xnor2_1
XFILLER_63_391 VGND VGND VPWR VPWR sky130_fd_sc_hd__fill_1
XFILLER_51_531 VGND VGND VPWR VPWR sky130_fd_sc_hd__fill_1
XFILLER_23_222 VGND VGND VPWR VPWR sky130_fd_sc_hd__fill_2
XFILLER_24_734 VGND VGND VPWR VPWR sky130_fd_sc_hd__fill_1
X_08445_ _00910_ _00917_ VGND VGND VPWR VPWR _00918_ sky130_fd_sc_hd__and2b_1
XFILLER_24_767 VPWR VGND VPWR VGND sky130_ef_sc_hd__decap_12
X_08376_ _00847_ _00848_ VGND VGND VPWR VPWR _00850_ sky130_fd_sc_hd__xnor2_1
XFILLER_11_417 VPWR VGND VPWR VGND sky130_ef_sc_hd__decap_12
XTAP_TAPCELL_ROW_34_795 VGND VPWR sky130_fd_sc_hd__tapvpwrvgnd_1
XFILLER_109_305 VPWR VGND VPWR VGND sky130_ef_sc_hd__decap_12
X_07327_ _05308_ _05330_ _06556_ _06557_ VGND VGND VPWR VPWR _06558_ sky130_fd_sc_hd__o211a_1
XFILLER_99_18 VPWR VGND VPWR VGND sky130_ef_sc_hd__decap_12
XFILLER_137_669 VGND VGND VPWR VPWR sky130_fd_sc_hd__decap_3
XFILLER_125_809 VGND VGND VPWR VPWR sky130_fd_sc_hd__decap_8
X_07258_ net519 net681 net677 net526 VGND VGND VPWR VPWR _06149_ sky130_fd_sc_hd__a22o_1
X_07189_ _04547_ _05363_ _05385_ VGND VGND VPWR VPWR _05395_ sky130_fd_sc_hd__nor3_1
XFILLER_117_393 VPWR VGND VPWR VGND sky130_ef_sc_hd__decap_12
XTAP_TAPCELL_ROW_115_1967 VGND VPWR sky130_fd_sc_hd__tapvpwrvgnd_1
XFILLER_132_363 VGND VGND VPWR VPWR sky130_fd_sc_hd__fill_1
XFILLER_120_503 VPWR VGND VPWR VGND sky130_ef_sc_hd__decap_12
XFILLER_78_417 VGND VGND VPWR VPWR sky130_fd_sc_hd__decap_3
XFILLER_132_385 VPWR VGND VPWR VGND sky130_ef_sc_hd__decap_12
XFILLER_120_547 VGND VGND VPWR VPWR sky130_fd_sc_hd__fill_1
Xfanout430 net432 VGND VGND VPWR VPWR net430 sky130_fd_sc_hd__clkbuf_4
Xfanout441 net158 VGND VGND VPWR VPWR net441 sky130_fd_sc_hd__clkbuf_4
Xfanout463 net464 VGND VGND VPWR VPWR net463 sky130_fd_sc_hd__buf_2
Xfanout474 net477 VGND VGND VPWR VPWR net474 sky130_fd_sc_hd__buf_2
Xfanout452 net156 VGND VGND VPWR VPWR net452 sky130_fd_sc_hd__clkbuf_4
Xfanout496 net498 VGND VGND VPWR VPWR net496 sky130_fd_sc_hd__buf_2
XFILLER_101_783 VGND VGND VPWR VPWR sky130_fd_sc_hd__fill_1
X_12910_ _05616_ _05618_ _05734_ VGND VGND VPWR VPWR _05736_ sky130_fd_sc_hd__and3_1
XFILLER_48_77 VGND VGND VPWR VPWR sky130_fd_sc_hd__decap_6
XFILLER_46_314 VGND VGND VPWR VPWR sky130_fd_sc_hd__decap_6
Xfanout485 net486 VGND VGND VPWR VPWR net485 sky130_fd_sc_hd__clkbuf_4
XFILLER_74_645 VGND VGND VPWR VPWR sky130_fd_sc_hd__decap_4
X_12841_ _05512_ _05520_ _05519_ VGND VGND VPWR VPWR _05661_ sky130_fd_sc_hd__a21oi_1
XPHY_EDGE_ROW_61_Left_200 VGND VGND VPWR VPWR sky130_fd_sc_hd__decap_3
XFILLER_46_336 VGND VGND VPWR VPWR sky130_fd_sc_hd__decap_3
XFILLER_0_29 VPWR VGND VPWR VGND sky130_ef_sc_hd__decap_12
XFILLER_104_83 VGND VGND VPWR VPWR sky130_fd_sc_hd__fill_1
X_12772_ _05583_ _05584_ VGND VGND VPWR VPWR _05585_ sky130_fd_sc_hd__and2_1
XFILLER_64_65 VGND VGND VPWR VPWR sky130_fd_sc_hd__decap_8
XFILLER_9_27 VPWR VGND VPWR VGND sky130_ef_sc_hd__decap_12
X_11723_ _04434_ _04443_ VGND VGND VPWR VPWR _04444_ sky130_fd_sc_hd__and2b_1
XFILLER_14_277 VGND VGND VPWR VPWR sky130_fd_sc_hd__fill_1
X_11654_ _04105_ _04368_ VGND VGND VPWR VPWR _04369_ sky130_fd_sc_hd__xor2_2
XFILLER_80_53 VPWR VGND VPWR VGND sky130_ef_sc_hd__decap_12
X_10605_ _03083_ _03221_ VGND VGND VPWR VPWR _03223_ sky130_fd_sc_hd__and2_1
XFILLER_128_636 VGND VGND VPWR VPWR sky130_fd_sc_hd__fill_1
XFILLER_6_410 VGND VGND VPWR VPWR sky130_fd_sc_hd__decap_6
X_11585_ _04023_ _04292_ VGND VGND VPWR VPWR _04294_ sky130_fd_sc_hd__xnor2_4
XTAP_TAPCELL_ROW_12_467 VGND VPWR sky130_fd_sc_hd__tapvpwrvgnd_1
XTAP_TAPCELL_ROW_12_478 VGND VPWR sky130_fd_sc_hd__tapvpwrvgnd_1
X_13324_ _06186_ _06187_ VGND VGND VPWR VPWR _06188_ sky130_fd_sc_hd__nor2_1
XTAP_TAPCELL_ROW_77_1417 VGND VPWR sky130_fd_sc_hd__tapvpwrvgnd_1
XFILLER_6_421 VGND VGND VPWR VPWR sky130_fd_sc_hd__fill_2
X_10536_ _02973_ _02976_ _03147_ VGND VGND VPWR VPWR _03148_ sky130_fd_sc_hd__a21o_1
XFILLER_136_680 VPWR VGND VPWR VGND sky130_ef_sc_hd__decap_12
XFILLER_115_308 VPWR VGND VPWR VGND sky130_ef_sc_hd__decap_12
XPHY_EDGE_ROW_108_Right_108 VGND VGND VPWR VPWR sky130_fd_sc_hd__decap_3
X_13255_ net606 net303 VGND VGND VPWR VPWR _06113_ sky130_fd_sc_hd__nand2_1
X_10467_ _03069_ _03071_ _02883_ VGND VGND VPWR VPWR _03073_ sky130_fd_sc_hd__a21o_1
XFILLER_135_190 VGND VGND VPWR VPWR sky130_fd_sc_hd__decap_8
XTAP_TAPCELL_ROW_90_1606 VGND VPWR sky130_fd_sc_hd__tapvpwrvgnd_1
X_12206_ _04965_ _04966_ VGND VGND VPWR VPWR _04967_ sky130_fd_sc_hd__or2_1
XFILLER_111_503 VGND VGND VPWR VPWR sky130_fd_sc_hd__fill_1
X_13186_ net539 net422 net500 net265 VGND VGND VPWR VPWR _06037_ sky130_fd_sc_hd__o2bb2a_1
X_10398_ _02990_ _02991_ _02996_ VGND VGND VPWR VPWR _02998_ sky130_fd_sc_hd__nand3_1
XFILLER_97_737 VGND VGND VPWR VPWR sky130_fd_sc_hd__fill_1
X_12137_ _04887_ _04889_ _04847_ VGND VGND VPWR VPWR _04892_ sky130_fd_sc_hd__o21a_1
X_12068_ net529 net523 net398 net400 VGND VGND VPWR VPWR _04817_ sky130_fd_sc_hd__and4_1
XFILLER_1_181 VGND VGND VPWR VPWR sky130_fd_sc_hd__fill_1
X_11019_ _03673_ _03674_ _03668_ VGND VGND VPWR VPWR _03677_ sky130_fd_sc_hd__a21o_1
XTAP_TAPCELL_ROW_88_1568 VGND VPWR sky130_fd_sc_hd__tapvpwrvgnd_1
XFILLER_65_645 VGND VGND VPWR VPWR sky130_fd_sc_hd__fill_2
XTAP_TAPCELL_ROW_88_1579 VGND VPWR sky130_fd_sc_hd__tapvpwrvgnd_1
X_08230_ net252 _00703_ VGND VGND VPWR VPWR _00705_ sky130_fd_sc_hd__xnor2_1
XTAP_TAPCELL_ROW_119_2023 VGND VPWR sky130_fd_sc_hd__tapvpwrvgnd_1
XTAP_TAPCELL_ROW_31_743 VGND VPWR sky130_fd_sc_hd__tapvpwrvgnd_1
X_08161_ _00628_ _00635_ VGND VGND VPWR VPWR _00637_ sky130_fd_sc_hd__xnor2_1
XTAP_TAPCELL_ROW_31_754 VGND VPWR sky130_fd_sc_hd__tapvpwrvgnd_1
XTAP_TAPCELL_ROW_132_2212 VGND VPWR sky130_fd_sc_hd__tapvpwrvgnd_1
XFILLER_107_809 VPWR VGND VPWR VGND sky130_ef_sc_hd__decap_12
X_07112_ _02151_ _02499_ _03041_ _03063_ _02997_ VGND VGND VPWR VPWR _04558_ sky130_fd_sc_hd__o32ai_1
XFILLER_9_281 VGND VGND VPWR VPWR sky130_fd_sc_hd__decap_3
X_08092_ net545 _00299_ VGND VGND VPWR VPWR _00568_ sky130_fd_sc_hd__nand2_2
XFILLER_133_105 VGND VGND VPWR VPWR sky130_fd_sc_hd__decap_6
XFILLER_109_39 VPWR VGND VPWR VGND sky130_ef_sc_hd__decap_12
X_07043_ _02020_ _03697_ _03784_ VGND VGND VPWR VPWR _03806_ sky130_fd_sc_hd__nand3_2
XFILLER_114_363 VGND VGND VPWR VPWR sky130_fd_sc_hd__fill_1
XFILLER_125_27 VPWR VGND VPWR VGND sky130_ef_sc_hd__decap_12
X_08994_ net625 net374 net37 net633 VGND VGND VPWR VPWR _01471_ sky130_fd_sc_hd__a22o_1
XFILLER_88_748 VGND VGND VPWR VPWR sky130_fd_sc_hd__decap_8
XFILLER_87_225 VGND VGND VPWR VPWR sky130_fd_sc_hd__decap_4
XFILLER_102_569 VPWR VGND VPWR VGND sky130_ef_sc_hd__decap_12
XFILLER_87_247 VGND VGND VPWR VPWR sky130_fd_sc_hd__decap_3
X_07945_ _00292_ _00422_ VGND VGND VPWR VPWR _00423_ sky130_fd_sc_hd__xnor2_2
XTAP_TAPCELL_ROW_110_1897 VGND VPWR sky130_fd_sc_hd__tapvpwrvgnd_1
XFILLER_56_612 VPWR VGND VPWR VGND sky130_ef_sc_hd__decap_12
XFILLER_56_601 VGND VGND VPWR VPWR sky130_fd_sc_hd__decap_4
X_09615_ _02147_ _02146_ VGND VGND VPWR VPWR _02148_ sky130_fd_sc_hd__and2b_1
XFILLER_56_645 VPWR VGND VPWR VGND sky130_ef_sc_hd__decap_12
X_07876_ _06804_ _00353_ VGND VGND VPWR VPWR _00354_ sky130_fd_sc_hd__xnor2_1
XFILLER_55_111 VGND VGND VPWR VPWR sky130_fd_sc_hd__fill_1
XFILLER_28_325 VGND VGND VPWR VPWR sky130_fd_sc_hd__fill_1
XFILLER_83_453 VGND VGND VPWR VPWR sky130_fd_sc_hd__fill_1
X_06827_ net404 VGND VGND VPWR VPWR _01453_ sky130_fd_sc_hd__inv_2
XFILLER_55_144 VGND VGND VPWR VPWR sky130_fd_sc_hd__fill_1
XTAP_TAPCELL_ROW_39_865 VGND VPWR sky130_fd_sc_hd__tapvpwrvgnd_1
X_09546_ _02032_ _02071_ VGND VGND VPWR VPWR _02072_ sky130_fd_sc_hd__nand2b_1
XFILLER_55_188 VGND VGND VPWR VPWR sky130_fd_sc_hd__fill_1
X_09477_ _01993_ _01994_ VGND VGND VPWR VPWR _01997_ sky130_fd_sc_hd__xnor2_1
XFILLER_12_704 VGND VGND VPWR VPWR sky130_fd_sc_hd__decap_4
XFILLER_24_564 VGND VGND VPWR VPWR sky130_fd_sc_hd__decap_6
X_08428_ _00743_ _00900_ VGND VGND VPWR VPWR _00901_ sky130_fd_sc_hd__or2_1
XFILLER_51_350 VGND VGND VPWR VPWR sky130_fd_sc_hd__decap_8
XFILLER_11_203 VGND VGND VPWR VPWR sky130_fd_sc_hd__decap_6
XFILLER_11_214 VGND VGND VPWR VPWR sky130_fd_sc_hd__decap_8
X_08359_ _00826_ _00832_ VGND VGND VPWR VPWR _00833_ sky130_fd_sc_hd__and2b_1
Xclkload1 clknet_3_1__leaf_clk VGND VGND VPWR VPWR clkload1/Y sky130_fd_sc_hd__bufinv_16
X_11370_ _04056_ _04058_ VGND VGND VPWR VPWR _04060_ sky130_fd_sc_hd__and2_1
XFILLER_20_781 VPWR VGND VPWR VGND sky130_ef_sc_hd__decap_12
XFILLER_119_3 VPWR VGND VPWR VGND sky130_ef_sc_hd__decap_12
X_10321_ _02911_ _02912_ VGND VGND VPWR VPWR _02913_ sky130_fd_sc_hd__nor2_1
XFILLER_118_691 VGND VGND VPWR VPWR sky130_fd_sc_hd__decap_8
X_13040_ _05877_ _05878_ VGND VGND VPWR VPWR _05879_ sky130_fd_sc_hd__nor2_1
XTAP_TAPCELL_ROW_59_1158 VGND VPWR sky130_fd_sc_hd__tapvpwrvgnd_1
XFILLER_105_352 VPWR VGND VPWR VGND sky130_ef_sc_hd__decap_12
XFILLER_1_3 VPWR VGND VPWR VGND sky130_ef_sc_hd__decap_12
X_10252_ net654 net643 net325 net323 VGND VGND VPWR VPWR _02838_ sky130_fd_sc_hd__and4_1
X_10183_ _02122_ _02596_ _02515_ VGND VGND VPWR VPWR _02766_ sky130_fd_sc_hd__mux2_1
XTAP_TAPCELL_ROW_72_1347 VGND VPWR sky130_fd_sc_hd__tapvpwrvgnd_1
XTAP_TAPCELL_ROW_72_1336 VGND VPWR sky130_fd_sc_hd__tapvpwrvgnd_1
XFILLER_59_54 VGND VGND VPWR VPWR sky130_fd_sc_hd__fill_2
Xfanout260 _01376_ VGND VGND VPWR VPWR net260 sky130_fd_sc_hd__clkbuf_2
XFILLER_120_377 VPWR VGND VPWR VGND sky130_ef_sc_hd__decap_12
Xfanout282 net91 VGND VGND VPWR VPWR net282 sky130_fd_sc_hd__dlymetal6s2s_1
Xfanout271 net97 VGND VGND VPWR VPWR net271 sky130_fd_sc_hd__buf_1
XFILLER_115_93 VPWR VGND VPWR VGND sky130_ef_sc_hd__decap_12
XFILLER_75_31 VPWR VGND VPWR VGND sky130_ef_sc_hd__decap_12
XFILLER_47_634 VPWR VGND VPWR VGND sky130_ef_sc_hd__decap_12
Xfanout293 net85 VGND VGND VPWR VPWR net293 sky130_fd_sc_hd__buf_2
XFILLER_74_453 VGND VGND VPWR VPWR sky130_fd_sc_hd__decap_6
X_12824_ net420 net389 _05492_ _05491_ VGND VGND VPWR VPWR _05642_ sky130_fd_sc_hd__a31o_1
XFILLER_131_81 VPWR VGND VPWR VGND sky130_ef_sc_hd__decap_12
X_12755_ _05391_ _05389_ _05390_ VGND VGND VPWR VPWR _05567_ sky130_fd_sc_hd__o21ba_4
XFILLER_61_169 VPWR VGND VPWR VGND sky130_ef_sc_hd__decap_12
XTAP_TAPCELL_ROW_17_548 VGND VPWR sky130_fd_sc_hd__tapvpwrvgnd_1
XTAP_TAPCELL_ROW_83_1498 VGND VPWR sky130_fd_sc_hd__tapvpwrvgnd_1
XFILLER_70_681 VPWR VGND VPWR VGND sky130_ef_sc_hd__decap_12
XFILLER_42_361 VGND VGND VPWR VPWR sky130_fd_sc_hd__decap_3
X_11706_ _04290_ _04293_ _04424_ VGND VGND VPWR VPWR _04426_ sky130_fd_sc_hd__nand3_1
XFILLER_30_501 VGND VGND VPWR VPWR sky130_fd_sc_hd__decap_4
X_12686_ net437 net384 net388 net430 VGND VGND VPWR VPWR _05492_ sky130_fd_sc_hd__a22o_1
XFILLER_30_589 VPWR VGND VPWR VGND sky130_ef_sc_hd__decap_12
X_11637_ net609 _04119_ _04117_ VGND VGND VPWR VPWR _04350_ sky130_fd_sc_hd__a21o_1
XFILLER_128_444 VGND VGND VPWR VPWR sky130_fd_sc_hd__fill_1
XFILLER_128_433 VGND VGND VPWR VPWR sky130_fd_sc_hd__decap_4
XFILLER_7_741 VPWR VGND VPWR VGND sky130_ef_sc_hd__decap_12
X_11568_ _04138_ _04139_ _04141_ VGND VGND VPWR VPWR _04276_ sky130_fd_sc_hd__o21a_1
XFILLER_128_477 VPWR VGND VPWR VGND sky130_ef_sc_hd__decap_12
X_13307_ _05887_ _06026_ _06169_ VGND VGND VPWR VPWR _06170_ sky130_fd_sc_hd__o21ai_1
XFILLER_7_785 VPWR VGND VPWR VGND sky130_ef_sc_hd__decap_12
X_10519_ _02980_ _03129_ VGND VGND VPWR VPWR _03130_ sky130_fd_sc_hd__xnor2_1
XFILLER_115_116 VPWR VGND VPWR VGND sky130_ef_sc_hd__decap_12
X_11499_ _04047_ _04055_ _04054_ VGND VGND VPWR VPWR _04201_ sky130_fd_sc_hd__a21bo_1
XFILLER_131_609 VGND VGND VPWR VPWR sky130_fd_sc_hd__decap_6
X_13238_ _05951_ _05959_ _05958_ VGND VGND VPWR VPWR _06095_ sky130_fd_sc_hd__a21oi_1
X_13169_ _06017_ _06019_ VGND VGND VPWR VPWR _06020_ sky130_fd_sc_hd__nor2_1
XFILLER_69_225 VPWR VGND VPWR VGND sky130_ef_sc_hd__decap_12
XFILLER_34_3 VPWR VGND VPWR VGND sky130_ef_sc_hd__decap_12
XFILLER_111_355 VGND VGND VPWR VPWR sky130_fd_sc_hd__fill_1
XFILLER_85_729 VGND VGND VPWR VPWR sky130_fd_sc_hd__fill_1
X_07730_ net671 net417 _00071_ _00070_ VGND VGND VPWR VPWR _00209_ sky130_fd_sc_hd__a31o_1
XFILLER_37_111 VGND VGND VPWR VPWR sky130_fd_sc_hd__fill_1
XFILLER_38_645 VGND VGND VPWR VPWR sky130_fd_sc_hd__decap_8
X_07661_ _00139_ _00140_ VGND VGND VPWR VPWR _00141_ sky130_fd_sc_hd__nor2_1
X_09400_ net488 net481 net347 net348 VGND VGND VPWR VPWR _01914_ sky130_fd_sc_hd__and4_1
XFILLER_111_18 VPWR VGND VPWR VGND sky130_ef_sc_hd__decap_12
XFILLER_80_412 VGND VGND VPWR VPWR sky130_fd_sc_hd__decap_8
XFILLER_65_497 VGND VGND VPWR VPWR sky130_fd_sc_hd__decap_6
X_07592_ _00070_ _00071_ VGND VGND VPWR VPWR _00072_ sky130_fd_sc_hd__and2b_1
XTAP_TAPCELL_ROW_36_824 VGND VPWR sky130_fd_sc_hd__tapvpwrvgnd_1
X_09331_ _01659_ _01662_ _01837_ _01838_ VGND VGND VPWR VPWR _01839_ sky130_fd_sc_hd__o211a_1
XFILLER_80_445 VGND VGND VPWR VPWR sky130_fd_sc_hd__decap_8
XPHY_EDGE_ROW_9_Left_148 VGND VGND VPWR VPWR sky130_fd_sc_hd__decap_3
XFILLER_80_489 VGND VGND VPWR VPWR sky130_fd_sc_hd__decap_6
XFILLER_21_512 VGND VGND VPWR VPWR sky130_fd_sc_hd__decap_8
XFILLER_40_309 VGND VGND VPWR VPWR sky130_fd_sc_hd__decap_3
X_09262_ _01590_ _01593_ VGND VGND VPWR VPWR _01763_ sky130_fd_sc_hd__nand2_1
XFILLER_60_180 VPWR VGND VPWR VGND sky130_ef_sc_hd__decap_12
X_09193_ _01528_ _01546_ _01544_ VGND VGND VPWR VPWR _01687_ sky130_fd_sc_hd__o21a_1
X_08213_ _00592_ _00594_ _00686_ VGND VGND VPWR VPWR _00688_ sky130_fd_sc_hd__or3b_1
X_08144_ _00596_ _00619_ VGND VGND VPWR VPWR _00620_ sky130_fd_sc_hd__xor2_2
XFILLER_107_617 VGND VGND VPWR VPWR sky130_fd_sc_hd__decap_3
XFILLER_20_15 VPWR VGND VPWR VGND sky130_ef_sc_hd__decap_12
XFILLER_136_15 VPWR VGND VPWR VGND sky130_ef_sc_hd__decap_12
X_08075_ _00549_ _00550_ VGND VGND VPWR VPWR _00552_ sky130_fd_sc_hd__xor2_2
XTAP_TAPCELL_ROW_112_1926 VGND VPWR sky130_fd_sc_hd__tapvpwrvgnd_1
X_07026_ _03522_ _03533_ _03598_ VGND VGND VPWR VPWR _03620_ sky130_fd_sc_hd__a21o_1
XFILLER_130_653 VPWR VGND VPWR VGND sky130_ef_sc_hd__decap_12
XFILLER_130_642 VGND VGND VPWR VPWR sky130_fd_sc_hd__fill_2
XFILLER_102_333 VPWR VGND VPWR VGND sky130_ef_sc_hd__decap_12
XFILLER_88_567 VGND VGND VPWR VPWR sky130_fd_sc_hd__fill_1
XFILLER_88_545 VGND VGND VPWR VPWR sky130_fd_sc_hd__decap_3
XTAP_TAPCELL_ROW_54_1077 VGND VPWR sky130_fd_sc_hd__tapvpwrvgnd_1
X_08977_ _01299_ _01301_ _01300_ VGND VGND VPWR VPWR _01452_ sky130_fd_sc_hd__o21bai_1
XFILLER_102_377 VPWR VGND VPWR VGND sky130_ef_sc_hd__decap_12
XFILLER_88_589 VGND VGND VPWR VPWR sky130_fd_sc_hd__fill_2
XTAP_TAPCELL_ROW_54_1088 VGND VPWR sky130_fd_sc_hd__tapvpwrvgnd_1
XFILLER_29_57 VGND VGND VPWR VPWR sky130_fd_sc_hd__fill_1
X_07928_ _00403_ _00404_ VGND VGND VPWR VPWR _00406_ sky130_fd_sc_hd__xnor2_2
XFILLER_83_250 VPWR VGND VPWR VGND sky130_ef_sc_hd__decap_12
XFILLER_56_475 VGND VGND VPWR VPWR sky130_fd_sc_hd__fill_1
X_07859_ net682 net681 net484 net475 VGND VGND VPWR VPWR _00337_ sky130_fd_sc_hd__and4_1
XFILLER_16_306 VGND VGND VPWR VPWR sky130_fd_sc_hd__fill_2
XFILLER_43_125 VPWR VGND VPWR VGND sky130_ef_sc_hd__decap_12
X_10870_ _03452_ _03512_ VGND VGND VPWR VPWR _03514_ sky130_fd_sc_hd__xnor2_1
X_09529_ _01892_ net250 _01896_ VGND VGND VPWR VPWR _02054_ sky130_fd_sc_hd__a21o_1
XFILLER_43_147 VGND VGND VPWR VPWR sky130_fd_sc_hd__decap_3
XFILLER_43_169 VGND VGND VPWR VPWR sky130_fd_sc_hd__fill_1
XTAP_TAPCELL_ROW_14_507 VGND VPWR sky130_fd_sc_hd__tapvpwrvgnd_1
XFILLER_24_361 VGND VGND VPWR VPWR sky130_fd_sc_hd__decap_3
XFILLER_40_810 VGND VGND VPWR VPWR sky130_fd_sc_hd__fill_2
XFILLER_129_208 VPWR VGND VPWR VGND sky130_ef_sc_hd__decap_12
X_12540_ _05331_ _05332_ VGND VGND VPWR VPWR _05333_ sky130_fd_sc_hd__nor2_1
X_12471_ net489 net402 net401 net497 VGND VGND VPWR VPWR _05257_ sky130_fd_sc_hd__a22o_1
XFILLER_137_230 VGND VGND VPWR VPWR sky130_fd_sc_hd__fill_1
X_11422_ net627 net618 net314 VGND VGND VPWR VPWR _04117_ sky130_fd_sc_hd__and3_1
XFILLER_138_797 VPWR VGND VPWR VGND sky130_ef_sc_hd__decap_12
X_11353_ _04034_ _04039_ VGND VGND VPWR VPWR _04041_ sky130_fd_sc_hd__xnor2_1
XFILLER_4_711 VPWR VGND VPWR VGND sky130_ef_sc_hd__decap_12
XFILLER_106_661 VPWR VGND VPWR VGND sky130_ef_sc_hd__decap_12
XFILLER_4_755 VGND VGND VPWR VPWR sky130_fd_sc_hd__fill_1
XFILLER_3_221 VGND VGND VPWR VPWR sky130_fd_sc_hd__decap_3
X_10304_ _02859_ _02893_ VGND VGND VPWR VPWR _02894_ sky130_fd_sc_hd__nor2_1
X_11284_ _03960_ _03965_ VGND VGND VPWR VPWR _03966_ sky130_fd_sc_hd__xnor2_1
XFILLER_79_534 VGND VGND VPWR VPWR sky130_fd_sc_hd__fill_2
XFILLER_79_523 VGND VGND VPWR VPWR sky130_fd_sc_hd__fill_1
X_13023_ _05677_ _05708_ _05707_ VGND VGND VPWR VPWR _05860_ sky130_fd_sc_hd__a21o_1
XFILLER_3_265 VPWR VGND VPWR VGND sky130_ef_sc_hd__decap_12
X_10235_ _02816_ _02817_ _02819_ VGND VGND VPWR VPWR _02820_ sky130_fd_sc_hd__and3_1
XFILLER_121_653 VPWR VGND VPWR VGND sky130_ef_sc_hd__decap_12
XFILLER_79_545 VPWR VGND VPWR VGND sky130_ef_sc_hd__decap_12
X_10166_ _02579_ _02670_ _02669_ VGND VGND VPWR VPWR _02748_ sky130_fd_sc_hd__o21a_1
XFILLER_121_686 VPWR VGND VPWR VGND sky130_ef_sc_hd__decap_12
XFILLER_120_141 VPWR VGND VPWR VGND sky130_ef_sc_hd__decap_12
XFILLER_86_41 VPWR VGND VPWR VGND sky130_ef_sc_hd__decap_12
XFILLER_67_729 VPWR VGND VPWR VGND sky130_ef_sc_hd__decap_12
X_10097_ _02671_ _02672_ VGND VGND VPWR VPWR _02673_ sky130_fd_sc_hd__nor2_1
XFILLER_66_239 VGND VGND VPWR VPWR sky130_fd_sc_hd__decap_4
XFILLER_47_431 VGND VGND VPWR VPWR sky130_fd_sc_hd__decap_6
XFILLER_19_111 VGND VGND VPWR VPWR sky130_fd_sc_hd__fill_1
XTAP_TAPCELL_ROW_85_1538 VGND VPWR sky130_fd_sc_hd__tapvpwrvgnd_1
XTAP_TAPCELL_ROW_85_1527 VGND VPWR sky130_fd_sc_hd__tapvpwrvgnd_1
XFILLER_35_648 VGND VGND VPWR VPWR sky130_fd_sc_hd__fill_1
X_12807_ net487 net398 net400 net480 VGND VGND VPWR VPWR _05623_ sky130_fd_sc_hd__a22o_1
XFILLER_43_670 VGND VGND VPWR VPWR sky130_fd_sc_hd__fill_2
XFILLER_22_309 VGND VGND VPWR VPWR sky130_fd_sc_hd__fill_2
X_10999_ _03490_ _03492_ VGND VGND VPWR VPWR _03655_ sky130_fd_sc_hd__nor2_1
X_12738_ _05546_ _05547_ _05488_ VGND VGND VPWR VPWR _05549_ sky130_fd_sc_hd__o21a_1
X_12669_ _05285_ _05473_ VGND VGND VPWR VPWR _05474_ sky130_fd_sc_hd__and2_1
XTAP_TAPCELL_ROW_41_893 VGND VPWR sky130_fd_sc_hd__tapvpwrvgnd_1
XFILLER_129_797 VPWR VGND VPWR VGND sky130_ef_sc_hd__decap_12
Xmax_cap235 _01350_ VGND VGND VPWR VPWR net235 sky130_fd_sc_hd__buf_1
XTAP_TAPCELL_ROW_96_1689 VGND VPWR sky130_fd_sc_hd__tapvpwrvgnd_1
X_08900_ net557 net361 VGND VGND VPWR VPWR _01368_ sky130_fd_sc_hd__nand2_1
X_09880_ _02323_ _02435_ VGND VGND VPWR VPWR _02437_ sky130_fd_sc_hd__xnor2_1
XFILLER_131_417 VPWR VGND VPWR VGND sky130_ef_sc_hd__decap_12
XFILLER_98_821 VGND VGND VPWR VPWR sky130_fd_sc_hd__decap_3
X_08831_ net439 net430 net341 net339 VGND VGND VPWR VPWR _01297_ sky130_fd_sc_hd__and4_1
XFILLER_106_29 VPWR VGND VPWR VGND sky130_ef_sc_hd__decap_12
XFILLER_58_707 VGND VGND VPWR VPWR sky130_fd_sc_hd__fill_1
XTAP_TAPCELL_ROW_127_2144 VGND VPWR sky130_fd_sc_hd__tapvpwrvgnd_1
X_08762_ net566 net42 _01121_ VGND VGND VPWR VPWR _01229_ sky130_fd_sc_hd__a21o_1
XFILLER_85_559 VGND VGND VPWR VPWR sky130_fd_sc_hd__fill_1
XFILLER_57_239 VPWR VGND VPWR VGND sky130_ef_sc_hd__decap_12
X_08693_ _01157_ _01159_ VGND VGND VPWR VPWR _01160_ sky130_fd_sc_hd__and2_1
X_07713_ net682 net684 net484 net477 VGND VGND VPWR VPWR _00192_ sky130_fd_sc_hd__and4_1
XFILLER_93_581 VGND VGND VPWR VPWR sky130_fd_sc_hd__decap_4
X_07644_ _00121_ _00122_ _06705_ _06707_ VGND VGND VPWR VPWR _00124_ sky130_fd_sc_hd__o211ai_2
XTAP_TAPCELL_ROW_0_279 VGND VPWR sky130_fd_sc_hd__tapvpwrvgnd_1
XFILLER_26_659 VGND VGND VPWR VPWR sky130_fd_sc_hd__decap_8
XFILLER_81_798 VGND VGND VPWR VPWR sky130_fd_sc_hd__decap_4
XFILLER_80_253 VGND VGND VPWR VPWR sky130_fd_sc_hd__decap_4
X_07575_ net521 net676 VGND VGND VPWR VPWR _06804_ sky130_fd_sc_hd__nand2_4
XFILLER_15_15 VPWR VGND VPWR VGND sky130_ef_sc_hd__decap_12
XFILLER_22_810 VGND VGND VPWR VPWR sky130_fd_sc_hd__fill_2
XFILLER_25_169 VPWR VGND VPWR VGND sky130_ef_sc_hd__decap_12
X_09314_ net652 net648 net41 VGND VGND VPWR VPWR _01820_ sky130_fd_sc_hd__and3_1
XFILLER_22_821 VGND VGND VPWR VPWR sky130_fd_sc_hd__decap_3
XFILLER_40_139 VGND VGND VPWR VPWR sky130_fd_sc_hd__fill_1
X_09245_ _01600_ _01602_ VGND VGND VPWR VPWR _01744_ sky130_fd_sc_hd__nand2_1
XTAP_TAPCELL_ROW_138_2295 VGND VPWR sky130_fd_sc_hd__tapvpwrvgnd_1
X_09176_ _01438_ _01496_ _01495_ VGND VGND VPWR VPWR _01669_ sky130_fd_sc_hd__a21bo_1
X_08127_ _00601_ _00602_ VGND VGND VPWR VPWR _00603_ sky130_fd_sc_hd__xnor2_1
X_08058_ _00533_ _00534_ VGND VGND VPWR VPWR _00535_ sky130_fd_sc_hd__xnor2_1
XTAP_TAPCELL_ROW_56_1117 VGND VPWR sky130_fd_sc_hd__tapvpwrvgnd_1
XTAP_TAPCELL_ROW_56_1106 VGND VPWR sky130_fd_sc_hd__tapvpwrvgnd_1
X_07009_ _03401_ _03412_ _03390_ VGND VGND VPWR VPWR _03434_ sky130_fd_sc_hd__a21o_1
XFILLER_0_202 VGND VGND VPWR VPWR sky130_fd_sc_hd__decap_4
X_10020_ _02580_ _02588_ VGND VGND VPWR VPWR _02589_ sky130_fd_sc_hd__xnor2_1
Xinput136 x0[6] VGND VGND VPWR VPWR net136 sky130_fd_sc_hd__dlymetal6s2s_1
Xinput103 w30[5] VGND VGND VPWR VPWR net103 sky130_fd_sc_hd__clkbuf_2
Xinput125 w33[3] VGND VGND VPWR VPWR net125 sky130_fd_sc_hd__buf_2
Xinput114 w32[0] VGND VGND VPWR VPWR net114 sky130_fd_sc_hd__clkbuf_4
Xinput158 x3[4] VGND VGND VPWR VPWR net158 sky130_fd_sc_hd__buf_1
XFILLER_103_697 VGND VGND VPWR VPWR sky130_fd_sc_hd__decap_6
XFILLER_48_239 VGND VGND VPWR VPWR sky130_fd_sc_hd__decap_6
Xinput147 x2[1] VGND VGND VPWR VPWR net147 sky130_fd_sc_hd__clkbuf_4
XFILLER_29_420 VGND VGND VPWR VPWR sky130_fd_sc_hd__decap_6
X_11971_ net470 net389 VGND VGND VPWR VPWR _04711_ sky130_fd_sc_hd__nand2_1
XFILLER_57_751 VPWR VGND VPWR VGND sky130_ef_sc_hd__decap_12
XFILLER_29_464 VGND VGND VPWR VPWR sky130_fd_sc_hd__decap_3
XFILLER_56_77 VGND VGND VPWR VPWR sky130_fd_sc_hd__fill_1
X_10922_ net588 net579 net300 VGND VGND VPWR VPWR _03570_ sky130_fd_sc_hd__and3_1
XTAP_TAPCELL_ROW_67_1268 VGND VPWR sky130_fd_sc_hd__tapvpwrvgnd_1
XFILLER_44_434 VGND VGND VPWR VPWR sky130_fd_sc_hd__fill_1
XFILLER_16_136 VGND VGND VPWR VPWR sky130_fd_sc_hd__decap_4
XFILLER_16_147 VGND VGND VPWR VPWR sky130_fd_sc_hd__fill_1
XFILLER_17_659 VPWR VGND VPWR VGND sky130_ef_sc_hd__decap_12
X_13641_ clknet_3_6__leaf_clk _00037_ net716 VGND VGND VPWR VPWR net176 sky130_fd_sc_hd__dfrtp_1
XTAP_TAPCELL_ROW_27_687 VGND VPWR sky130_fd_sc_hd__tapvpwrvgnd_1
X_10853_ _06694_ _03494_ VGND VGND VPWR VPWR _03495_ sky130_fd_sc_hd__and2_1
X_13572_ _06446_ _06458_ VGND VGND VPWR VPWR _06459_ sky130_fd_sc_hd__xnor2_1
XFILLER_72_65 VGND VGND VPWR VPWR sky130_fd_sc_hd__decap_4
XFILLER_12_320 VGND VGND VPWR VPWR sky130_fd_sc_hd__decap_8
XFILLER_13_821 VGND VGND VPWR VPWR sky130_fd_sc_hd__decap_3
X_10784_ _03417_ _03418_ VGND VGND VPWR VPWR _03419_ sky130_fd_sc_hd__and2b_1
XTAP_TAPCELL_ROW_80_1457 VGND VPWR sky130_fd_sc_hd__tapvpwrvgnd_1
X_12523_ _05313_ VGND VGND VPWR VPWR _05314_ sky130_fd_sc_hd__inv_2
XFILLER_8_302 VGND VGND VPWR VPWR sky130_fd_sc_hd__decap_6
XFILLER_8_335 VGND VGND VPWR VPWR sky130_fd_sc_hd__fill_1
XFILLER_138_561 VGND VGND VPWR VPWR sky130_fd_sc_hd__fill_2
XFILLER_126_701 VPWR VGND VPWR VGND sky130_ef_sc_hd__decap_12
X_12454_ net407 net153 VGND VGND VPWR VPWR _05238_ sky130_fd_sc_hd__and2b_1
XFILLER_138_594 VGND VGND VPWR VPWR sky130_fd_sc_hd__decap_4
XFILLER_126_734 VPWR VGND VPWR VGND sky130_ef_sc_hd__decap_12
X_12385_ _05160_ _05161_ _05016_ VGND VGND VPWR VPWR _05163_ sky130_fd_sc_hd__a21oi_1
X_11405_ _04069_ _04097_ VGND VGND VPWR VPWR _04098_ sky130_fd_sc_hd__and2b_1
XFILLER_4_552 VPWR VGND VPWR VGND sky130_ef_sc_hd__decap_12
X_11336_ _03731_ _03897_ _03896_ VGND VGND VPWR VPWR _04022_ sky130_fd_sc_hd__a21oi_2
XFILLER_113_417 VGND VGND VPWR VPWR sky130_fd_sc_hd__decap_8
XFILLER_99_629 VPWR VGND VPWR VGND sky130_ef_sc_hd__decap_12
XFILLER_98_139 VGND VGND VPWR VPWR sky130_fd_sc_hd__fill_1
X_13006_ _05834_ _05839_ VGND VGND VPWR VPWR _05841_ sky130_fd_sc_hd__xnor2_1
X_11267_ _03933_ _03946_ VGND VGND VPWR VPWR _03947_ sky130_fd_sc_hd__xor2_1
XFILLER_121_461 VGND VGND VPWR VPWR sky130_fd_sc_hd__decap_4
XFILLER_79_375 VGND VGND VPWR VPWR sky130_fd_sc_hd__decap_4
X_11198_ _03870_ _03871_ VGND VGND VPWR VPWR _00025_ sky130_fd_sc_hd__xnor2_1
X_10218_ _02799_ _02800_ _02801_ VGND VGND VPWR VPWR _02803_ sky130_fd_sc_hd__or3_1
XFILLER_39_206 VGND VGND VPWR VPWR sky130_fd_sc_hd__fill_1
X_10149_ _02654_ _02657_ _02729_ VGND VGND VPWR VPWR _02730_ sky130_fd_sc_hd__a21oi_1
XFILLER_94_334 VGND VGND VPWR VPWR sky130_fd_sc_hd__fill_1
XFILLER_67_559 VGND VGND VPWR VPWR sky130_fd_sc_hd__fill_1
XFILLER_39_217 VGND VGND VPWR VPWR sky130_fd_sc_hd__decap_6
XFILLER_54_209 VGND VGND VPWR VPWR sky130_fd_sc_hd__fill_2
XFILLER_63_710 VGND VGND VPWR VPWR sky130_fd_sc_hd__fill_1
XFILLER_47_261 VGND VGND VPWR VPWR sky130_fd_sc_hd__decap_6
XFILLER_63_754 VGND VGND VPWR VPWR sky130_fd_sc_hd__decap_3
XFILLER_62_231 VGND VGND VPWR VPWR sky130_fd_sc_hd__decap_6
XTAP_TAPCELL_ROW_122_2074 VGND VPWR sky130_fd_sc_hd__tapvpwrvgnd_1
XTAP_TAPCELL_ROW_122_2063 VGND VPWR sky130_fd_sc_hd__tapvpwrvgnd_1
XFILLER_62_253 VPWR VGND VPWR VGND sky130_ef_sc_hd__decap_12
XTAP_TAPCELL_ROW_46_963 VGND VPWR sky130_fd_sc_hd__tapvpwrvgnd_1
XFILLER_23_629 VGND VGND VPWR VPWR sky130_fd_sc_hd__decap_6
XFILLER_16_692 VGND VGND VPWR VPWR sky130_fd_sc_hd__decap_8
X_07360_ net591 net688 _06588_ VGND VGND VPWR VPWR _06590_ sky130_fd_sc_hd__and3_1
XPHY_EDGE_ROW_99_Left_238 VGND VGND VPWR VPWR sky130_fd_sc_hd__decap_3
X_09030_ _01233_ _01359_ _01509_ _01510_ VGND VGND VPWR VPWR _01511_ sky130_fd_sc_hd__and4bb_1
XTAP_TAPCELL_ROW_98_1718 VGND VPWR sky130_fd_sc_hd__tapvpwrvgnd_1
X_07291_ _06486_ _06497_ VGND VGND VPWR VPWR _06508_ sky130_fd_sc_hd__nor2_1
XFILLER_31_673 VPWR VGND VPWR VGND sky130_ef_sc_hd__decap_12
XFILLER_30_194 VGND VGND VPWR VPWR sky130_fd_sc_hd__fill_2
XFILLER_116_211 VPWR VGND VPWR VGND sky130_ef_sc_hd__decap_12
XFILLER_117_39 VPWR VGND VPWR VGND sky130_ef_sc_hd__decap_12
X_09932_ _01989_ _01991_ _02390_ VGND VGND VPWR VPWR _02493_ sky130_fd_sc_hd__or3b_2
XFILLER_131_225 VPWR VGND VPWR VGND sky130_ef_sc_hd__decap_12
XFILLER_131_269 VGND VGND VPWR VPWR sky130_fd_sc_hd__decap_8
X_09863_ _02262_ _02418_ VGND VGND VPWR VPWR _02419_ sky130_fd_sc_hd__xor2_1
XFILLER_97_161 VGND VGND VPWR VPWR sky130_fd_sc_hd__decap_6
XFILLER_86_813 VGND VGND VPWR VPWR sky130_fd_sc_hd__decap_6
XFILLER_86_802 VGND VGND VPWR VPWR sky130_fd_sc_hd__decap_8
XFILLER_133_27 VPWR VGND VPWR VGND sky130_ef_sc_hd__decap_12
X_09794_ _02228_ _02230_ _02226_ VGND VGND VPWR VPWR _02343_ sky130_fd_sc_hd__a21o_1
X_08814_ _01277_ _01278_ _01279_ VGND VGND VPWR VPWR _01280_ sky130_fd_sc_hd__and3_1
XFILLER_100_645 VGND VGND VPWR VPWR sky130_fd_sc_hd__fill_2
XFILLER_85_334 VGND VGND VPWR VPWR sky130_fd_sc_hd__fill_2
XTAP_TAPCELL_ROW_51_1036 VGND VPWR sky130_fd_sc_hd__tapvpwrvgnd_1
X_08745_ _01142_ _01210_ _01211_ VGND VGND VPWR VPWR _01212_ sky130_fd_sc_hd__nor3_1
XFILLER_85_389 VGND VGND VPWR VPWR sky130_fd_sc_hd__decap_3
X_08676_ net439 net58 VGND VGND VPWR VPWR _01143_ sky130_fd_sc_hd__nand2_1
XTAP_TAPCELL_ROW_107_1847 VGND VPWR sky130_fd_sc_hd__tapvpwrvgnd_1
XFILLER_53_220 VGND VGND VPWR VPWR sky130_fd_sc_hd__decap_4
XFILLER_38_283 VPWR VGND VPWR VGND sky130_ef_sc_hd__decap_12
X_07627_ _01398_ _00103_ _00104_ _00105_ VGND VGND VPWR VPWR _00107_ sky130_fd_sc_hd__or4_1
XFILLER_54_787 VPWR VGND VPWR VGND sky130_ef_sc_hd__decap_12
XFILLER_53_264 VGND VGND VPWR VPWR sky130_fd_sc_hd__decap_3
X_07558_ net687 net258 VGND VGND VPWR VPWR _06787_ sky130_fd_sc_hd__nor2_1
XFILLER_22_651 VGND VGND VPWR VPWR sky130_fd_sc_hd__decap_8
XTAP_TAPCELL_ROW_24_646 VGND VPWR sky130_fd_sc_hd__tapvpwrvgnd_1
XTAP_TAPCELL_ROW_62_1198 VGND VPWR sky130_fd_sc_hd__tapvpwrvgnd_1
X_07489_ _05963_ _06559_ _06558_ VGND VGND VPWR VPWR _06719_ sky130_fd_sc_hd__o21ba_1
XFILLER_10_813 VGND VGND VPWR VPWR sky130_fd_sc_hd__decap_8
XFILLER_21_172 VGND VGND VPWR VPWR sky130_fd_sc_hd__fill_1
X_09228_ net574 _06762_ _01723_ VGND VGND VPWR VPWR _01726_ sky130_fd_sc_hd__and3_2
XFILLER_108_701 VPWR VGND VPWR VGND sky130_ef_sc_hd__decap_12
XFILLER_107_211 VGND VGND VPWR VPWR sky130_fd_sc_hd__fill_2
X_09159_ _06694_ _01648_ VGND VGND VPWR VPWR _01651_ sky130_fd_sc_hd__xor2_1
XFILLER_5_327 VGND VGND VPWR VPWR sky130_fd_sc_hd__decap_8
XFILLER_107_244 VGND VGND VPWR VPWR sky130_fd_sc_hd__decap_4
X_12170_ _04920_ _04923_ _04922_ VGND VGND VPWR VPWR _04929_ sky130_fd_sc_hd__a21o_1
X_11121_ _03617_ _03787_ VGND VGND VPWR VPWR _03788_ sky130_fd_sc_hd__xnor2_1
XFILLER_1_522 VGND VGND VPWR VPWR sky130_fd_sc_hd__fill_1
XFILLER_131_770 VPWR VGND VPWR VGND sky130_ef_sc_hd__decap_12
XFILLER_89_673 VPWR VGND VPWR VGND sky130_ef_sc_hd__decap_12
XFILLER_77_802 VGND VGND VPWR VPWR sky130_fd_sc_hd__fill_2
X_11052_ _03711_ _03712_ VGND VGND VPWR VPWR _00024_ sky130_fd_sc_hd__nor2_1
XFILLER_1_555 VGND VGND VPWR VPWR sky130_fd_sc_hd__decap_4
X_10003_ _02439_ _02441_ _02570_ VGND VGND VPWR VPWR _02571_ sky130_fd_sc_hd__a21oi_1
XFILLER_67_43 VPWR VGND VPWR VGND sky130_ef_sc_hd__decap_12
XFILLER_49_548 VGND VGND VPWR VPWR sky130_fd_sc_hd__fill_2
XFILLER_1_599 VGND VGND VPWR VPWR sky130_fd_sc_hd__decap_3
XFILLER_92_805 VGND VGND VPWR VPWR sky130_fd_sc_hd__decap_6
XFILLER_76_356 VGND VGND VPWR VPWR sky130_fd_sc_hd__fill_2
XTAP_TAPCELL_ROW_4_360 VGND VPWR sky130_fd_sc_hd__tapvpwrvgnd_1
XFILLER_76_378 VPWR VGND VPWR VGND sky130_ef_sc_hd__decap_12
XFILLER_123_93 VPWR VGND VPWR VGND sky130_ef_sc_hd__decap_12
XFILLER_91_348 VGND VGND VPWR VPWR sky130_fd_sc_hd__fill_1
X_11954_ net583 net711 net695 net593 VGND VGND VPWR VPWR _04693_ sky130_fd_sc_hd__a22o_1
XFILLER_17_423 VGND VGND VPWR VPWR sky130_fd_sc_hd__fill_1
X_11885_ _04619_ _04620_ VGND VGND VPWR VPWR _00018_ sky130_fd_sc_hd__xnor2_1
X_10905_ net552 net306 net305 net560 VGND VGND VPWR VPWR _03551_ sky130_fd_sc_hd__a22o_1
X_13624_ _06442_ _06462_ _06460_ VGND VGND VPWR VPWR _06515_ sky130_fd_sc_hd__a21o_1
XFILLER_72_595 VGND VGND VPWR VPWR sky130_fd_sc_hd__decap_4
XTAP_TAPCELL_ROW_43_922 VGND VPWR sky130_fd_sc_hd__tapvpwrvgnd_1
X_10836_ _03309_ _03474_ VGND VGND VPWR VPWR _03476_ sky130_fd_sc_hd__xor2_1
XFILLER_9_611 VGND VGND VPWR VPWR sky130_fd_sc_hd__decap_4
X_13555_ _06438_ _06439_ VGND VGND VPWR VPWR _06440_ sky130_fd_sc_hd__nand2b_1
XFILLER_12_161 VGND VGND VPWR VPWR sky130_fd_sc_hd__fill_1
X_10767_ _03392_ _03399_ VGND VGND VPWR VPWR _03400_ sky130_fd_sc_hd__nand2_1
XFILLER_13_673 VGND VGND VPWR VPWR sky130_fd_sc_hd__decap_3
XFILLER_40_470 VGND VGND VPWR VPWR sky130_fd_sc_hd__decap_6
X_13486_ _06363_ _06364_ _06182_ VGND VGND VPWR VPWR _06365_ sky130_fd_sc_hd__a21oi_1
X_12506_ net446 net439 net385 net388 VGND VGND VPWR VPWR _05295_ sky130_fd_sc_hd__nand4_1
XFILLER_9_655 VGND VGND VPWR VPWR sky130_fd_sc_hd__fill_1
X_10698_ _03316_ _03323_ _03324_ VGND VGND VPWR VPWR _03326_ sky130_fd_sc_hd__nand3_1
X_12437_ _05217_ _05219_ VGND VGND VPWR VPWR _00036_ sky130_fd_sc_hd__xnor2_1
XFILLER_8_165 VPWR VGND VPWR VGND sky130_ef_sc_hd__decap_12
XFILLER_99_415 VGND VGND VPWR VPWR sky130_fd_sc_hd__decap_8
XTAP_TAPCELL_ROW_93_1648 VGND VPWR sky130_fd_sc_hd__tapvpwrvgnd_1
X_12368_ net420 net393 VGND VGND VPWR VPWR _05145_ sky130_fd_sc_hd__nand2_1
XFILLER_113_225 VPWR VGND VPWR VGND sky130_ef_sc_hd__decap_12
X_12299_ _04934_ _04940_ _05066_ _05067_ VGND VGND VPWR VPWR _05070_ sky130_fd_sc_hd__a22o_1
X_11319_ _04001_ _04002_ VGND VGND VPWR VPWR _04005_ sky130_fd_sc_hd__xnor2_1
XFILLER_68_813 VGND VGND VPWR VPWR sky130_fd_sc_hd__decap_6
XFILLER_122_781 VPWR VGND VPWR VGND sky130_ef_sc_hd__decap_12
XFILLER_67_334 VGND VGND VPWR VPWR sky130_fd_sc_hd__fill_2
XFILLER_67_323 VGND VGND VPWR VPWR sky130_fd_sc_hd__fill_1
X_06860_ _01529_ _01791_ VGND VGND VPWR VPWR _01813_ sky130_fd_sc_hd__nand2_1
XTAP_TAPCELL_ROW_124_2103 VGND VPWR sky130_fd_sc_hd__tapvpwrvgnd_1
X_08530_ net529 net352 VGND VGND VPWR VPWR _01000_ sky130_fd_sc_hd__nand2_1
XFILLER_94_197 VPWR VGND VPWR VGND sky130_ef_sc_hd__decap_12
XFILLER_82_348 VGND VGND VPWR VPWR sky130_fd_sc_hd__decap_8
XFILLER_51_702 VPWR VGND VPWR VGND sky130_ef_sc_hd__decap_12
X_08461_ net251 _00864_ _00861_ VGND VGND VPWR VPWR _00934_ sky130_fd_sc_hd__o21a_1
X_07412_ net668 net444 net436 net125 VGND VGND VPWR VPWR _06642_ sky130_fd_sc_hd__a22o_1
XFILLER_50_201 VPWR VGND VPWR VGND sky130_ef_sc_hd__decap_12
X_08392_ _00481_ _00760_ _00865_ VGND VGND VPWR VPWR _00866_ sky130_fd_sc_hd__o21a_1
XTAP_TAPCELL_ROW_102_1777 VGND VPWR sky130_fd_sc_hd__tapvpwrvgnd_1
X_07343_ _05570_ _05930_ _05952_ VGND VGND VPWR VPWR _06573_ sky130_fd_sc_hd__a21oi_1
XFILLER_10_109 VPWR VGND VPWR VGND sky130_ef_sc_hd__decap_12
XTAP_TAPCELL_ROW_21_605 VGND VPWR sky130_fd_sc_hd__tapvpwrvgnd_1
X_07274_ net672 net670 net436 net426 VGND VGND VPWR VPWR _06323_ sky130_fd_sc_hd__and4_1
XFILLER_12_27 VGND VGND VPWR VPWR sky130_fd_sc_hd__fill_1
XTAP_TAPCELL_ROW_135_2254 VGND VPWR sky130_fd_sc_hd__tapvpwrvgnd_1
XFILLER_128_27 VGND VGND VPWR VPWR sky130_fd_sc_hd__fill_1
X_09013_ _01489_ _01490_ _01332_ _01334_ VGND VGND VPWR VPWR _01492_ sky130_fd_sc_hd__o211ai_2
XFILLER_3_809 VPWR VGND VPWR VGND sky130_ef_sc_hd__decap_12
XFILLER_132_545 VGND VGND VPWR VPWR sky130_fd_sc_hd__fill_1
XFILLER_132_589 VPWR VGND VPWR VGND sky130_ef_sc_hd__decap_12
X_09915_ _02362_ _02368_ _02235_ VGND VGND VPWR VPWR _02474_ sky130_fd_sc_hd__a21o_1
Xfanout601 net137 VGND VGND VPWR VPWR net601 sky130_fd_sc_hd__clkbuf_4
Xfanout623 net626 VGND VGND VPWR VPWR net623 sky130_fd_sc_hd__clkbuf_2
Xfanout612 net617 VGND VGND VPWR VPWR net612 sky130_fd_sc_hd__clkbuf_4
Xfanout634 net635 VGND VGND VPWR VPWR net634 sky130_fd_sc_hd__buf_2
X_09846_ _02398_ _02399_ VGND VGND VPWR VPWR _02400_ sky130_fd_sc_hd__xnor2_1
XFILLER_86_632 VPWR VGND VPWR VGND sky130_ef_sc_hd__decap_12
Xfanout656 net657 VGND VGND VPWR VPWR net656 sky130_fd_sc_hd__buf_4
Xfanout645 net647 VGND VGND VPWR VPWR net645 sky130_fd_sc_hd__buf_4
Xfanout667 net126 VGND VGND VPWR VPWR net667 sky130_fd_sc_hd__clkbuf_4
XFILLER_100_442 VGND VGND VPWR VPWR sky130_fd_sc_hd__decap_8
Xfanout678 net120 VGND VGND VPWR VPWR net678 sky130_fd_sc_hd__dlymetal6s2s_1
Xfanout689 net112 VGND VGND VPWR VPWR net689 sky130_fd_sc_hd__buf_2
X_09777_ _02204_ _02218_ _02217_ VGND VGND VPWR VPWR _02324_ sky130_fd_sc_hd__o21ai_1
X_06989_ _03194_ _03205_ net122 net443 VGND VGND VPWR VPWR _03215_ sky130_fd_sc_hd__and4bb_1
XFILLER_58_389 VGND VGND VPWR VPWR sky130_fd_sc_hd__decap_3
XFILLER_18_209 VGND VGND VPWR VPWR sky130_fd_sc_hd__decap_3
XTAP_TAPCELL_ROW_29_716 VGND VPWR sky130_fd_sc_hd__tapvpwrvgnd_1
XFILLER_37_57 VPWR VGND VPWR VGND sky130_ef_sc_hd__decap_12
XFILLER_39_570 VPWR VGND VPWR VGND sky130_ef_sc_hd__decap_12
X_08728_ _01185_ _01192_ _01036_ VGND VGND VPWR VPWR _01195_ sky130_fd_sc_hd__a21o_1
XFILLER_73_359 VPWR VGND VPWR VGND sky130_ef_sc_hd__decap_12
XFILLER_73_337 VGND VGND VPWR VPWR sky130_fd_sc_hd__decap_6
X_08659_ net497 net50 VGND VGND VPWR VPWR _01126_ sky130_fd_sc_hd__nand2_1
XFILLER_54_551 VPWR VGND VPWR VGND sky130_ef_sc_hd__decap_12
XTAP_TAPCELL_ROW_64_1227 VGND VPWR sky130_fd_sc_hd__tapvpwrvgnd_1
XFILLER_14_426 VGND VGND VPWR VPWR sky130_fd_sc_hd__fill_2
XFILLER_42_757 VPWR VGND VPWR VGND sky130_ef_sc_hd__decap_12
X_11670_ _04385_ _04386_ VGND VGND VPWR VPWR _04387_ sky130_fd_sc_hd__xnor2_1
X_10621_ _03240_ _03238_ VGND VGND VPWR VPWR _03241_ sky130_fd_sc_hd__and2b_1
XFILLER_127_306 VGND VGND VPWR VPWR sky130_fd_sc_hd__decap_6
X_13340_ _06059_ _06062_ _06204_ VGND VGND VPWR VPWR _06206_ sky130_fd_sc_hd__and3_1
X_10552_ _02987_ _02989_ _02988_ VGND VGND VPWR VPWR _03166_ sky130_fd_sc_hd__a21bo_1
X_13271_ _06129_ _06130_ VGND VGND VPWR VPWR _06131_ sky130_fd_sc_hd__nor2_1
XFILLER_5_113 VPWR VGND VPWR VGND sky130_ef_sc_hd__decap_12
X_12222_ net523 net397 VGND VGND VPWR VPWR _04985_ sky130_fd_sc_hd__and2_1
X_10483_ net568 net309 VGND VGND VPWR VPWR _03090_ sky130_fd_sc_hd__nand2_1
XFILLER_5_179 VPWR VGND VPWR VGND sky130_ef_sc_hd__decap_12
XFILLER_135_383 VGND VGND VPWR VPWR sky130_fd_sc_hd__decap_6
X_12153_ _04769_ _04909_ VGND VGND VPWR VPWR _04910_ sky130_fd_sc_hd__nor2_1
XTAP_TAPCELL_ROW_9_430 VGND VPWR sky130_fd_sc_hd__tapvpwrvgnd_1
XFILLER_111_729 VPWR VGND VPWR VGND sky130_ef_sc_hd__decap_12
XFILLER_78_53 VPWR VGND VPWR VGND sky130_ef_sc_hd__decap_12
X_12084_ net446 net26 VGND VGND VPWR VPWR _04834_ sky130_fd_sc_hd__nand2_1
XTAP_TAPCELL_ROW_75_1389 VGND VPWR sky130_fd_sc_hd__tapvpwrvgnd_1
X_11104_ _03767_ _03768_ VGND VGND VPWR VPWR _03769_ sky130_fd_sc_hd__xnor2_1
XFILLER_104_781 VPWR VGND VPWR VGND sky130_ef_sc_hd__decap_12
X_11035_ _03592_ _03692_ _03693_ VGND VGND VPWR VPWR _03694_ sky130_fd_sc_hd__or3_1
XFILLER_77_654 VGND VGND VPWR VPWR sky130_fd_sc_hd__fill_2
XFILLER_94_41 VPWR VGND VPWR VGND sky130_ef_sc_hd__decap_12
XFILLER_37_518 VGND VGND VPWR VPWR sky130_fd_sc_hd__fill_1
XFILLER_94_85 VPWR VGND VPWR VGND sky130_ef_sc_hd__decap_12
XFILLER_92_657 VGND VGND VPWR VPWR sky130_fd_sc_hd__fill_1
XFILLER_91_145 VGND VGND VPWR VPWR sky130_fd_sc_hd__decap_6
X_12986_ _05816_ _05817_ net418 net384 VGND VGND VPWR VPWR _05819_ sky130_fd_sc_hd__and4bb_1
XFILLER_76_197 VGND VGND VPWR VPWR sky130_fd_sc_hd__decap_8
XFILLER_64_337 VPWR VGND VPWR VGND sky130_ef_sc_hd__decap_12
XFILLER_80_819 VGND VGND VPWR VPWR sky130_fd_sc_hd__fill_1
XFILLER_17_264 VGND VGND VPWR VPWR sky130_fd_sc_hd__decap_8
X_11937_ net470 net391 VGND VGND VPWR VPWR _04674_ sky130_fd_sc_hd__nand2_1
XFILLER_32_201 VGND VGND VPWR VPWR sky130_fd_sc_hd__fill_1
XFILLER_33_735 VPWR VGND VPWR VGND sky130_ef_sc_hd__decap_12
XFILLER_60_543 VPWR VGND VPWR VGND sky130_ef_sc_hd__decap_12
X_11868_ _04495_ _04528_ _04494_ VGND VGND VPWR VPWR _04603_ sky130_fd_sc_hd__a21oi_1
X_13607_ _06446_ _06495_ VGND VGND VPWR VPWR _06496_ sky130_fd_sc_hd__xor2_1
X_11799_ _04496_ _04525_ VGND VGND VPWR VPWR _04528_ sky130_fd_sc_hd__xnor2_1
X_10819_ net457 net273 VGND VGND VPWR VPWR _03458_ sky130_fd_sc_hd__nand2_1
XFILLER_119_818 VGND VGND VPWR VPWR sky130_fd_sc_hd__decap_6
X_13538_ _06315_ _06316_ _06325_ VGND VGND VPWR VPWR _06422_ sky130_fd_sc_hd__o21a_1
XFILLER_9_441 VGND VGND VPWR VPWR sky130_fd_sc_hd__decap_6
XFILLER_9_485 VPWR VGND VPWR VGND sky130_ef_sc_hd__decap_12
X_13469_ _06261_ _06265_ _06267_ VGND VGND VPWR VPWR _06347_ sky130_fd_sc_hd__o21a_1
XFILLER_126_372 VPWR VGND VPWR VGND sky130_ef_sc_hd__decap_12
XFILLER_99_201 VGND VGND VPWR VPWR sky130_fd_sc_hd__fill_1
Xoutput226 net226 VGND VGND VPWR VPWR y3[6] sky130_fd_sc_hd__buf_2
Xoutput204 net204 VGND VGND VPWR VPWR y2[1] sky130_fd_sc_hd__buf_2
Xoutput215 net215 VGND VGND VPWR VPWR y3[11] sky130_fd_sc_hd__buf_2
XFILLER_99_223 VGND VGND VPWR VPWR sky130_fd_sc_hd__fill_1
XTAP_TAPCELL_ROW_130_2184 VGND VPWR sky130_fd_sc_hd__tapvpwrvgnd_1
XFILLER_114_567 VPWR VGND VPWR VGND sky130_ef_sc_hd__decap_12
XFILLER_59_109 VGND VGND VPWR VPWR sky130_fd_sc_hd__decap_3
X_07961_ net545 net689 VGND VGND VPWR VPWR _00438_ sky130_fd_sc_hd__nand2_1
X_09700_ _02111_ _02114_ VGND VGND VPWR VPWR _02241_ sky130_fd_sc_hd__nor2_1
XFILLER_114_589 VGND VGND VPWR VPWR sky130_fd_sc_hd__decap_4
XFILLER_101_217 VGND VGND VPWR VPWR sky130_fd_sc_hd__decap_6
XFILLER_99_289 VGND VGND VPWR VPWR sky130_fd_sc_hd__decap_3
X_06912_ _01802_ _01867_ _02369_ VGND VGND VPWR VPWR _02380_ sky130_fd_sc_hd__a21oi_1
XFILLER_4_83 VGND VGND VPWR VPWR sky130_fd_sc_hd__fill_1
XFILLER_114_29 VPWR VGND VPWR VGND sky130_ef_sc_hd__decap_12
X_07892_ net667 net415 VGND VGND VPWR VPWR _00370_ sky130_fd_sc_hd__nand2_1
X_09631_ _02164_ _02165_ VGND VGND VPWR VPWR _02166_ sky130_fd_sc_hd__nor2_1
XFILLER_67_164 VGND VGND VPWR VPWR sky130_fd_sc_hd__decap_4
X_06843_ net467 net672 _01616_ VGND VGND VPWR VPWR _01627_ sky130_fd_sc_hd__and3_1
XFILLER_55_304 VGND VGND VPWR VPWR sky130_fd_sc_hd__decap_3
X_09562_ net522 net343 _01937_ _01936_ net414 VGND VGND VPWR VPWR _02090_ sky130_fd_sc_hd__a32o_1
XFILLER_55_337 VGND VGND VPWR VPWR sky130_fd_sc_hd__decap_4
XTAP_TAPCELL_ROW_104_1806 VGND VPWR sky130_fd_sc_hd__tapvpwrvgnd_1
XFILLER_82_156 VGND VGND VPWR VPWR sky130_fd_sc_hd__fill_1
XFILLER_70_307 VGND VGND VPWR VPWR sky130_fd_sc_hd__fill_1
X_08513_ _00899_ _00904_ _00898_ VGND VGND VPWR VPWR _00985_ sky130_fd_sc_hd__o21a_1
X_09493_ _02012_ _02013_ VGND VGND VPWR VPWR _02015_ sky130_fd_sc_hd__xor2_1
XFILLER_51_543 VPWR VGND VPWR VGND sky130_ef_sc_hd__decap_12
X_08444_ _00911_ _00916_ VGND VGND VPWR VPWR _00917_ sky130_fd_sc_hd__xnor2_1
XFILLER_24_779 VPWR VGND VPWR VGND sky130_ef_sc_hd__decap_12
X_08375_ _00848_ _00847_ VGND VGND VPWR VPWR _00849_ sky130_fd_sc_hd__and2b_1
XFILLER_11_429 VGND VGND VPWR VPWR sky130_fd_sc_hd__decap_4
XFILLER_23_15 VPWR VGND VPWR VGND sky130_ef_sc_hd__decap_12
XFILLER_23_289 VGND VGND VPWR VPWR sky130_fd_sc_hd__fill_2
XTAP_TAPCELL_ROW_34_785 VGND VPWR sky130_fd_sc_hd__tapvpwrvgnd_1
X_07326_ _06554_ _06555_ _06291_ VGND VGND VPWR VPWR _06557_ sky130_fd_sc_hd__a21o_1
XTAP_TAPCELL_ROW_34_796 VGND VPWR sky130_fd_sc_hd__tapvpwrvgnd_1
XFILLER_109_317 VPWR VGND VPWR VGND sky130_ef_sc_hd__decap_12
X_07257_ _06018_ _06127_ VGND VGND VPWR VPWR _06138_ sky130_fd_sc_hd__xnor2_1
XFILLER_133_821 VGND VGND VPWR VPWR sky130_fd_sc_hd__decap_3
X_07188_ _05341_ _05352_ _03861_ _03882_ VGND VGND VPWR VPWR _05385_ sky130_fd_sc_hd__a211oi_2
XFILLER_3_617 VPWR VGND VPWR VGND sky130_ef_sc_hd__decap_12
XFILLER_3_606 VGND VGND VPWR VPWR sky130_fd_sc_hd__fill_1
XTAP_TAPCELL_ROW_115_1968 VGND VPWR sky130_fd_sc_hd__tapvpwrvgnd_1
XFILLER_132_397 VGND VGND VPWR VPWR sky130_fd_sc_hd__decap_8
XFILLER_120_515 VGND VGND VPWR VPWR sky130_fd_sc_hd__decap_6
Xfanout420 net421 VGND VGND VPWR VPWR net420 sky130_fd_sc_hd__clkbuf_4
Xfanout431 net432 VGND VGND VPWR VPWR net431 sky130_fd_sc_hd__clkbuf_2
Xfanout453 net456 VGND VGND VPWR VPWR net453 sky130_fd_sc_hd__clkbuf_4
Xfanout464 net465 VGND VGND VPWR VPWR net464 sky130_fd_sc_hd__buf_2
Xfanout475 net477 VGND VGND VPWR VPWR net475 sky130_fd_sc_hd__clkbuf_2
Xfanout442 net448 VGND VGND VPWR VPWR net442 sky130_fd_sc_hd__buf_4
X_09829_ _02379_ _02381_ VGND VGND VPWR VPWR _02382_ sky130_fd_sc_hd__or2_1
Xfanout497 net498 VGND VGND VPWR VPWR net497 sky130_fd_sc_hd__clkbuf_4
XFILLER_74_602 VGND VGND VPWR VPWR sky130_fd_sc_hd__decap_3
Xfanout486 net491 VGND VGND VPWR VPWR net486 sky130_fd_sc_hd__clkbuf_4
X_12840_ _05503_ _05506_ VGND VGND VPWR VPWR _05660_ sky130_fd_sc_hd__nand2_1
XFILLER_58_197 VPWR VGND VPWR VGND sky130_ef_sc_hd__decap_12
XFILLER_62_819 VGND VGND VPWR VPWR sky130_fd_sc_hd__fill_1
XFILLER_27_540 VPWR VGND VPWR VGND sky130_ef_sc_hd__decap_12
X_12771_ net550 net659 _05410_ _05409_ net577 VGND VGND VPWR VPWR _05584_ sky130_fd_sc_hd__a32o_1
X_11722_ _04350_ _04442_ _04436_ VGND VGND VPWR VPWR _04443_ sky130_fd_sc_hd__mux2_1
XFILLER_120_83 VGND VGND VPWR VPWR sky130_fd_sc_hd__fill_1
XFILLER_42_587 VGND VGND VPWR VPWR sky130_fd_sc_hd__fill_1
XFILLER_9_39 VPWR VGND VPWR VGND sky130_ef_sc_hd__decap_12
X_11653_ _04366_ _04367_ VGND VGND VPWR VPWR _04368_ sky130_fd_sc_hd__or2_2
XFILLER_30_716 VPWR VGND VPWR VGND sky130_ef_sc_hd__decap_12
XFILLER_80_65 VGND VGND VPWR VPWR sky130_fd_sc_hd__decap_3
X_10604_ _03083_ _03221_ VGND VGND VPWR VPWR _03222_ sky130_fd_sc_hd__nor2_1
X_13323_ _06038_ _06044_ _06042_ VGND VGND VPWR VPWR _06187_ sky130_fd_sc_hd__a21o_1
X_11584_ _04023_ _04292_ VGND VGND VPWR VPWR _04293_ sky130_fd_sc_hd__nand2_1
XTAP_TAPCELL_ROW_12_468 VGND VPWR sky130_fd_sc_hd__tapvpwrvgnd_1
XTAP_TAPCELL_ROW_12_479 VGND VPWR sky130_fd_sc_hd__tapvpwrvgnd_1
XTAP_TAPCELL_ROW_77_1418 VGND VPWR sky130_fd_sc_hd__tapvpwrvgnd_1
X_10535_ _03136_ _03146_ VGND VGND VPWR VPWR _03147_ sky130_fd_sc_hd__xnor2_1
XFILLER_129_81 VPWR VGND VPWR VGND sky130_ef_sc_hd__decap_12
X_13254_ _05984_ _05987_ _05983_ VGND VGND VPWR VPWR _06112_ sky130_fd_sc_hd__o21ba_1
XFILLER_6_477 VGND VGND VPWR VPWR sky130_fd_sc_hd__decap_4
X_10466_ _02883_ _03069_ _03071_ VGND VGND VPWR VPWR _03072_ sky130_fd_sc_hd__and3_1
XFILLER_136_692 VGND VGND VPWR VPWR sky130_fd_sc_hd__decap_8
X_13185_ net500 net422 net539 net533 VGND VGND VPWR VPWR _06036_ sky130_fd_sc_hd__and4b_1
XTAP_TAPCELL_ROW_90_1607 VGND VPWR sky130_fd_sc_hd__tapvpwrvgnd_1
X_12205_ _04823_ _04964_ VGND VGND VPWR VPWR _04966_ sky130_fd_sc_hd__nor2_1
XFILLER_123_331 VGND VGND VPWR VPWR sky130_fd_sc_hd__fill_1
XFILLER_97_727 VGND VGND VPWR VPWR sky130_fd_sc_hd__fill_1
X_12136_ _04847_ _04887_ _04889_ VGND VGND VPWR VPWR _04891_ sky130_fd_sc_hd__or3_4
X_10397_ _02993_ _02994_ _02992_ VGND VGND VPWR VPWR _02996_ sky130_fd_sc_hd__a21bo_1
X_12067_ net529 net398 VGND VGND VPWR VPWR _04815_ sky130_fd_sc_hd__nand2_1
XFILLER_92_410 VGND VGND VPWR VPWR sky130_fd_sc_hd__fill_2
XFILLER_49_142 VGND VGND VPWR VPWR sky130_fd_sc_hd__fill_1
X_11018_ _03668_ _03673_ _03674_ VGND VGND VPWR VPWR _03676_ sky130_fd_sc_hd__nand3_1
XFILLER_92_421 VPWR VGND VPWR VGND sky130_ef_sc_hd__decap_12
XFILLER_64_123 VGND VGND VPWR VPWR sky130_fd_sc_hd__fill_1
XFILLER_37_337 VGND VGND VPWR VPWR sky130_fd_sc_hd__decap_6
XTAP_TAPCELL_ROW_88_1569 VGND VPWR sky130_fd_sc_hd__tapvpwrvgnd_1
XFILLER_18_540 VGND VGND VPWR VPWR sky130_fd_sc_hd__fill_2
XFILLER_80_649 VPWR VGND VPWR VGND sky130_ef_sc_hd__decap_12
X_12969_ _05287_ _05798_ VGND VGND VPWR VPWR _05801_ sky130_fd_sc_hd__xnor2_1
XFILLER_33_510 VGND VGND VPWR VPWR sky130_fd_sc_hd__decap_6
XFILLER_60_351 VPWR VGND VPWR VGND sky130_ef_sc_hd__decap_12
XFILLER_20_204 VGND VGND VPWR VPWR sky130_fd_sc_hd__decap_6
XFILLER_21_727 VGND VGND VPWR VPWR sky130_fd_sc_hd__fill_1
XTAP_TAPCELL_ROW_119_2024 VGND VPWR sky130_fd_sc_hd__tapvpwrvgnd_1
X_08160_ _00628_ _00635_ VGND VGND VPWR VPWR _00636_ sky130_fd_sc_hd__nand2_1
XTAP_TAPCELL_ROW_31_744 VGND VPWR sky130_fd_sc_hd__tapvpwrvgnd_1
XFILLER_119_615 VGND VGND VPWR VPWR sky130_fd_sc_hd__fill_1
X_07111_ _04526_ _04537_ VGND VGND VPWR VPWR _04547_ sky130_fd_sc_hd__or2_1
XTAP_TAPCELL_ROW_31_755 VGND VPWR sky130_fd_sc_hd__tapvpwrvgnd_1
XTAP_TAPCELL_ROW_132_2213 VGND VPWR sky130_fd_sc_hd__tapvpwrvgnd_1
X_08091_ net545 _00299_ VGND VGND VPWR VPWR _00567_ sky130_fd_sc_hd__and2_1
XFILLER_134_629 VPWR VGND VPWR VGND sky130_ef_sc_hd__decap_12
X_07042_ _02020_ _03697_ _03784_ VGND VGND VPWR VPWR _03795_ sky130_fd_sc_hd__and3_1
XFILLER_130_813 VGND VGND VPWR VPWR sky130_fd_sc_hd__decap_8
XFILLER_125_39 VPWR VGND VPWR VGND sky130_ef_sc_hd__decap_12
X_08993_ net633 net625 net374 net37 VGND VGND VPWR VPWR _01470_ sky130_fd_sc_hd__and4_1
X_07944_ _00419_ _00420_ VGND VGND VPWR VPWR _00422_ sky130_fd_sc_hd__xor2_2
XTAP_TAPCELL_ROW_110_1898 VGND VPWR sky130_fd_sc_hd__tapvpwrvgnd_1
XTAP_TAPCELL_ROW_110_1887 VGND VPWR sky130_fd_sc_hd__tapvpwrvgnd_1
XFILLER_56_624 VGND VGND VPWR VPWR sky130_fd_sc_hd__decap_3
X_07875_ _06633_ _00352_ VGND VGND VPWR VPWR _00353_ sky130_fd_sc_hd__xnor2_1
XFILLER_18_15 VPWR VGND VPWR VGND sky130_ef_sc_hd__decap_12
XFILLER_110_581 VGND VGND VPWR VPWR sky130_fd_sc_hd__decap_6
X_09614_ _01988_ _01992_ _01989_ VGND VGND VPWR VPWR _02147_ sky130_fd_sc_hd__a21oi_1
XFILLER_95_281 VGND VGND VPWR VPWR sky130_fd_sc_hd__fill_2
XFILLER_68_484 VGND VGND VPWR VPWR sky130_fd_sc_hd__decap_3
XFILLER_56_657 VGND VGND VPWR VPWR sky130_fd_sc_hd__fill_1
XFILLER_55_134 VGND VGND VPWR VPWR sky130_fd_sc_hd__decap_3
XFILLER_28_348 VPWR VGND VPWR VGND sky130_ef_sc_hd__decap_12
X_06826_ net315 VGND VGND VPWR VPWR _01442_ sky130_fd_sc_hd__inv_2
XTAP_TAPCELL_ROW_39_866 VGND VPWR sky130_fd_sc_hd__tapvpwrvgnd_1
X_09545_ _02033_ _02069_ VGND VGND VPWR VPWR _02071_ sky130_fd_sc_hd__xnor2_1
XFILLER_70_126 VPWR VGND VPWR VGND sky130_ef_sc_hd__decap_12
X_09476_ _01993_ _01994_ VGND VGND VPWR VPWR _01996_ sky130_fd_sc_hd__nand2_1
X_08427_ _00803_ _00805_ _00807_ _00801_ VGND VGND VPWR VPWR _00900_ sky130_fd_sc_hd__o2bb2a_1
XFILLER_12_716 VGND VGND VPWR VPWR sky130_fd_sc_hd__fill_1
XFILLER_24_587 VGND VGND VPWR VPWR sky130_fd_sc_hd__fill_1
Xclkload2 clknet_3_4__leaf_clk VGND VGND VPWR VPWR clkload2/Y sky130_fd_sc_hd__bufinv_16
X_08358_ _00830_ _00831_ VGND VGND VPWR VPWR _00832_ sky130_fd_sc_hd__nor2_1
XFILLER_137_456 VGND VGND VPWR VPWR sky130_fd_sc_hd__decap_6
X_07309_ _05078_ _05100_ _05089_ VGND VGND VPWR VPWR _06540_ sky130_fd_sc_hd__o21bai_1
X_08289_ net663 net256 _06633_ VGND VGND VPWR VPWR _00764_ sky130_fd_sc_hd__o21a_1
XFILLER_20_793 VPWR VGND VPWR VGND sky130_ef_sc_hd__decap_12
XFILLER_137_489 VGND VGND VPWR VPWR sky130_fd_sc_hd__fill_2
XFILLER_109_169 VPWR VGND VPWR VGND sky130_ef_sc_hd__decap_12
XTAP_TAPCELL_ROW_59_1148 VGND VPWR sky130_fd_sc_hd__tapvpwrvgnd_1
X_10320_ net569 net310 _02908_ _02910_ VGND VGND VPWR VPWR _02912_ sky130_fd_sc_hd__o2bb2a_1
XFILLER_124_117 VGND VGND VPWR VPWR sky130_fd_sc_hd__fill_1
XFILLER_106_821 VGND VGND VPWR VPWR sky130_fd_sc_hd__decap_3
XTAP_TAPCELL_ROW_59_1159 VGND VPWR sky130_fd_sc_hd__tapvpwrvgnd_1
X_10251_ net641 net328 VGND VGND VPWR VPWR _02837_ sky130_fd_sc_hd__nand2_1
XFILLER_132_161 VGND VGND VPWR VPWR sky130_fd_sc_hd__fill_1
X_10182_ _02700_ _02707_ _02709_ VGND VGND VPWR VPWR _02765_ sky130_fd_sc_hd__o21a_1
XFILLER_105_364 VGND VGND VPWR VPWR sky130_fd_sc_hd__fill_1
XTAP_TAPCELL_ROW_72_1348 VGND VPWR sky130_fd_sc_hd__tapvpwrvgnd_1
XTAP_TAPCELL_ROW_72_1337 VGND VPWR sky130_fd_sc_hd__tapvpwrvgnd_1
Xfanout250 _01894_ VGND VGND VPWR VPWR net250 sky130_fd_sc_hd__clkbuf_4
XFILLER_120_389 VPWR VGND VPWR VGND sky130_ef_sc_hd__decap_12
Xfanout261 _01365_ VGND VGND VPWR VPWR net261 sky130_fd_sc_hd__buf_4
Xfanout272 net96 VGND VGND VPWR VPWR net272 sky130_fd_sc_hd__buf_2
Xfanout283 net90 VGND VGND VPWR VPWR net283 sky130_fd_sc_hd__buf_2
XFILLER_101_592 VGND VGND VPWR VPWR sky130_fd_sc_hd__fill_1
XFILLER_75_43 VPWR VGND VPWR VGND sky130_ef_sc_hd__decap_12
XFILLER_74_432 VGND VGND VPWR VPWR sky130_fd_sc_hd__fill_2
XFILLER_47_646 VPWR VGND VPWR VGND sky130_ef_sc_hd__decap_12
Xfanout294 net85 VGND VGND VPWR VPWR net294 sky130_fd_sc_hd__clkbuf_2
XFILLER_19_337 VPWR VGND VPWR VGND sky130_ef_sc_hd__decap_12
XFILLER_46_167 VGND VGND VPWR VPWR sky130_fd_sc_hd__fill_1
XFILLER_34_307 VGND VGND VPWR VPWR sky130_fd_sc_hd__fill_1
X_12823_ net522 net25 _05475_ _05474_ VGND VGND VPWR VPWR _05641_ sky130_fd_sc_hd__a31o_1
XFILLER_15_521 VGND VGND VPWR VPWR sky130_fd_sc_hd__fill_1
XFILLER_131_93 VPWR VGND VPWR VGND sky130_ef_sc_hd__decap_12
X_12754_ _05564_ _05565_ VGND VGND VPWR VPWR _05566_ sky130_fd_sc_hd__or2_1
XFILLER_42_340 VGND VGND VPWR VPWR sky130_fd_sc_hd__decap_3
XTAP_TAPCELL_ROW_17_549 VGND VPWR sky130_fd_sc_hd__tapvpwrvgnd_1
X_11705_ _04290_ _04293_ _04424_ VGND VGND VPWR VPWR _04425_ sky130_fd_sc_hd__a21oi_1
XTAP_TAPCELL_ROW_83_1499 VGND VPWR sky130_fd_sc_hd__tapvpwrvgnd_1
X_12685_ net437 net430 net384 net388 VGND VGND VPWR VPWR _05491_ sky130_fd_sc_hd__and4_1
XFILLER_70_693 VGND VGND VPWR VPWR sky130_fd_sc_hd__decap_6
XFILLER_24_91 VPWR VGND VPWR VGND sky130_ef_sc_hd__decap_12
X_11636_ _03455_ _04251_ _04250_ VGND VGND VPWR VPWR _04349_ sky130_fd_sc_hd__a21oi_1
X_11567_ _04260_ _04272_ VGND VGND VPWR VPWR _04274_ sky130_fd_sc_hd__xor2_1
XFILLER_128_489 VPWR VGND VPWR VGND sky130_ef_sc_hd__decap_12
X_13306_ _05877_ _05878_ _05887_ _06026_ VGND VGND VPWR VPWR _06169_ sky130_fd_sc_hd__a2bb2o_1
XFILLER_7_753 VPWR VGND VPWR VGND sky130_ef_sc_hd__decap_12
X_10518_ _03119_ _03126_ VGND VGND VPWR VPWR _03129_ sky130_fd_sc_hd__xnor2_1
XFILLER_115_128 VPWR VGND VPWR VGND sky130_ef_sc_hd__decap_12
X_13237_ _06085_ _06092_ VGND VGND VPWR VPWR _06093_ sky130_fd_sc_hd__xnor2_1
XFILLER_7_797 VPWR VGND VPWR VGND sky130_ef_sc_hd__decap_12
X_11498_ _04189_ _04197_ VGND VGND VPWR VPWR _04200_ sky130_fd_sc_hd__xor2_1
XFILLER_124_640 VGND VGND VPWR VPWR sky130_fd_sc_hd__decap_4
X_10449_ _03043_ _03046_ _03045_ VGND VGND VPWR VPWR _03054_ sky130_fd_sc_hd__o21ba_1
XFILLER_130_109 VPWR VGND VPWR VGND sky130_ef_sc_hd__decap_12
XFILLER_112_813 VGND VGND VPWR VPWR sky130_fd_sc_hd__decap_8
X_13168_ _05778_ _05867_ _05866_ VGND VGND VPWR VPWR _06019_ sky130_fd_sc_hd__a21boi_2
X_13099_ net495 net394 _00342_ _05629_ VGND VGND VPWR VPWR _05943_ sky130_fd_sc_hd__and4_1
X_12119_ _04869_ _04870_ _04872_ VGND VGND VPWR VPWR _04873_ sky130_fd_sc_hd__or3_4
XFILLER_69_237 VGND VGND VPWR VPWR sky130_fd_sc_hd__fill_1
XFILLER_78_771 VPWR VGND VPWR VGND sky130_ef_sc_hd__decap_12
XFILLER_27_3 VPWR VGND VPWR VGND sky130_ef_sc_hd__decap_12
XFILLER_77_292 VGND VGND VPWR VPWR sky130_fd_sc_hd__fill_1
XFILLER_77_281 VGND VGND VPWR VPWR sky130_fd_sc_hd__decap_4
XFILLER_92_240 VGND VGND VPWR VPWR sky130_fd_sc_hd__decap_4
XFILLER_65_443 VGND VGND VPWR VPWR sky130_fd_sc_hd__decap_4
X_07660_ _00137_ _00138_ _06724_ VGND VGND VPWR VPWR _00140_ sky130_fd_sc_hd__a21oi_1
XFILLER_1_51 VGND VGND VPWR VPWR sky130_fd_sc_hd__decap_4
XFILLER_26_808 VGND VGND VPWR VPWR sky130_fd_sc_hd__decap_4
XFILLER_26_819 VGND VGND VPWR VPWR sky130_fd_sc_hd__fill_1
XFILLER_93_785 VPWR VGND VPWR VGND sky130_ef_sc_hd__decap_12
XFILLER_92_273 VPWR VGND VPWR VGND sky130_ef_sc_hd__decap_12
X_07591_ net667 net434 net427 net669 VGND VGND VPWR VPWR _00071_ sky130_fd_sc_hd__a22o_1
XTAP_TAPCELL_ROW_36_814 VGND VPWR sky130_fd_sc_hd__tapvpwrvgnd_1
XTAP_TAPCELL_ROW_36_825 VGND VPWR sky130_fd_sc_hd__tapvpwrvgnd_1
X_09330_ _01834_ _01836_ _01804_ VGND VGND VPWR VPWR _01838_ sky130_fd_sc_hd__a21o_1
X_09261_ _01751_ _01761_ VGND VGND VPWR VPWR _01762_ sky130_fd_sc_hd__xnor2_1
XPHY_EDGE_ROW_80_Left_219 VGND VGND VPWR VPWR sky130_fd_sc_hd__decap_3
XFILLER_61_671 VGND VGND VPWR VPWR sky130_fd_sc_hd__fill_1
XFILLER_33_362 VGND VGND VPWR VPWR sky130_fd_sc_hd__fill_1
XFILLER_33_373 VGND VGND VPWR VPWR sky130_fd_sc_hd__fill_1
XFILLER_60_192 VGND VGND VPWR VPWR sky130_fd_sc_hd__decap_4
X_08212_ _00592_ _00594_ _00686_ VGND VGND VPWR VPWR _00687_ sky130_fd_sc_hd__o21ba_1
XFILLER_138_209 VGND VGND VPWR VPWR sky130_fd_sc_hd__decap_4
X_09192_ _01685_ _01686_ VGND VGND VPWR VPWR _00065_ sky130_fd_sc_hd__xor2_1
X_08143_ _00597_ _00617_ VGND VGND VPWR VPWR _00619_ sky130_fd_sc_hd__xnor2_1
X_08074_ _00549_ _00550_ VGND VGND VPWR VPWR _00551_ sky130_fd_sc_hd__nor2_1
X_07025_ _03522_ _03533_ _03598_ VGND VGND VPWR VPWR _03609_ sky130_fd_sc_hd__nand3_2
XFILLER_20_27 VGND VGND VPWR VPWR sky130_fd_sc_hd__fill_1
XFILLER_136_27 VGND VGND VPWR VPWR sky130_fd_sc_hd__fill_1
XTAP_TAPCELL_ROW_112_1927 VGND VPWR sky130_fd_sc_hd__tapvpwrvgnd_1
XTAP_TAPCELL_ROW_112_1916 VGND VPWR sky130_fd_sc_hd__tapvpwrvgnd_1
XFILLER_102_345 VGND VGND VPWR VPWR sky130_fd_sc_hd__decap_3
XTAP_TAPCELL_ROW_54_1078 VGND VPWR sky130_fd_sc_hd__tapvpwrvgnd_1
XFILLER_130_665 VGND VGND VPWR VPWR sky130_fd_sc_hd__decap_6
X_08976_ _01448_ _01449_ _01446_ VGND VGND VPWR VPWR _01451_ sky130_fd_sc_hd__o21ai_1
XTAP_TAPCELL_ROW_54_1089 VGND VPWR sky130_fd_sc_hd__tapvpwrvgnd_1
XFILLER_84_730 VGND VGND VPWR VPWR sky130_fd_sc_hd__decap_6
X_07927_ _00404_ _00403_ VGND VGND VPWR VPWR _00405_ sky130_fd_sc_hd__nand2b_1
XFILLER_56_421 VGND VGND VPWR VPWR sky130_fd_sc_hd__decap_8
XFILLER_56_410 VGND VGND VPWR VPWR sky130_fd_sc_hd__fill_1
XFILLER_84_774 VGND VGND VPWR VPWR sky130_fd_sc_hd__fill_1
X_07858_ _00224_ _00241_ _00240_ VGND VGND VPWR VPWR _00336_ sky130_fd_sc_hd__a21oi_1
XFILLER_29_679 VGND VGND VPWR VPWR sky130_fd_sc_hd__decap_4
XFILLER_83_262 VGND VGND VPWR VPWR sky130_fd_sc_hd__decap_3
X_07789_ _00097_ _00115_ _00114_ VGND VGND VPWR VPWR _00268_ sky130_fd_sc_hd__a21bo_1
X_09528_ _01880_ _02050_ VGND VGND VPWR VPWR _02053_ sky130_fd_sc_hd__xnor2_1
XPHY_EDGE_ROW_119_Left_258 VGND VGND VPWR VPWR sky130_fd_sc_hd__decap_3
XFILLER_45_57 VPWR VGND VPWR VGND sky130_ef_sc_hd__decap_12
XFILLER_43_137 VGND VGND VPWR VPWR sky130_fd_sc_hd__decap_3
XFILLER_101_30 VPWR VGND VPWR VGND sky130_ef_sc_hd__decap_12
XTAP_TAPCELL_ROW_14_508 VGND VPWR sky130_fd_sc_hd__tapvpwrvgnd_1
X_09459_ _01611_ _01977_ VGND VGND VPWR VPWR _01978_ sky130_fd_sc_hd__nor2_1
XFILLER_131_3 VPWR VGND VPWR VGND sky130_ef_sc_hd__decap_12
X_12470_ net497 net489 net402 net401 VGND VGND VPWR VPWR _05256_ sky130_fd_sc_hd__and4_1
X_11421_ _04103_ _04115_ VGND VGND VPWR VPWR _04116_ sky130_fd_sc_hd__xnor2_1
XFILLER_6_29 VPWR VGND VPWR VGND sky130_ef_sc_hd__decap_12
XFILLER_4_701 VGND VGND VPWR VPWR sky130_fd_sc_hd__fill_2
X_11352_ _04034_ _04036_ _04038_ VGND VGND VPWR VPWR _04040_ sky130_fd_sc_hd__or3_1
XPHY_EDGE_ROW_128_Left_267 VGND VGND VPWR VPWR sky130_fd_sc_hd__decap_3
XFILLER_4_723 VPWR VGND VPWR VGND sky130_ef_sc_hd__decap_12
X_10303_ net520 net293 VGND VGND VPWR VPWR _02893_ sky130_fd_sc_hd__nand2_1
XFILLER_3_233 VGND VGND VPWR VPWR sky130_fd_sc_hd__fill_2
X_11283_ _03961_ _03963_ VGND VGND VPWR VPWR _03965_ sky130_fd_sc_hd__xnor2_1
XFILLER_106_673 VPWR VGND VPWR VGND sky130_ef_sc_hd__decap_12
XFILLER_79_502 VGND VGND VPWR VPWR sky130_fd_sc_hd__fill_2
X_13022_ _05831_ _05858_ VGND VGND VPWR VPWR _05859_ sky130_fd_sc_hd__xnor2_1
XFILLER_10_71 VGND VGND VPWR VPWR sky130_fd_sc_hd__fill_1
XFILLER_3_277 VGND VGND VPWR VPWR sky130_fd_sc_hd__decap_3
X_10234_ net298 _02818_ VGND VGND VPWR VPWR _02819_ sky130_fd_sc_hd__nand2_1
X_10165_ _02742_ _02746_ VGND VGND VPWR VPWR _02747_ sky130_fd_sc_hd__xnor2_1
XFILLER_79_557 VGND VGND VPWR VPWR sky130_fd_sc_hd__decap_3
XFILLER_121_665 VGND VGND VPWR VPWR sky130_fd_sc_hd__decap_6
XFILLER_120_153 VPWR VGND VPWR VGND sky130_ef_sc_hd__decap_12
XFILLER_86_53 VPWR VGND VPWR VGND sky130_ef_sc_hd__decap_12
X_10096_ _02460_ _02563_ _02562_ VGND VGND VPWR VPWR _02672_ sky130_fd_sc_hd__a21oi_1
XFILLER_121_698 VGND VGND VPWR VPWR sky130_fd_sc_hd__decap_6
XFILLER_47_443 VGND VGND VPWR VPWR sky130_fd_sc_hd__decap_4
XPHY_EDGE_ROW_137_Left_276 VGND VGND VPWR VPWR sky130_fd_sc_hd__decap_3
XTAP_TAPCELL_ROW_85_1528 VGND VPWR sky130_fd_sc_hd__tapvpwrvgnd_1
XFILLER_90_744 VPWR VGND VPWR VGND sky130_ef_sc_hd__decap_12
X_12806_ net487 net480 net398 net400 VGND VGND VPWR VPWR _05622_ sky130_fd_sc_hd__and4_1
X_10998_ _03480_ _03483_ VGND VGND VPWR VPWR _03654_ sky130_fd_sc_hd__nand2_1
X_12737_ _05488_ _05546_ _05547_ VGND VGND VPWR VPWR _05548_ sky130_fd_sc_hd__nor3_1
X_12668_ net391 net412 VGND VGND VPWR VPWR _05473_ sky130_fd_sc_hd__and2b_1
XTAP_TAPCELL_ROW_41_894 VGND VPWR sky130_fd_sc_hd__tapvpwrvgnd_1
X_11619_ _04080_ _04218_ _04328_ VGND VGND VPWR VPWR _04331_ sky130_fd_sc_hd__and3_1
XFILLER_30_365 VGND VGND VPWR VPWR sky130_fd_sc_hd__fill_2
XFILLER_128_253 VPWR VGND VPWR VGND sky130_ef_sc_hd__decap_12
XFILLER_116_404 VGND VGND VPWR VPWR sky130_fd_sc_hd__decap_8
X_12599_ _05394_ _05396_ VGND VGND VPWR VPWR _05397_ sky130_fd_sc_hd__nor2_1
Xmax_cap236 _04101_ VGND VGND VPWR VPWR net236 sky130_fd_sc_hd__buf_1
XFILLER_131_429 VGND VGND VPWR VPWR sky130_fd_sc_hd__fill_2
XFILLER_98_811 VGND VGND VPWR VPWR sky130_fd_sc_hd__fill_1
X_08830_ net430 net341 net339 net439 VGND VGND VPWR VPWR _01296_ sky130_fd_sc_hd__a22oi_1
XFILLER_100_805 VGND VGND VPWR VPWR sky130_fd_sc_hd__decap_6
XFILLER_85_505 VPWR VGND VPWR VGND sky130_ef_sc_hd__decap_12
XTAP_TAPCELL_ROW_127_2145 VGND VPWR sky130_fd_sc_hd__tapvpwrvgnd_1
XTAP_TAPCELL_ROW_127_2134 VGND VPWR sky130_fd_sc_hd__tapvpwrvgnd_1
X_08761_ _01048_ _01057_ _01221_ _01227_ VGND VGND VPWR VPWR _01228_ sky130_fd_sc_hd__a211o_1
XFILLER_122_29 VPWR VGND VPWR VGND sky130_ef_sc_hd__decap_12
X_08692_ _01044_ _01158_ VGND VGND VPWR VPWR _01159_ sky130_fd_sc_hd__and2_1
X_07712_ _00068_ _00086_ _00085_ VGND VGND VPWR VPWR _00191_ sky130_fd_sc_hd__a21oi_2
XFILLER_81_700 VGND VGND VPWR VPWR sky130_fd_sc_hd__fill_2
XFILLER_65_273 VGND VGND VPWR VPWR sky130_fd_sc_hd__decap_6
X_07643_ _06705_ _06707_ _00121_ _00122_ VGND VGND VPWR VPWR _00123_ sky130_fd_sc_hd__a211o_1
XFILLER_80_210 VGND VGND VPWR VPWR sky130_fd_sc_hd__decap_4
X_09313_ _01817_ _01818_ VGND VGND VPWR VPWR _01819_ sky130_fd_sc_hd__xnor2_1
X_07574_ net521 net676 VGND VGND VPWR VPWR _06803_ sky130_fd_sc_hd__and2_2
XFILLER_15_27 VPWR VGND VPWR VGND sky130_ef_sc_hd__decap_12
XFILLER_34_660 VGND VGND VPWR VPWR sky130_fd_sc_hd__fill_1
XFILLER_80_287 VGND VGND VPWR VPWR sky130_fd_sc_hd__fill_1
X_09244_ _01691_ _01742_ VGND VGND VPWR VPWR _01743_ sky130_fd_sc_hd__xnor2_1
X_09175_ _01607_ _01666_ VGND VGND VPWR VPWR _01668_ sky130_fd_sc_hd__xnor2_1
XFILLER_21_376 VPWR VGND VPWR VGND sky130_ef_sc_hd__decap_12
XFILLER_31_15 VPWR VGND VPWR VGND sky130_ef_sc_hd__decap_12
XTAP_TAPCELL_ROW_138_2296 VGND VPWR sky130_fd_sc_hd__tapvpwrvgnd_1
X_08126_ net681 net258 VGND VGND VPWR VPWR _00602_ sky130_fd_sc_hd__nor2_1
XFILLER_119_297 VGND VGND VPWR VPWR sky130_fd_sc_hd__decap_8
XFILLER_107_459 VPWR VGND VPWR VGND sky130_ef_sc_hd__decap_12
X_08057_ _00392_ _00402_ _00401_ VGND VGND VPWR VPWR _00534_ sky130_fd_sc_hd__a21oi_1
XTAP_TAPCELL_ROW_56_1118 VGND VPWR sky130_fd_sc_hd__tapvpwrvgnd_1
XTAP_TAPCELL_ROW_56_1107 VGND VPWR sky130_fd_sc_hd__tapvpwrvgnd_1
XPHY_EDGE_ROW_1_Right_1 VGND VGND VPWR VPWR sky130_fd_sc_hd__decap_3
X_07008_ _03390_ _03401_ _03412_ VGND VGND VPWR VPWR _03423_ sky130_fd_sc_hd__nand3_1
XFILLER_115_481 VGND VGND VPWR VPWR sky130_fd_sc_hd__fill_1
XFILLER_102_131 VGND VGND VPWR VPWR sky130_fd_sc_hd__decap_3
XFILLER_88_365 VGND VGND VPWR VPWR sky130_fd_sc_hd__fill_1
Xinput104 w30[6] VGND VGND VPWR VPWR net104 sky130_fd_sc_hd__buf_2
Xinput126 w33[4] VGND VGND VPWR VPWR net126 sky130_fd_sc_hd__dlymetal6s2s_1
Xinput115 w32[1] VGND VGND VPWR VPWR net115 sky130_fd_sc_hd__dlymetal6s2s_1
X_08959_ _01422_ _01432_ VGND VGND VPWR VPWR _01433_ sky130_fd_sc_hd__xor2_1
Xinput159 x3[5] VGND VGND VPWR VPWR net159 sky130_fd_sc_hd__buf_1
XFILLER_102_197 VGND VGND VPWR VPWR sky130_fd_sc_hd__decap_3
Xinput137 x0[7] VGND VGND VPWR VPWR net137 sky130_fd_sc_hd__clkbuf_4
Xinput148 x2[2] VGND VGND VPWR VPWR net148 sky130_fd_sc_hd__buf_1
X_11970_ _04672_ _04708_ VGND VGND VPWR VPWR _04710_ sky130_fd_sc_hd__xor2_1
XFILLER_57_763 VPWR VGND VPWR VGND sky130_ef_sc_hd__decap_12
XFILLER_57_741 VGND VGND VPWR VPWR sky130_fd_sc_hd__fill_1
XFILLER_56_251 VGND VGND VPWR VPWR sky130_fd_sc_hd__fill_1
X_10921_ net502 net292 _03418_ _03417_ VGND VGND VPWR VPWR _03569_ sky130_fd_sc_hd__a31o_1
XFILLER_72_755 VGND VGND VPWR VPWR sky130_fd_sc_hd__fill_1
X_13640_ clknet_3_6__leaf_clk _00036_ net716 VGND VGND VPWR VPWR net175 sky130_fd_sc_hd__dfrtp_1
XTAP_TAPCELL_ROW_67_1269 VGND VPWR sky130_fd_sc_hd__tapvpwrvgnd_1
X_10852_ _03317_ _03319_ _03318_ VGND VGND VPWR VPWR _03494_ sky130_fd_sc_hd__o21bai_1
X_13571_ _06456_ _06457_ VGND VGND VPWR VPWR _06458_ sky130_fd_sc_hd__and2b_1
X_10783_ net510 net290 net289 net520 VGND VGND VPWR VPWR _03418_ sky130_fd_sc_hd__a22o_1
XTAP_TAPCELL_ROW_27_688 VGND VPWR sky130_fd_sc_hd__tapvpwrvgnd_1
XTAP_TAPCELL_ROW_80_1458 VGND VPWR sky130_fd_sc_hd__tapvpwrvgnd_1
X_12522_ _05158_ _05160_ VGND VGND VPWR VPWR _05313_ sky130_fd_sc_hd__and2_1
XFILLER_40_696 VGND VGND VPWR VPWR sky130_fd_sc_hd__decap_4
X_12453_ _05073_ _05236_ VGND VGND VPWR VPWR _05237_ sky130_fd_sc_hd__xnor2_1
XFILLER_8_369 VGND VGND VPWR VPWR sky130_fd_sc_hd__fill_1
XFILLER_126_746 VGND VGND VPWR VPWR sky130_fd_sc_hd__decap_8
XFILLER_126_713 VGND VGND VPWR VPWR sky130_fd_sc_hd__decap_4
XFILLER_125_212 VPWR VGND VPWR VGND sky130_ef_sc_hd__decap_12
X_12384_ _05016_ _05160_ _05161_ VGND VGND VPWR VPWR _05162_ sky130_fd_sc_hd__and3_1
X_11404_ _04083_ _04096_ VGND VGND VPWR VPWR _04097_ sky130_fd_sc_hd__xor2_1
XFILLER_126_757 VPWR VGND VPWR VGND sky130_ef_sc_hd__decap_12
XFILLER_4_520 VGND VGND VPWR VPWR sky130_fd_sc_hd__fill_2
X_11335_ _04019_ _04021_ VGND VGND VPWR VPWR _00013_ sky130_fd_sc_hd__xor2_1
XFILLER_21_81 VGND VGND VPWR VPWR sky130_fd_sc_hd__fill_1
XFILLER_137_81 VPWR VGND VPWR VGND sky130_ef_sc_hd__decap_12
XFILLER_125_267 VPWR VGND VPWR VGND sky130_ef_sc_hd__decap_12
XFILLER_4_586 VGND VGND VPWR VPWR sky130_fd_sc_hd__fill_2
XFILLER_4_564 VGND VGND VPWR VPWR sky130_fd_sc_hd__fill_2
X_11266_ _03943_ _03944_ VGND VGND VPWR VPWR _03946_ sky130_fd_sc_hd__xnor2_1
X_13005_ _05834_ _05839_ VGND VGND VPWR VPWR _05840_ sky130_fd_sc_hd__and2b_1
X_10217_ net590 net74 VGND VGND VPWR VPWR _02801_ sky130_fd_sc_hd__nand2_1
XFILLER_95_803 VGND VGND VPWR VPWR sky130_fd_sc_hd__fill_1
XFILLER_67_505 VGND VGND VPWR VPWR sky130_fd_sc_hd__fill_1
X_11197_ _03528_ _03707_ _03711_ VGND VGND VPWR VPWR _03871_ sky130_fd_sc_hd__o21ba_1
X_10148_ _02726_ _02727_ VGND VGND VPWR VPWR _02729_ sky130_fd_sc_hd__xor2_1
XFILLER_79_387 VGND VGND VPWR VPWR sky130_fd_sc_hd__decap_4
XFILLER_0_781 VGND VGND VPWR VPWR sky130_fd_sc_hd__decap_3
X_10079_ _02235_ _02534_ _02653_ VGND VGND VPWR VPWR _02654_ sky130_fd_sc_hd__o21ai_1
XFILLER_47_251 VGND VGND VPWR VPWR sky130_fd_sc_hd__fill_1
XFILLER_90_541 VGND VGND VPWR VPWR sky130_fd_sc_hd__decap_3
XTAP_TAPCELL_ROW_122_2075 VGND VPWR sky130_fd_sc_hd__tapvpwrvgnd_1
XTAP_TAPCELL_ROW_122_2064 VGND VPWR sky130_fd_sc_hd__tapvpwrvgnd_1
XFILLER_62_265 VPWR VGND VPWR VGND sky130_ef_sc_hd__decap_12
XTAP_TAPCELL_ROW_46_964 VGND VPWR sky130_fd_sc_hd__tapvpwrvgnd_1
XFILLER_16_671 VGND VGND VPWR VPWR sky130_fd_sc_hd__fill_1
XFILLER_94_3 VPWR VGND VPWR VGND sky130_ef_sc_hd__decap_12
X_07290_ _06465_ _06476_ _04991_ VGND VGND VPWR VPWR _06497_ sky130_fd_sc_hd__a21oi_1
XFILLER_15_181 VGND VGND VPWR VPWR sky130_fd_sc_hd__decap_8
XFILLER_31_663 VGND VGND VPWR VPWR sky130_fd_sc_hd__fill_1
XTAP_TAPCELL_ROW_98_1719 VGND VPWR sky130_fd_sc_hd__tapvpwrvgnd_1
XFILLER_31_685 VPWR VGND VPWR VGND sky130_ef_sc_hd__decap_12
XFILLER_116_223 VPWR VGND VPWR VGND sky130_ef_sc_hd__decap_12
X_09931_ _01990_ _02390_ VGND VGND VPWR VPWR _02492_ sky130_fd_sc_hd__or2_2
XFILLER_131_237 VPWR VGND VPWR VGND sky130_ef_sc_hd__decap_12
X_09862_ _02416_ _02417_ VGND VGND VPWR VPWR _02418_ sky130_fd_sc_hd__xor2_1
XFILLER_133_39 VPWR VGND VPWR VGND sky130_ef_sc_hd__decap_12
X_09793_ _02231_ _02236_ _02235_ VGND VGND VPWR VPWR _02342_ sky130_fd_sc_hd__a21o_1
X_08813_ net497 net50 _01127_ _01078_ net350 VGND VGND VPWR VPWR _01279_ sky130_fd_sc_hd__a32o_1
XFILLER_112_484 VGND VGND VPWR VPWR sky130_fd_sc_hd__fill_1
XTAP_TAPCELL_ROW_51_1037 VGND VPWR sky130_fd_sc_hd__tapvpwrvgnd_1
X_08744_ _01201_ _01203_ _01205_ _01209_ VGND VGND VPWR VPWR _01211_ sky130_fd_sc_hd__o211a_1
XFILLER_100_657 VGND VGND VPWR VPWR sky130_fd_sc_hd__decap_4
XFILLER_39_741 VPWR VGND VPWR VGND sky130_ef_sc_hd__decap_12
XFILLER_26_15 VPWR VGND VPWR VGND sky130_ef_sc_hd__decap_12
XFILLER_38_273 VGND VGND VPWR VPWR sky130_fd_sc_hd__fill_1
XFILLER_39_785 VPWR VGND VPWR VGND sky130_ef_sc_hd__decap_12
X_08675_ _01140_ _01141_ VGND VGND VPWR VPWR _01142_ sky130_fd_sc_hd__or2_1
XTAP_TAPCELL_ROW_107_1848 VGND VPWR sky130_fd_sc_hd__tapvpwrvgnd_1
XFILLER_93_390 VGND VGND VPWR VPWR sky130_fd_sc_hd__fill_2
XFILLER_54_755 VGND VGND VPWR VPWR sky130_fd_sc_hd__fill_1
XFILLER_38_295 VGND VGND VPWR VPWR sky130_fd_sc_hd__fill_2
X_07626_ _01398_ _00103_ _00104_ _00105_ VGND VGND VPWR VPWR _00106_ sky130_fd_sc_hd__o31ai_1
XFILLER_54_799 VPWR VGND VPWR VGND sky130_ef_sc_hd__decap_12
XFILLER_14_608 VGND VGND VPWR VPWR sky130_fd_sc_hd__fill_1
X_07557_ _06784_ _06785_ VGND VGND VPWR VPWR _06786_ sky130_fd_sc_hd__nand2b_1
XFILLER_41_449 VGND VGND VPWR VPWR sky130_fd_sc_hd__fill_2
XTAP_TAPCELL_ROW_24_647 VGND VPWR sky130_fd_sc_hd__tapvpwrvgnd_1
X_07488_ _06622_ _06716_ VGND VGND VPWR VPWR _06718_ sky130_fd_sc_hd__xor2_1
X_09227_ net574 net355 _06762_ _01723_ VGND VGND VPWR VPWR _01724_ sky130_fd_sc_hd__a22o_1
XTAP_TAPCELL_ROW_62_1199 VGND VPWR sky130_fd_sc_hd__tapvpwrvgnd_1
XFILLER_108_713 VGND VGND VPWR VPWR sky130_fd_sc_hd__fill_2
X_09158_ _06694_ _01648_ VGND VGND VPWR VPWR _01650_ sky130_fd_sc_hd__and2_1
X_09089_ _01572_ _01574_ VGND VGND VPWR VPWR _01575_ sky130_fd_sc_hd__and2b_1
XFILLER_108_757 VPWR VGND VPWR VGND sky130_ef_sc_hd__decap_12
X_08109_ _00578_ _00583_ VGND VGND VPWR VPWR _00585_ sky130_fd_sc_hd__xnor2_1
XFILLER_123_727 VGND VGND VPWR VPWR sky130_fd_sc_hd__fill_1
XFILLER_107_256 VGND VGND VPWR VPWR sky130_fd_sc_hd__fill_1
X_11120_ _03427_ _03785_ VGND VGND VPWR VPWR _03787_ sky130_fd_sc_hd__xnor2_1
XFILLER_107_51 VGND VGND VPWR VPWR sky130_fd_sc_hd__decap_4
XFILLER_89_663 VGND VGND VPWR VPWR sky130_fd_sc_hd__fill_1
XFILLER_49_505 VPWR VGND VPWR VGND sky130_ef_sc_hd__decap_12
X_11051_ _03709_ _03710_ VGND VGND VPWR VPWR _03712_ sky130_fd_sc_hd__and2_1
X_10002_ _02321_ _02569_ VGND VGND VPWR VPWR _02570_ sky130_fd_sc_hd__xnor2_1
XFILLER_131_782 VGND VGND VPWR VPWR sky130_fd_sc_hd__fill_2
XFILLER_89_685 VGND VGND VPWR VPWR sky130_fd_sc_hd__fill_1
XFILLER_88_173 VPWR VGND VPWR VGND sky130_ef_sc_hd__decap_12
XFILLER_67_55 VGND VGND VPWR VPWR sky130_fd_sc_hd__fill_1
XTAP_TAPCELL_ROW_4_350 VGND VPWR sky130_fd_sc_hd__tapvpwrvgnd_1
XFILLER_91_316 VGND VGND VPWR VPWR sky130_fd_sc_hd__decap_6
XFILLER_45_700 VGND VGND VPWR VPWR sky130_fd_sc_hd__decap_3
XTAP_TAPCELL_ROW_4_361 VGND VPWR sky130_fd_sc_hd__tapvpwrvgnd_1
XFILLER_17_402 VGND VGND VPWR VPWR sky130_fd_sc_hd__fill_1
X_11953_ _04690_ _04691_ VGND VGND VPWR VPWR _04692_ sky130_fd_sc_hd__nand2_1
XFILLER_72_541 VGND VGND VPWR VPWR sky130_fd_sc_hd__fill_2
XFILLER_72_574 VPWR VGND VPWR VGND sky130_ef_sc_hd__decap_12
X_11884_ _04540_ _04543_ VGND VGND VPWR VPWR _04620_ sky130_fd_sc_hd__nor2_1
X_10904_ net560 net552 net305 VGND VGND VPWR VPWR _03550_ sky130_fd_sc_hd__and3_1
X_13623_ _06441_ _06463_ _06440_ VGND VGND VPWR VPWR _06514_ sky130_fd_sc_hd__o21ai_1
XFILLER_60_747 VGND VGND VPWR VPWR sky130_fd_sc_hd__decap_8
XFILLER_60_725 VGND VGND VPWR VPWR sky130_fd_sc_hd__decap_8
XTAP_TAPCELL_ROW_43_923 VGND VPWR sky130_fd_sc_hd__tapvpwrvgnd_1
X_10835_ _03309_ _03474_ VGND VGND VPWR VPWR _03475_ sky130_fd_sc_hd__nor2_1
XFILLER_13_641 VPWR VGND VPWR VGND sky130_ef_sc_hd__decap_12
X_13554_ _06329_ _06354_ _06328_ VGND VGND VPWR VPWR _06439_ sky130_fd_sc_hd__a21o_1
X_10766_ _03393_ _03398_ VGND VGND VPWR VPWR _03399_ sky130_fd_sc_hd__xor2_1
X_13485_ _06043_ _06184_ _06362_ VGND VGND VPWR VPWR _06364_ sky130_fd_sc_hd__nand3_1
X_12505_ net420 net393 _05147_ _05146_ VGND VGND VPWR VPWR _05294_ sky130_fd_sc_hd__a31o_1
XFILLER_12_195 VGND VGND VPWR VPWR sky130_fd_sc_hd__fill_1
X_10697_ _03320_ _03321_ _03322_ VGND VGND VPWR VPWR _03324_ sky130_fd_sc_hd__a21o_1
XFILLER_138_370 VPWR VGND VPWR VGND sky130_ef_sc_hd__decap_12
X_12436_ _04934_ _04940_ _05066_ _05067_ _05218_ VGND VGND VPWR VPWR _05219_ sky130_fd_sc_hd__a41o_1
XFILLER_66_7 VPWR VGND VPWR VGND sky130_ef_sc_hd__decap_12
XFILLER_9_689 VGND VGND VPWR VPWR sky130_fd_sc_hd__decap_6
XFILLER_8_177 VGND VGND VPWR VPWR sky130_fd_sc_hd__decap_6
XTAP_TAPCELL_ROW_93_1649 VGND VPWR sky130_fd_sc_hd__tapvpwrvgnd_1
X_12367_ _05000_ _05010_ _05008_ VGND VGND VPWR VPWR _05143_ sky130_fd_sc_hd__a21o_1
XFILLER_59_6 VPWR VGND VPWR VGND sky130_ef_sc_hd__decap_12
XFILLER_113_237 VGND VGND VPWR VPWR sky130_fd_sc_hd__decap_4
XFILLER_113_215 VGND VGND VPWR VPWR sky130_fd_sc_hd__decap_8
XFILLER_99_449 VGND VGND VPWR VPWR sky130_fd_sc_hd__fill_2
X_12298_ _04934_ _04940_ _05066_ _05067_ VGND VGND VPWR VPWR _05069_ sky130_fd_sc_hd__and4_1
X_11318_ _04001_ _04002_ VGND VGND VPWR VPWR _04004_ sky130_fd_sc_hd__nand2b_1
X_11249_ net492 net288 VGND VGND VPWR VPWR _03928_ sky130_fd_sc_hd__nand2_1
XFILLER_122_793 VPWR VGND VPWR VGND sky130_ef_sc_hd__decap_12
XFILLER_95_633 VPWR VGND VPWR VGND sky130_ef_sc_hd__decap_12
XFILLER_121_281 VPWR VGND VPWR VGND sky130_ef_sc_hd__decap_12
XFILLER_94_121 VPWR VGND VPWR VGND sky130_ef_sc_hd__decap_12
XTAP_TAPCELL_ROW_124_2104 VGND VPWR sky130_fd_sc_hd__tapvpwrvgnd_1
XFILLER_82_305 VGND VGND VPWR VPWR sky130_fd_sc_hd__decap_3
XFILLER_55_519 VGND VGND VPWR VPWR sky130_fd_sc_hd__fill_1
XFILLER_48_560 VGND VGND VPWR VPWR sky130_fd_sc_hd__decap_4
XFILLER_94_187 VGND VGND VPWR VPWR sky130_fd_sc_hd__decap_8
XFILLER_48_593 VPWR VGND VPWR VGND sky130_ef_sc_hd__decap_12
XFILLER_48_582 VGND VGND VPWR VPWR sky130_fd_sc_hd__decap_6
XFILLER_36_722 VGND VGND VPWR VPWR sky130_fd_sc_hd__fill_1
XFILLER_63_552 VGND VGND VPWR VPWR sky130_fd_sc_hd__decap_8
XFILLER_51_714 VGND VGND VPWR VPWR sky130_fd_sc_hd__decap_4
X_08460_ _00928_ _00931_ VGND VGND VPWR VPWR _00933_ sky130_fd_sc_hd__xnor2_1
X_07411_ net668 net125 net444 net436 VGND VGND VPWR VPWR _06641_ sky130_fd_sc_hd__nand4_1
XFILLER_50_213 VPWR VGND VPWR VGND sky130_ef_sc_hd__decap_12
X_08391_ net251 _00864_ VGND VGND VPWR VPWR _00865_ sky130_fd_sc_hd__xor2_1
X_07342_ _06570_ _06572_ VGND VGND VPWR VPWR _00050_ sky130_fd_sc_hd__xor2_1
XTAP_TAPCELL_ROW_102_1778 VGND VPWR sky130_fd_sc_hd__tapvpwrvgnd_1
XTAP_TAPCELL_ROW_21_606 VGND VPWR sky130_fd_sc_hd__tapvpwrvgnd_1
X_07273_ net674 net416 VGND VGND VPWR VPWR _06312_ sky130_fd_sc_hd__nand2_1
XTAP_TAPCELL_ROW_135_2255 VGND VPWR sky130_fd_sc_hd__tapvpwrvgnd_1
XFILLER_129_370 VGND VGND VPWR VPWR sky130_fd_sc_hd__decap_4
X_09012_ _01332_ _01334_ _01489_ _01490_ VGND VGND VPWR VPWR _01491_ sky130_fd_sc_hd__a211o_1
XFILLER_129_381 VGND VGND VPWR VPWR sky130_fd_sc_hd__decap_4
XFILLER_117_543 VGND VGND VPWR VPWR sky130_fd_sc_hd__decap_8
XFILLER_132_513 VGND VGND VPWR VPWR sky130_fd_sc_hd__decap_8
XFILLER_117_587 VGND VGND VPWR VPWR sky130_fd_sc_hd__decap_8
XFILLER_105_727 VGND VGND VPWR VPWR sky130_fd_sc_hd__fill_1
X_09914_ _02056_ _02345_ _02344_ VGND VGND VPWR VPWR _02473_ sky130_fd_sc_hd__o21ai_1
Xfanout624 net625 VGND VGND VPWR VPWR net624 sky130_fd_sc_hd__clkbuf_4
Xfanout613 net617 VGND VGND VPWR VPWR net613 sky130_fd_sc_hd__clkbuf_4
Xfanout602 net605 VGND VGND VPWR VPWR net602 sky130_fd_sc_hd__clkbuf_4
X_09845_ net370 net601 VGND VGND VPWR VPWR _02399_ sky130_fd_sc_hd__and2b_1
Xfanout646 net647 VGND VGND VPWR VPWR net646 sky130_fd_sc_hd__buf_8
Xfanout635 net133 VGND VGND VPWR VPWR net635 sky130_fd_sc_hd__buf_4
XFILLER_98_471 VGND VGND VPWR VPWR sky130_fd_sc_hd__decap_4
Xfanout657 net658 VGND VGND VPWR VPWR net657 sky130_fd_sc_hd__buf_6
Xfanout679 net680 VGND VGND VPWR VPWR net679 sky130_fd_sc_hd__clkbuf_2
Xfanout668 net126 VGND VGND VPWR VPWR net668 sky130_fd_sc_hd__clkbuf_2
X_09776_ _02321_ _02322_ VGND VGND VPWR VPWR _02323_ sky130_fd_sc_hd__and2b_1
XFILLER_86_699 VGND VGND VPWR VPWR sky130_fd_sc_hd__fill_1
XFILLER_85_176 VGND VGND VPWR VPWR sky130_fd_sc_hd__decap_4
XFILLER_73_316 VPWR VGND VPWR VGND sky130_ef_sc_hd__decap_12
X_06988_ net460 net671 net451 net673 VGND VGND VPWR VPWR _03205_ sky130_fd_sc_hd__a22oi_1
XTAP_TAPCELL_ROW_29_717 VGND VPWR sky130_fd_sc_hd__tapvpwrvgnd_1
X_08727_ net473 net335 VGND VGND VPWR VPWR _01194_ sky130_fd_sc_hd__and2_1
XFILLER_85_187 VGND VGND VPWR VPWR sky130_fd_sc_hd__decap_4
XTAP_TAPCELL_ROW_1_320 VGND VPWR sky130_fd_sc_hd__tapvpwrvgnd_1
XFILLER_37_69 VPWR VGND VPWR VGND sky130_ef_sc_hd__decap_12
XFILLER_39_582 VGND VGND VPWR VPWR sky130_fd_sc_hd__fill_1
X_08658_ _01123_ _01124_ VGND VGND VPWR VPWR _01125_ sky130_fd_sc_hd__and2_1
XFILLER_54_563 VPWR VGND VPWR VGND sky130_ef_sc_hd__decap_12
XFILLER_81_360 VGND VGND VPWR VPWR sky130_fd_sc_hd__decap_6
X_07609_ _06679_ _06682_ VGND VGND VPWR VPWR _00089_ sky130_fd_sc_hd__nand2_1
XTAP_TAPCELL_ROW_64_1228 VGND VPWR sky130_fd_sc_hd__tapvpwrvgnd_1
XFILLER_41_213 VGND VGND VPWR VPWR sky130_fd_sc_hd__decap_8
XFILLER_14_416 VGND VGND VPWR VPWR sky130_fd_sc_hd__fill_1
XFILLER_26_287 VGND VGND VPWR VPWR sky130_fd_sc_hd__fill_2
X_08589_ _01049_ _01056_ VGND VGND VPWR VPWR _01057_ sky130_fd_sc_hd__nand2_1
XFILLER_81_393 VPWR VGND VPWR VGND sky130_ef_sc_hd__decap_12
XFILLER_53_57 VPWR VGND VPWR VGND sky130_ef_sc_hd__decap_12
XFILLER_42_769 VPWR VGND VPWR VGND sky130_ef_sc_hd__decap_12
X_10620_ _02947_ _03096_ _03239_ VGND VGND VPWR VPWR _03240_ sky130_fd_sc_hd__a21oi_1
X_10551_ _03162_ _03163_ _03160_ VGND VGND VPWR VPWR _03165_ sky130_fd_sc_hd__o21ai_1
X_13270_ net437 net428 net379 VGND VGND VPWR VPWR _06130_ sky130_fd_sc_hd__o21ai_1
X_10482_ _03087_ _03088_ VGND VGND VPWR VPWR _03089_ sky130_fd_sc_hd__and2b_1
X_12221_ net523 net399 net397 net529 VGND VGND VPWR VPWR _04984_ sky130_fd_sc_hd__a22oi_1
XFILLER_5_125 VGND VGND VPWR VPWR sky130_fd_sc_hd__decap_4
XFILLER_10_699 VGND VGND VPWR VPWR sky130_fd_sc_hd__fill_1
XFILLER_108_587 VGND VGND VPWR VPWR sky130_fd_sc_hd__fill_1
XFILLER_5_158 VGND VGND VPWR VPWR sky130_fd_sc_hd__decap_8
XFILLER_118_83 VGND VGND VPWR VPWR sky130_fd_sc_hd__fill_1
X_12152_ _04730_ _04768_ VGND VGND VPWR VPWR _04909_ sky130_fd_sc_hd__and2_1
XTAP_TAPCELL_ROW_9_431 VGND VPWR sky130_fd_sc_hd__tapvpwrvgnd_1
XFILLER_2_821 VGND VGND VPWR VPWR sky130_fd_sc_hd__decap_3
XFILLER_78_65 VPWR VGND VPWR VGND sky130_ef_sc_hd__decap_12
X_12083_ net464 net454 net392 net390 VGND VGND VPWR VPWR _04833_ sky130_fd_sc_hd__and4_1
X_11103_ net257 net295 VGND VGND VPWR VPWR _03768_ sky130_fd_sc_hd__nor2_1
XFILLER_104_793 VPWR VGND VPWR VGND sky130_ef_sc_hd__decap_12
X_11034_ _03690_ _03691_ _03510_ _03513_ VGND VGND VPWR VPWR _03693_ sky130_fd_sc_hd__o211a_1
XFILLER_103_281 VGND VGND VPWR VPWR sky130_fd_sc_hd__fill_2
XFILLER_49_357 VGND VGND VPWR VPWR sky130_fd_sc_hd__fill_1
XFILLER_49_335 VGND VGND VPWR VPWR sky130_fd_sc_hd__fill_1
XFILLER_94_53 VPWR VGND VPWR VGND sky130_ef_sc_hd__decap_12
XFILLER_92_614 VGND VGND VPWR VPWR sky130_fd_sc_hd__decap_8
XFILLER_92_603 VGND VGND VPWR VPWR sky130_fd_sc_hd__decap_4
XFILLER_65_817 VGND VGND VPWR VPWR sky130_fd_sc_hd__decap_3
XFILLER_91_113 VGND VGND VPWR VPWR sky130_fd_sc_hd__fill_1
X_12985_ net418 net384 _05816_ _05817_ VGND VGND VPWR VPWR _05818_ sky130_fd_sc_hd__o2bb2a_1
XFILLER_64_349 VPWR VGND VPWR VGND sky130_ef_sc_hd__decap_12
XFILLER_57_390 VGND VGND VPWR VPWR sky130_fd_sc_hd__fill_2
XFILLER_18_744 VPWR VGND VPWR VGND sky130_ef_sc_hd__decap_12
XFILLER_94_97 VPWR VGND VPWR VGND sky130_ef_sc_hd__decap_12
XFILLER_91_157 VGND VGND VPWR VPWR sky130_fd_sc_hd__decap_8
X_11936_ _04671_ _04672_ VGND VGND VPWR VPWR _04673_ sky130_fd_sc_hd__nor2_1
XFILLER_45_541 VPWR VGND VPWR VGND sky130_ef_sc_hd__decap_12
XFILLER_17_232 VGND VGND VPWR VPWR sky130_fd_sc_hd__fill_1
XFILLER_27_80 VGND VGND VPWR VPWR sky130_fd_sc_hd__decap_6
XFILLER_91_179 VGND VGND VPWR VPWR sky130_fd_sc_hd__decap_8
XFILLER_72_382 VGND VGND VPWR VPWR sky130_fd_sc_hd__decap_4
XFILLER_33_747 VPWR VGND VPWR VGND sky130_ef_sc_hd__decap_12
XFILLER_60_555 VGND VGND VPWR VPWR sky130_fd_sc_hd__decap_8
X_11867_ _04575_ _04599_ VGND VGND VPWR VPWR _04601_ sky130_fd_sc_hd__xor2_1
X_13606_ net246 _06370_ _06448_ VGND VGND VPWR VPWR _06495_ sky130_fd_sc_hd__o21ai_1
X_11798_ _04525_ _04496_ VGND VGND VPWR VPWR _04527_ sky130_fd_sc_hd__nand2b_1
XFILLER_20_419 VGND VGND VPWR VPWR sky130_fd_sc_hd__fill_1
X_10818_ net466 net270 VGND VGND VPWR VPWR _03457_ sky130_fd_sc_hd__nand2_4
X_13537_ _06415_ _06419_ VGND VGND VPWR VPWR _06420_ sky130_fd_sc_hd__xnor2_1
X_10749_ _03377_ _03378_ VGND VGND VPWR VPWR _03381_ sky130_fd_sc_hd__xnor2_1
XFILLER_118_307 VGND VGND VPWR VPWR sky130_fd_sc_hd__fill_1
X_13468_ _06343_ _06344_ VGND VGND VPWR VPWR _06346_ sky130_fd_sc_hd__nand2_1
XFILLER_9_497 VGND VGND VPWR VPWR sky130_fd_sc_hd__decap_6
X_13399_ _06268_ _06270_ VGND VGND VPWR VPWR _06271_ sky130_fd_sc_hd__nor2_1
X_12419_ _05197_ _05198_ _05043_ _05045_ VGND VGND VPWR VPWR _05201_ sky130_fd_sc_hd__a211o_1
XFILLER_57_3 VPWR VGND VPWR VGND sky130_ef_sc_hd__decap_12
Xoutput216 net216 VGND VGND VPWR VPWR y3[12] sky130_fd_sc_hd__buf_2
Xoutput205 net205 VGND VGND VPWR VPWR y2[2] sky130_fd_sc_hd__buf_2
XFILLER_126_384 VGND VGND VPWR VPWR sky130_fd_sc_hd__fill_2
Xoutput227 net227 VGND VGND VPWR VPWR y3[7] sky130_fd_sc_hd__buf_2
XTAP_TAPCELL_ROW_130_2185 VGND VPWR sky130_fd_sc_hd__tapvpwrvgnd_1
XFILLER_114_579 VGND VGND VPWR VPWR sky130_fd_sc_hd__decap_8
X_07960_ _00299_ _00436_ net688 VGND VGND VPWR VPWR _00437_ sky130_fd_sc_hd__and3b_1
XFILLER_99_279 VGND VGND VPWR VPWR sky130_fd_sc_hd__fill_1
X_06911_ _02347_ _02358_ VGND VGND VPWR VPWR _02369_ sky130_fd_sc_hd__nand2_1
XFILLER_114_19 VGND VGND VPWR VPWR sky130_fd_sc_hd__decap_8
XFILLER_67_110 VGND VGND VPWR VPWR sky130_fd_sc_hd__fill_2
X_07891_ _00367_ _00368_ VGND VGND VPWR VPWR _00369_ sky130_fd_sc_hd__nor2_1
X_09630_ _01910_ _02011_ _02010_ VGND VGND VPWR VPWR _02165_ sky130_fd_sc_hd__a21oi_1
XFILLER_68_699 VGND VGND VPWR VPWR sky130_fd_sc_hd__fill_1
X_06842_ _01594_ _01605_ VGND VGND VPWR VPWR _01616_ sky130_fd_sc_hd__nor2_1
X_09561_ _02081_ _02088_ VGND VGND VPWR VPWR _02089_ sky130_fd_sc_hd__xnor2_1
XFILLER_83_636 VPWR VGND VPWR VGND sky130_ef_sc_hd__decap_12
XFILLER_82_124 VPWR VGND VPWR VGND sky130_ef_sc_hd__decap_12
XTAP_TAPCELL_ROW_104_1807 VGND VPWR sky130_fd_sc_hd__tapvpwrvgnd_1
X_08512_ _00911_ _00914_ _00915_ _00918_ VGND VGND VPWR VPWR _00984_ sky130_fd_sc_hd__a31o_1
XFILLER_130_29 VPWR VGND VPWR VGND sky130_ef_sc_hd__decap_12
X_09492_ _02012_ _02013_ VGND VGND VPWR VPWR _02014_ sky130_fd_sc_hd__nor2_1
XFILLER_63_360 VPWR VGND VPWR VGND sky130_ef_sc_hd__decap_12
X_08443_ _00914_ _00915_ VGND VGND VPWR VPWR _00916_ sky130_fd_sc_hd__nand2_1
XFILLER_51_555 VGND VGND VPWR VPWR sky130_fd_sc_hd__decap_4
X_08374_ _00750_ _00751_ _00778_ VGND VGND VPWR VPWR _00848_ sky130_fd_sc_hd__o21a_1
XFILLER_23_27 VPWR VGND VPWR VGND sky130_ef_sc_hd__decap_12
XTAP_TAPCELL_ROW_34_786 VGND VPWR sky130_fd_sc_hd__tapvpwrvgnd_1
X_07325_ _06291_ _06554_ _06555_ VGND VGND VPWR VPWR _06556_ sky130_fd_sc_hd__nand3_1
XTAP_TAPCELL_ROW_34_797 VGND VPWR sky130_fd_sc_hd__tapvpwrvgnd_1
X_07256_ _06105_ _06116_ VGND VGND VPWR VPWR _06127_ sky130_fd_sc_hd__nand2b_1
XFILLER_105_502 VGND VGND VPWR VPWR sky130_fd_sc_hd__fill_2
X_07187_ _05363_ VGND VGND VPWR VPWR _05374_ sky130_fd_sc_hd__inv_2
XTAP_TAPCELL_ROW_115_1969 VGND VPWR sky130_fd_sc_hd__tapvpwrvgnd_1
XFILLER_3_629 VGND VGND VPWR VPWR sky130_fd_sc_hd__decap_6
XFILLER_2_139 VGND VGND VPWR VPWR sky130_fd_sc_hd__fill_1
XFILLER_132_365 VGND VGND VPWR VPWR sky130_fd_sc_hd__fill_2
Xfanout432 net159 VGND VGND VPWR VPWR net432 sky130_fd_sc_hd__clkbuf_4
Xfanout421 net160 VGND VGND VPWR VPWR net421 sky130_fd_sc_hd__buf_2
Xfanout410 net411 VGND VGND VPWR VPWR net410 sky130_fd_sc_hd__clkbuf_4
Xfanout454 net456 VGND VGND VPWR VPWR net454 sky130_fd_sc_hd__buf_2
XFILLER_58_121 VGND VGND VPWR VPWR sky130_fd_sc_hd__fill_1
Xfanout443 net448 VGND VGND VPWR VPWR net443 sky130_fd_sc_hd__clkbuf_4
Xfanout465 net155 VGND VGND VPWR VPWR net465 sky130_fd_sc_hd__clkbuf_4
XPHY_EDGE_ROW_122_Right_122 VGND VGND VPWR VPWR sky130_fd_sc_hd__decap_3
X_09828_ _02240_ _02247_ _02246_ VGND VGND VPWR VPWR _02381_ sky130_fd_sc_hd__a21oi_1
XFILLER_101_785 VPWR VGND VPWR VGND sky130_ef_sc_hd__decap_12
XFILLER_100_251 VGND VGND VPWR VPWR sky130_fd_sc_hd__fill_1
Xfanout498 net499 VGND VGND VPWR VPWR net498 sky130_fd_sc_hd__clkbuf_2
Xfanout487 net491 VGND VGND VPWR VPWR net487 sky130_fd_sc_hd__buf_2
XFILLER_74_625 VGND VGND VPWR VPWR sky130_fd_sc_hd__fill_2
Xfanout476 net477 VGND VGND VPWR VPWR net476 sky130_fd_sc_hd__clkbuf_4
X_09759_ _02302_ _02303_ VGND VGND VPWR VPWR _02306_ sky130_fd_sc_hd__xnor2_2
XFILLER_104_41 VPWR VGND VPWR VGND sky130_ef_sc_hd__decap_12
XFILLER_58_187 VGND VGND VPWR VPWR sky130_fd_sc_hd__decap_8
XPHY_EDGE_ROW_100_Left_239 VGND VGND VPWR VPWR sky130_fd_sc_hd__decap_3
XFILLER_73_157 VGND VGND VPWR VPWR sky130_fd_sc_hd__decap_8
XFILLER_27_552 VGND VGND VPWR VPWR sky130_fd_sc_hd__fill_1
X_12770_ _05581_ _05582_ VGND VGND VPWR VPWR _05583_ sky130_fd_sc_hd__xnor2_1
XFILLER_14_202 VGND VGND VPWR VPWR sky130_fd_sc_hd__decap_8
XFILLER_42_533 VPWR VGND VPWR VGND sky130_ef_sc_hd__decap_12
XFILLER_15_769 VPWR VGND VPWR VGND sky130_ef_sc_hd__decap_12
X_11721_ _04350_ _04437_ VGND VGND VPWR VPWR _04442_ sky130_fd_sc_hd__xnor2_1
X_11652_ net415 _04266_ VGND VGND VPWR VPWR _04367_ sky130_fd_sc_hd__and2_1
XFILLER_30_728 VPWR VGND VPWR VGND sky130_ef_sc_hd__decap_12
X_10603_ _03219_ _03220_ VGND VGND VPWR VPWR _03221_ sky130_fd_sc_hd__nand2_1
X_13322_ _06184_ _06185_ VGND VGND VPWR VPWR _06186_ sky130_fd_sc_hd__and2_1
XFILLER_80_88 VPWR VGND VPWR VGND sky130_ef_sc_hd__decap_12
X_11583_ _04290_ _04291_ VGND VGND VPWR VPWR _04292_ sky130_fd_sc_hd__and2_2
XTAP_TAPCELL_ROW_12_469 VGND VPWR sky130_fd_sc_hd__tapvpwrvgnd_1
XFILLER_22_290 VGND VGND VPWR VPWR sky130_fd_sc_hd__decap_6
XTAP_TAPCELL_ROW_77_1419 VGND VPWR sky130_fd_sc_hd__tapvpwrvgnd_1
XFILLER_10_474 VGND VGND VPWR VPWR sky130_fd_sc_hd__fill_2
XFILLER_13_93 VGND VGND VPWR VPWR sky130_fd_sc_hd__decap_8
X_10534_ _03144_ _03145_ VGND VGND VPWR VPWR _03146_ sky130_fd_sc_hd__nor2_1
XFILLER_129_93 VPWR VGND VPWR VGND sky130_ef_sc_hd__decap_12
XFILLER_89_31 VPWR VGND VPWR VGND sky130_ef_sc_hd__decap_12
X_13253_ _05316_ _05999_ _05998_ VGND VGND VPWR VPWR _06111_ sky130_fd_sc_hd__o21bai_1
XFILLER_6_467 VGND VGND VPWR VPWR sky130_fd_sc_hd__fill_2
X_10465_ _03059_ _03064_ _03066_ VGND VGND VPWR VPWR _03071_ sky130_fd_sc_hd__a21bo_1
X_12204_ _04823_ _04964_ VGND VGND VPWR VPWR _04965_ sky130_fd_sc_hd__and2_1
X_13184_ _05965_ _05967_ VGND VGND VPWR VPWR _06035_ sky130_fd_sc_hd__nor2_1
X_10396_ _02992_ _02993_ _02994_ VGND VGND VPWR VPWR _02995_ sky130_fd_sc_hd__nand3_1
XTAP_TAPCELL_ROW_90_1608 VGND VPWR sky130_fd_sc_hd__tapvpwrvgnd_1
X_12135_ _04847_ _04887_ _04889_ VGND VGND VPWR VPWR _04890_ sky130_fd_sc_hd__nor3_1
XFILLER_96_227 VGND VGND VPWR VPWR sky130_fd_sc_hd__fill_1
X_12066_ _04812_ _04813_ VGND VGND VPWR VPWR _04814_ sky130_fd_sc_hd__or2_1
X_11017_ _03671_ _03672_ _00108_ VGND VGND VPWR VPWR _03674_ sky130_fd_sc_hd__a21o_1
XFILLER_92_433 VPWR VGND VPWR VGND sky130_ef_sc_hd__decap_12
XFILLER_77_496 VGND VGND VPWR VPWR sky130_fd_sc_hd__decap_3
Xclkbuf_3_7__f_clk clknet_0_clk VGND VGND VPWR VPWR clknet_3_7__leaf_clk sky130_fd_sc_hd__clkbuf_16
XFILLER_80_617 VPWR VGND VPWR VGND sky130_ef_sc_hd__decap_12
XFILLER_80_606 VGND VGND VPWR VPWR sky130_fd_sc_hd__fill_1
XFILLER_53_809 VGND VGND VPWR VPWR sky130_fd_sc_hd__decap_8
X_12968_ net388 net254 VGND VGND VPWR VPWR _05800_ sky130_fd_sc_hd__nor2_1
XFILLER_45_360 VGND VGND VPWR VPWR sky130_fd_sc_hd__decap_4
X_12899_ _05722_ _05724_ VGND VGND VPWR VPWR _05725_ sky130_fd_sc_hd__and2b_1
XFILLER_45_393 VGND VGND VPWR VPWR sky130_fd_sc_hd__decap_8
X_11919_ _04604_ _04607_ _04657_ VGND VGND VPWR VPWR _04658_ sky130_fd_sc_hd__a21boi_1
XFILLER_60_363 VGND VGND VPWR VPWR sky130_fd_sc_hd__fill_1
XTAP_TAPCELL_ROW_119_2025 VGND VPWR sky130_fd_sc_hd__tapvpwrvgnd_1
XFILLER_14_791 VPWR VGND VPWR VGND sky130_ef_sc_hd__decap_12
XFILLER_21_739 VPWR VGND VPWR VGND sky130_ef_sc_hd__decap_12
X_07110_ _04264_ _04515_ VGND VGND VPWR VPWR _04537_ sky130_fd_sc_hd__and2_1
XTAP_TAPCELL_ROW_31_745 VGND VPWR sky130_fd_sc_hd__tapvpwrvgnd_1
XFILLER_9_294 VGND VGND VPWR VPWR sky130_fd_sc_hd__decap_3
X_08090_ net545 _00437_ _00565_ VGND VGND VPWR VPWR _00566_ sky130_fd_sc_hd__a21oi_1
XTAP_TAPCELL_ROW_132_2214 VGND VPWR sky130_fd_sc_hd__tapvpwrvgnd_1
X_07041_ _03664_ _03686_ _03675_ VGND VGND VPWR VPWR _03784_ sky130_fd_sc_hd__a21o_1
XFILLER_127_671 VGND VGND VPWR VPWR sky130_fd_sc_hd__fill_1
XFILLER_114_365 VGND VGND VPWR VPWR sky130_fd_sc_hd__decap_8
X_08992_ net616 net375 VGND VGND VPWR VPWR _01469_ sky130_fd_sc_hd__nand2_1
XFILLER_114_398 VGND VGND VPWR VPWR sky130_fd_sc_hd__fill_1
XFILLER_96_750 VGND VGND VPWR VPWR sky130_fd_sc_hd__decap_6
XFILLER_68_430 VGND VGND VPWR VPWR sky130_fd_sc_hd__decap_6
X_07943_ _00419_ _00420_ VGND VGND VPWR VPWR _00421_ sky130_fd_sc_hd__nor2_1
XTAP_TAPCELL_ROW_110_1899 VGND VPWR sky130_fd_sc_hd__tapvpwrvgnd_1
XTAP_TAPCELL_ROW_110_1888 VGND VPWR sky130_fd_sc_hd__tapvpwrvgnd_1
X_07874_ net669 net411 VGND VGND VPWR VPWR _00352_ sky130_fd_sc_hd__and2b_1
X_09613_ _02139_ _02145_ VGND VGND VPWR VPWR _02146_ sky130_fd_sc_hd__xnor2_2
XFILLER_55_113 VGND VGND VPWR VPWR sky130_fd_sc_hd__decap_4
XFILLER_18_27 VGND VGND VPWR VPWR sky130_fd_sc_hd__fill_1
X_06825_ net327 VGND VGND VPWR VPWR _01431_ sky130_fd_sc_hd__inv_2
XTAP_TAPCELL_ROW_39_867 VGND VPWR sky130_fd_sc_hd__tapvpwrvgnd_1
X_09544_ _02033_ _02069_ VGND VGND VPWR VPWR _02070_ sky130_fd_sc_hd__nand2b_1
XFILLER_83_499 VGND VGND VPWR VPWR sky130_fd_sc_hd__decap_4
XFILLER_36_360 VGND VGND VPWR VPWR sky130_fd_sc_hd__decap_4
X_09475_ _01993_ _01994_ VGND VGND VPWR VPWR _01995_ sky130_fd_sc_hd__nor2_1
XFILLER_70_138 VGND VGND VPWR VPWR sky130_fd_sc_hd__fill_2
XTAP_TAPCELL_ROW_19_580 VGND VPWR sky130_fd_sc_hd__tapvpwrvgnd_1
XFILLER_34_15 VPWR VGND VPWR VGND sky130_ef_sc_hd__decap_12
X_08426_ _00896_ _00897_ VGND VGND VPWR VPWR _00899_ sky130_fd_sc_hd__xnor2_1
XFILLER_12_728 VPWR VGND VPWR VGND sky130_ef_sc_hd__decap_12
Xclkload3 clknet_3_5__leaf_clk VGND VGND VPWR VPWR clkload3/X sky130_fd_sc_hd__clkbuf_8
X_08357_ _06803_ _00829_ VGND VGND VPWR VPWR _00831_ sky130_fd_sc_hd__nor2_1
X_07308_ _06536_ _06537_ _06535_ VGND VGND VPWR VPWR _06539_ sky130_fd_sc_hd__o21ai_1
X_08288_ net663 _00648_ _00644_ VGND VGND VPWR VPWR _00763_ sky130_fd_sc_hd__a21oi_1
X_07239_ _05570_ _05930_ VGND VGND VPWR VPWR _05941_ sky130_fd_sc_hd__xnor2_1
XFILLER_106_811 VGND VGND VPWR VPWR sky130_fd_sc_hd__fill_1
XTAP_TAPCELL_ROW_59_1149 VGND VPWR sky130_fd_sc_hd__tapvpwrvgnd_1
X_10250_ _02833_ _02836_ VGND VGND VPWR VPWR _00001_ sky130_fd_sc_hd__and2_1
XFILLER_133_630 VPWR VGND VPWR VGND sky130_ef_sc_hd__decap_12
XFILLER_79_706 VPWR VGND VPWR VGND sky130_ef_sc_hd__decap_12
XFILLER_3_437 VGND VGND VPWR VPWR sky130_fd_sc_hd__fill_1
X_10181_ _02714_ _02737_ _02713_ VGND VGND VPWR VPWR _02764_ sky130_fd_sc_hd__a21o_1
XFILLER_105_376 VGND VGND VPWR VPWR sky130_fd_sc_hd__fill_2
XTAP_TAPCELL_ROW_72_1349 VGND VPWR sky130_fd_sc_hd__tapvpwrvgnd_1
XTAP_TAPCELL_ROW_72_1338 VGND VPWR sky130_fd_sc_hd__tapvpwrvgnd_1
XFILLER_105_398 VGND VGND VPWR VPWR sky130_fd_sc_hd__decap_8
XFILLER_115_51 VGND VGND VPWR VPWR sky130_fd_sc_hd__decap_4
Xfanout262 _01365_ VGND VGND VPWR VPWR net262 sky130_fd_sc_hd__clkbuf_4
Xfanout251 _00319_ VGND VGND VPWR VPWR net251 sky130_fd_sc_hd__clkbuf_4
XFILLER_19_305 VGND VGND VPWR VPWR sky130_fd_sc_hd__decap_6
Xfanout273 net96 VGND VGND VPWR VPWR net273 sky130_fd_sc_hd__buf_1
XFILLER_75_55 VGND VGND VPWR VPWR sky130_fd_sc_hd__fill_1
Xfanout284 net9 VGND VGND VPWR VPWR net284 sky130_fd_sc_hd__buf_2
XFILLER_46_124 VPWR VGND VPWR VGND sky130_ef_sc_hd__decap_12
Xfanout295 net84 VGND VGND VPWR VPWR net295 sky130_fd_sc_hd__clkbuf_4
XFILLER_47_658 VPWR VGND VPWR VGND sky130_ef_sc_hd__decap_12
XFILLER_35_809 VGND VGND VPWR VPWR sky130_fd_sc_hd__decap_8
X_12822_ _05627_ _05639_ VGND VGND VPWR VPWR _05640_ sky130_fd_sc_hd__xor2_1
XFILLER_74_477 VGND VGND VPWR VPWR sky130_fd_sc_hd__decap_8
X_12753_ _05562_ _05563_ _05386_ VGND VGND VPWR VPWR _05565_ sky130_fd_sc_hd__a21oi_1
XTAP_TAPCELL_ROW_17_539 VGND VPWR sky130_fd_sc_hd__tapvpwrvgnd_1
XFILLER_27_393 VPWR VGND VPWR VGND sky130_ef_sc_hd__decap_12
X_11704_ _04168_ _04423_ VGND VGND VPWR VPWR _04424_ sky130_fd_sc_hd__xnor2_1
X_12684_ _05169_ _05345_ _05344_ VGND VGND VPWR VPWR _05490_ sky130_fd_sc_hd__a21o_1
XFILLER_42_385 VGND VGND VPWR VPWR sky130_fd_sc_hd__fill_2
XFILLER_15_599 VGND VGND VPWR VPWR sky130_fd_sc_hd__decap_8
XFILLER_30_547 VPWR VGND VPWR VGND sky130_ef_sc_hd__decap_12
X_11635_ _04346_ _04347_ VGND VGND VPWR VPWR _04348_ sky130_fd_sc_hd__nor2_1
X_11566_ _04260_ _04272_ VGND VGND VPWR VPWR _04273_ sky130_fd_sc_hd__or2_1
X_13305_ _05567_ _05566_ _05730_ _06166_ VGND VGND VPWR VPWR _06168_ sky130_fd_sc_hd__and4bb_1
XFILLER_7_765 VPWR VGND VPWR VGND sky130_ef_sc_hd__decap_12
X_10517_ _03126_ _03119_ VGND VGND VPWR VPWR _03127_ sky130_fd_sc_hd__and2b_1
X_13236_ _06086_ _06090_ VGND VGND VPWR VPWR _06092_ sky130_fd_sc_hd__xnor2_1
XFILLER_6_275 VGND VGND VPWR VPWR sky130_fd_sc_hd__fill_1
X_11497_ _04197_ _04189_ VGND VGND VPWR VPWR _04198_ sky130_fd_sc_hd__nand2b_1
X_10448_ _03048_ _03049_ _02941_ VGND VGND VPWR VPWR _03053_ sky130_fd_sc_hd__a21oi_1
XFILLER_111_302 VGND VGND VPWR VPWR sky130_fd_sc_hd__fill_1
XFILLER_97_503 VGND VGND VPWR VPWR sky130_fd_sc_hd__fill_1
X_13167_ _05933_ _06016_ VGND VGND VPWR VPWR _06017_ sky130_fd_sc_hd__xnor2_2
X_10379_ _02961_ _02974_ VGND VGND VPWR VPWR _02977_ sky130_fd_sc_hd__xnor2_1
XFILLER_123_173 VGND VGND VPWR VPWR sky130_fd_sc_hd__fill_1
XFILLER_111_324 VPWR VGND VPWR VGND sky130_ef_sc_hd__decap_12
XFILLER_97_569 VGND VGND VPWR VPWR sky130_fd_sc_hd__decap_4
XFILLER_97_558 VGND VGND VPWR VPWR sky130_fd_sc_hd__fill_2
X_13098_ net495 net394 _05629_ _05786_ VGND VGND VPWR VPWR _05942_ sky130_fd_sc_hd__a22oi_1
X_12118_ _04861_ _04868_ _04867_ VGND VGND VPWR VPWR _04872_ sky130_fd_sc_hd__a21oi_1
XFILLER_2_481 VGND VGND VPWR VPWR sky130_fd_sc_hd__decap_3
X_12049_ _04743_ _04795_ VGND VGND VPWR VPWR _04796_ sky130_fd_sc_hd__nor2_1
XFILLER_78_783 VGND VGND VPWR VPWR sky130_fd_sc_hd__fill_1
XFILLER_65_422 VGND VGND VPWR VPWR sky130_fd_sc_hd__decap_8
XFILLER_37_113 VPWR VGND VPWR VGND sky130_ef_sc_hd__decap_12
XFILLER_92_230 VGND VGND VPWR VPWR sky130_fd_sc_hd__fill_1
XFILLER_93_797 VPWR VGND VPWR VGND sky130_ef_sc_hd__decap_12
XFILLER_92_285 VPWR VGND VPWR VGND sky130_ef_sc_hd__decap_12
X_07590_ net667 net669 net434 net427 VGND VGND VPWR VPWR _00070_ sky130_fd_sc_hd__and4_1
XFILLER_53_617 VGND VGND VPWR VPWR sky130_fd_sc_hd__fill_2
XTAP_TAPCELL_ROW_36_815 VGND VPWR sky130_fd_sc_hd__tapvpwrvgnd_1
XTAP_TAPCELL_ROW_36_826 VGND VPWR sky130_fd_sc_hd__tapvpwrvgnd_1
X_09260_ _01757_ _01759_ VGND VGND VPWR VPWR _01761_ sky130_fd_sc_hd__xnor2_1
XFILLER_21_503 VGND VGND VPWR VPWR sky130_fd_sc_hd__fill_1
XFILLER_60_160 VGND VGND VPWR VPWR sky130_fd_sc_hd__fill_1
X_08211_ _00443_ _00575_ _00574_ VGND VGND VPWR VPWR _00686_ sky130_fd_sc_hd__a21oi_1
X_09191_ _01515_ _01512_ _01511_ VGND VGND VPWR VPWR _01686_ sky130_fd_sc_hd__a21o_1
XFILLER_21_569 VGND VGND VPWR VPWR sky130_fd_sc_hd__fill_1
X_08142_ _00617_ _00597_ VGND VGND VPWR VPWR _00618_ sky130_fd_sc_hd__and2b_1
XFILLER_134_405 VPWR VGND VPWR VGND sky130_ef_sc_hd__decap_12
X_08073_ _00296_ _00418_ _00417_ VGND VGND VPWR VPWR _00550_ sky130_fd_sc_hd__a21oi_2
X_07024_ _03347_ _03576_ _03565_ VGND VGND VPWR VPWR _03598_ sky130_fd_sc_hd__o21bai_1
XFILLER_127_490 VGND VGND VPWR VPWR sky130_fd_sc_hd__fill_1
XFILLER_115_641 VGND VGND VPWR VPWR sky130_fd_sc_hd__fill_1
XTAP_TAPCELL_ROW_112_1917 VGND VPWR sky130_fd_sc_hd__tapvpwrvgnd_1
XTAP_TAPCELL_ROW_112_1928 VGND VPWR sky130_fd_sc_hd__tapvpwrvgnd_1
XFILLER_130_622 VPWR VGND VPWR VGND sky130_ef_sc_hd__decap_12
X_08975_ _01446_ _01448_ _01449_ VGND VGND VPWR VPWR _01450_ sky130_fd_sc_hd__or3_1
XFILLER_29_15 VPWR VGND VPWR VGND sky130_ef_sc_hd__decap_12
X_07926_ _00252_ _00266_ _00265_ VGND VGND VPWR VPWR _00404_ sky130_fd_sc_hd__o21a_1
XTAP_TAPCELL_ROW_54_1079 VGND VPWR sky130_fd_sc_hd__tapvpwrvgnd_1
XFILLER_130_699 VGND VGND VPWR VPWR sky130_fd_sc_hd__fill_1
XFILLER_75_219 VGND VGND VPWR VPWR sky130_fd_sc_hd__decap_4
XFILLER_69_783 VGND VGND VPWR VPWR sky130_fd_sc_hd__fill_1
XFILLER_28_113 VGND VGND VPWR VPWR sky130_fd_sc_hd__fill_1
XFILLER_83_241 VGND VGND VPWR VPWR sky130_fd_sc_hd__fill_1
XFILLER_56_455 VGND VGND VPWR VPWR sky130_fd_sc_hd__decap_6
X_07857_ _00207_ _00218_ _00217_ VGND VGND VPWR VPWR _00335_ sky130_fd_sc_hd__o21ai_2
XFILLER_17_809 VPWR VGND VPWR VGND sky130_ef_sc_hd__decap_12
XFILLER_29_658 VGND VGND VPWR VPWR sky130_fd_sc_hd__decap_4
X_07788_ _00252_ _00266_ VGND VGND VPWR VPWR _00267_ sky130_fd_sc_hd__xnor2_2
XFILLER_56_477 VPWR VGND VPWR VGND sky130_ef_sc_hd__decap_12
XFILLER_44_628 VGND VGND VPWR VPWR sky130_fd_sc_hd__fill_2
XFILLER_43_105 VGND VGND VPWR VPWR sky130_fd_sc_hd__decap_6
XFILLER_16_319 VGND VGND VPWR VPWR sky130_fd_sc_hd__decap_3
X_09527_ _01880_ _02050_ VGND VGND VPWR VPWR _02051_ sky130_fd_sc_hd__nand2_1
XFILLER_45_69 VPWR VGND VPWR VGND sky130_ef_sc_hd__decap_12
XFILLER_101_42 VPWR VGND VPWR VGND sky130_ef_sc_hd__decap_12
XFILLER_52_672 VGND VGND VPWR VPWR sky130_fd_sc_hd__fill_1
XTAP_TAPCELL_ROW_14_509 VGND VPWR sky130_fd_sc_hd__tapvpwrvgnd_1
XFILLER_36_190 VGND VGND VPWR VPWR sky130_fd_sc_hd__decap_6
X_09458_ _01974_ _01975_ VGND VGND VPWR VPWR _01977_ sky130_fd_sc_hd__xnor2_1
XFILLER_52_694 VGND VGND VPWR VPWR sky130_fd_sc_hd__decap_6
XFILLER_51_160 VGND VGND VPWR VPWR sky130_fd_sc_hd__decap_8
X_09389_ _01719_ _01734_ _01733_ VGND VGND VPWR VPWR _01902_ sky130_fd_sc_hd__o21ai_2
XFILLER_61_57 VGND VGND VPWR VPWR sky130_fd_sc_hd__decap_8
X_08409_ _00880_ _00881_ VGND VGND VPWR VPWR _00883_ sky130_fd_sc_hd__xor2_1
XFILLER_8_507 VGND VGND VPWR VPWR sky130_fd_sc_hd__fill_2
XFILLER_12_558 VGND VGND VPWR VPWR sky130_fd_sc_hd__fill_1
XFILLER_61_79 VGND VGND VPWR VPWR sky130_fd_sc_hd__fill_1
X_11420_ _04104_ _04113_ VGND VGND VPWR VPWR _04115_ sky130_fd_sc_hd__xor2_1
XFILLER_124_3 VPWR VGND VPWR VGND sky130_ef_sc_hd__decap_12
X_11351_ _04036_ _04038_ VGND VGND VPWR VPWR _04039_ sky130_fd_sc_hd__nor2_1
XFILLER_137_298 VGND VGND VPWR VPWR sky130_fd_sc_hd__decap_8
XFILLER_137_287 VGND VGND VPWR VPWR sky130_fd_sc_hd__fill_1
XFILLER_4_735 VPWR VGND VPWR VGND sky130_ef_sc_hd__decap_12
X_10302_ net527 net293 VGND VGND VPWR VPWR _02892_ sky130_fd_sc_hd__nand2_1
XFILLER_125_449 VPWR VGND VPWR VGND sky130_ef_sc_hd__decap_12
XFILLER_4_757 VPWR VGND VPWR VGND sky130_ef_sc_hd__decap_12
X_11282_ net442 _03638_ VGND VGND VPWR VPWR _03964_ sky130_fd_sc_hd__nand2_4
XFILLER_106_685 VPWR VGND VPWR VGND sky130_ef_sc_hd__decap_12
X_13021_ _05855_ _05856_ VGND VGND VPWR VPWR _05858_ sky130_fd_sc_hd__xor2_1
X_10233_ net527 net520 net297 VGND VGND VPWR VPWR _02818_ sky130_fd_sc_hd__and3_1
X_10164_ _02743_ _02744_ VGND VGND VPWR VPWR _02746_ sky130_fd_sc_hd__xnor2_1
XFILLER_120_121 VPWR VGND VPWR VGND sky130_ef_sc_hd__decap_12
XFILLER_10_83 VGND VGND VPWR VPWR sky130_fd_sc_hd__fill_1
XFILLER_126_83 VGND VGND VPWR VPWR sky130_fd_sc_hd__fill_1
XFILLER_86_65 VPWR VGND VPWR VGND sky130_ef_sc_hd__decap_12
XFILLER_67_709 VPWR VGND VPWR VGND sky130_ef_sc_hd__decap_12
X_10095_ _02579_ _02670_ VGND VGND VPWR VPWR _02671_ sky130_fd_sc_hd__xnor2_1
XFILLER_120_165 VPWR VGND VPWR VGND sky130_ef_sc_hd__decap_12
XFILLER_19_113 VGND VGND VPWR VPWR sky130_fd_sc_hd__decap_4
XFILLER_47_455 VPWR VGND VPWR VGND sky130_ef_sc_hd__decap_12
XFILLER_19_81 VPWR VGND VPWR VGND sky130_ef_sc_hd__decap_12
XTAP_TAPCELL_ROW_85_1529 VGND VPWR sky130_fd_sc_hd__tapvpwrvgnd_1
XFILLER_62_414 VGND VGND VPWR VPWR sky130_fd_sc_hd__decap_6
XFILLER_62_403 VGND VGND VPWR VPWR sky130_fd_sc_hd__decap_4
XFILLER_35_617 VPWR VGND VPWR VGND sky130_ef_sc_hd__decap_12
X_12805_ _05489_ _05509_ _05508_ VGND VGND VPWR VPWR _05621_ sky130_fd_sc_hd__o21ba_1
XFILLER_34_116 VGND VGND VPWR VPWR sky130_fd_sc_hd__fill_1
X_10997_ _03630_ _03651_ VGND VGND VPWR VPWR _03652_ sky130_fd_sc_hd__xnor2_1
X_12736_ _05544_ _05545_ _05365_ _05367_ VGND VGND VPWR VPWR _05547_ sky130_fd_sc_hd__a211oi_2
XFILLER_30_300 VGND VGND VPWR VPWR sky130_fd_sc_hd__fill_1
X_12667_ net453 net31 _05318_ _05320_ VGND VGND VPWR VPWR _05471_ sky130_fd_sc_hd__a31o_1
X_11618_ _04080_ _04218_ _04328_ VGND VGND VPWR VPWR _04330_ sky130_fd_sc_hd__a21oi_1
X_12598_ _05270_ _05272_ _05393_ VGND VGND VPWR VPWR _05396_ sky130_fd_sc_hd__and3_1
XTAP_TAPCELL_ROW_41_895 VGND VPWR sky130_fd_sc_hd__tapvpwrvgnd_1
XFILLER_11_591 VGND VGND VPWR VPWR sky130_fd_sc_hd__decap_6
XFILLER_128_276 VPWR VGND VPWR VGND sky130_ef_sc_hd__decap_12
XFILLER_128_265 VGND VGND VPWR VPWR sky130_fd_sc_hd__fill_1
X_11549_ _04248_ _04252_ VGND VGND VPWR VPWR _04255_ sky130_fd_sc_hd__xnor2_1
Xmax_cap237 _03047_ VGND VGND VPWR VPWR net237 sky130_fd_sc_hd__clkbuf_2
X_13219_ _05948_ _05949_ _05962_ _05961_ _05960_ VGND VGND VPWR VPWR _06074_ sky130_fd_sc_hd__o32a_1
XFILLER_97_377 VGND VGND VPWR VPWR sky130_fd_sc_hd__fill_1
XFILLER_85_517 VGND VGND VPWR VPWR sky130_fd_sc_hd__decap_8
XTAP_TAPCELL_ROW_127_2146 VGND VPWR sky130_fd_sc_hd__tapvpwrvgnd_1
XTAP_TAPCELL_ROW_127_2135 VGND VPWR sky130_fd_sc_hd__tapvpwrvgnd_1
X_08760_ _01217_ _01220_ _01219_ VGND VGND VPWR VPWR _01227_ sky130_fd_sc_hd__o21ba_1
XFILLER_85_528 VPWR VGND VPWR VGND sky130_ef_sc_hd__decap_12
X_08691_ _01150_ _01152_ VGND VGND VPWR VPWR _01158_ sky130_fd_sc_hd__xnor2_1
X_07711_ _06797_ _06811_ _06810_ VGND VGND VPWR VPWR _00190_ sky130_fd_sc_hd__o21ai_2
XFILLER_38_455 VGND VGND VPWR VPWR sky130_fd_sc_hd__fill_2
X_07642_ _00119_ _00120_ _00088_ VGND VGND VPWR VPWR _00122_ sky130_fd_sc_hd__a21oi_1
XFILLER_81_745 VGND VGND VPWR VPWR sky130_fd_sc_hd__fill_1
XFILLER_80_233 VGND VGND VPWR VPWR sky130_fd_sc_hd__decap_8
X_09312_ net613 net373 VGND VGND VPWR VPWR _01818_ sky130_fd_sc_hd__nand2_1
X_07573_ _06633_ _06800_ VGND VGND VPWR VPWR _06802_ sky130_fd_sc_hd__xnor2_1
XFILLER_15_39 VPWR VGND VPWR VGND sky130_ef_sc_hd__decap_12
X_09243_ _01693_ _01740_ VGND VGND VPWR VPWR _01742_ sky130_fd_sc_hd__xnor2_1
XFILLER_61_491 VPWR VGND VPWR VGND sky130_ef_sc_hd__decap_12
X_09174_ _01607_ _01666_ VGND VGND VPWR VPWR _01667_ sky130_fd_sc_hd__or2_1
XTAP_TAPCELL_ROW_138_2297 VGND VPWR sky130_fd_sc_hd__tapvpwrvgnd_1
X_08125_ _00599_ _00600_ VGND VGND VPWR VPWR _00601_ sky130_fd_sc_hd__nand2b_1
XFILLER_31_27 VPWR VGND VPWR VGND sky130_ef_sc_hd__decap_12
XFILLER_107_438 VGND VGND VPWR VPWR sky130_fd_sc_hd__decap_3
XFILLER_107_416 VGND VGND VPWR VPWR sky130_fd_sc_hd__decap_3
X_08056_ _00522_ _00532_ VGND VGND VPWR VPWR _00533_ sky130_fd_sc_hd__xnor2_1
XTAP_TAPCELL_ROW_56_1108 VGND VPWR sky130_fd_sc_hd__tapvpwrvgnd_1
XFILLER_115_460 VGND VGND VPWR VPWR sky130_fd_sc_hd__fill_1
X_07007_ net655 net708 net709 net642 VGND VGND VPWR VPWR _03412_ sky130_fd_sc_hd__a22o_1
XFILLER_88_322 VGND VGND VPWR VPWR sky130_fd_sc_hd__fill_1
Xinput105 w30[7] VGND VGND VPWR VPWR net105 sky130_fd_sc_hd__clkbuf_2
Xinput127 w33[5] VGND VGND VPWR VPWR net127 sky130_fd_sc_hd__buf_1
Xinput116 w32[2] VGND VGND VPWR VPWR net116 sky130_fd_sc_hd__clkbuf_2
XFILLER_0_259 VGND VGND VPWR VPWR sky130_fd_sc_hd__decap_8
Xinput138 x1[0] VGND VGND VPWR VPWR net138 sky130_fd_sc_hd__clkbuf_1
XFILLER_130_485 VGND VGND VPWR VPWR sky130_fd_sc_hd__fill_1
XFILLER_130_474 VGND VGND VPWR VPWR sky130_fd_sc_hd__fill_2
X_08958_ _01427_ _01429_ VGND VGND VPWR VPWR _01432_ sky130_fd_sc_hd__xnor2_1
Xinput149 x2[3] VGND VGND VPWR VPWR net149 sky130_fd_sc_hd__clkbuf_2
X_08889_ _01245_ _01353_ _01354_ VGND VGND VPWR VPWR _01357_ sky130_fd_sc_hd__or3_1
X_07909_ _00385_ _00386_ VGND VGND VPWR VPWR _00387_ sky130_fd_sc_hd__nor2_1
XFILLER_29_433 VGND VGND VPWR VPWR sky130_fd_sc_hd__fill_1
XFILLER_84_561 VGND VGND VPWR VPWR sky130_fd_sc_hd__fill_1
XFILLER_72_701 VPWR VGND VPWR VGND sky130_ef_sc_hd__decap_12
XFILLER_57_775 VGND VGND VPWR VPWR sky130_fd_sc_hd__decap_8
XFILLER_56_274 VGND VGND VPWR VPWR sky130_fd_sc_hd__decap_8
X_10920_ _03420_ _03431_ _03430_ VGND VGND VPWR VPWR _03568_ sky130_fd_sc_hd__a21bo_1
XFILLER_17_606 VGND VGND VPWR VPWR sky130_fd_sc_hd__decap_8
XFILLER_17_617 VGND VGND VPWR VPWR sky130_fd_sc_hd__decap_8
XFILLER_112_41 VPWR VGND VPWR VGND sky130_ef_sc_hd__decap_12
XFILLER_112_85 VGND VGND VPWR VPWR sky130_fd_sc_hd__decap_4
XFILLER_71_266 VGND VGND VPWR VPWR sky130_fd_sc_hd__decap_3
X_10851_ _03491_ _03492_ VGND VGND VPWR VPWR _03493_ sky130_fd_sc_hd__nor2_1
X_13570_ _06375_ _06379_ _06455_ VGND VGND VPWR VPWR _06457_ sky130_fd_sc_hd__or3_1
XFILLER_71_288 VPWR VGND VPWR VGND sky130_ef_sc_hd__decap_12
X_10782_ net510 net288 _03121_ VGND VGND VPWR VPWR _03417_ sky130_fd_sc_hd__and3_1
XTAP_TAPCELL_ROW_27_689 VGND VPWR sky130_fd_sc_hd__tapvpwrvgnd_1
XFILLER_31_108 VGND VGND VPWR VPWR sky130_fd_sc_hd__decap_4
X_12521_ _05274_ _05311_ VGND VGND VPWR VPWR _05312_ sky130_fd_sc_hd__xnor2_1
XTAP_TAPCELL_ROW_80_1459 VGND VPWR sky130_fd_sc_hd__tapvpwrvgnd_1
XFILLER_72_78 VGND VGND VPWR VPWR sky130_fd_sc_hd__decap_6
X_12452_ _05234_ _05235_ VGND VGND VPWR VPWR _05236_ sky130_fd_sc_hd__and2b_1
XFILLER_12_377 VGND VGND VPWR VPWR sky130_fd_sc_hd__fill_2
X_11403_ _04093_ _04094_ VGND VGND VPWR VPWR _04096_ sky130_fd_sc_hd__xnor2_1
XFILLER_138_574 VGND VGND VPWR VPWR sky130_fd_sc_hd__decap_3
X_12383_ _05158_ _05159_ _05149_ VGND VGND VPWR VPWR _05161_ sky130_fd_sc_hd__a21o_1
XFILLER_4_510 VGND VGND VPWR VPWR sky130_fd_sc_hd__decap_3
XFILLER_126_769 VPWR VGND VPWR VGND sky130_ef_sc_hd__decap_12
XFILLER_99_609 VGND VGND VPWR VPWR sky130_fd_sc_hd__decap_6
X_11334_ _03711_ _03870_ _04020_ VGND VGND VPWR VPWR _04021_ sky130_fd_sc_hd__a21oi_1
XFILLER_125_279 VGND VGND VPWR VPWR sky130_fd_sc_hd__fill_1
XTAP_TAPCELL_ROW_95_1680 VGND VPWR sky130_fd_sc_hd__tapvpwrvgnd_1
X_11265_ _03943_ _03944_ VGND VGND VPWR VPWR _03945_ sky130_fd_sc_hd__or2_1
XFILLER_137_93 VPWR VGND VPWR VGND sky130_ef_sc_hd__decap_12
XFILLER_97_53 VGND VGND VPWR VPWR sky130_fd_sc_hd__decap_3
X_13004_ _05315_ _05837_ VGND VGND VPWR VPWR _05839_ sky130_fd_sc_hd__xnor2_1
X_10216_ _02796_ _02797_ _02798_ VGND VGND VPWR VPWR _02800_ sky130_fd_sc_hd__o21a_1
XFILLER_133_290 VGND VGND VPWR VPWR sky130_fd_sc_hd__decap_8
XFILLER_121_441 VGND VGND VPWR VPWR sky130_fd_sc_hd__decap_6
XFILLER_97_97 VGND VGND VPWR VPWR sky130_fd_sc_hd__fill_1
X_11196_ _03868_ _03869_ VGND VGND VPWR VPWR _03870_ sky130_fd_sc_hd__and2b_1
X_10147_ _02056_ _02651_ _02650_ VGND VGND VPWR VPWR _02727_ sky130_fd_sc_hd__o21a_1
X_10078_ _02057_ _02651_ VGND VGND VPWR VPWR _02653_ sky130_fd_sc_hd__xnor2_1
XFILLER_48_764 VGND VGND VPWR VPWR sky130_fd_sc_hd__decap_8
XFILLER_75_561 VGND VGND VPWR VPWR sky130_fd_sc_hd__decap_4
XFILLER_35_436 VPWR VGND VPWR VGND sky130_ef_sc_hd__decap_12
XTAP_TAPCELL_ROW_122_2065 VGND VPWR sky130_fd_sc_hd__tapvpwrvgnd_1
XTAP_TAPCELL_ROW_46_965 VGND VPWR sky130_fd_sc_hd__tapvpwrvgnd_1
XFILLER_23_609 VGND VGND VPWR VPWR sky130_fd_sc_hd__decap_6
XFILLER_62_277 VPWR VGND VPWR VGND sky130_ef_sc_hd__decap_12
XFILLER_50_417 VGND VGND VPWR VPWR sky130_fd_sc_hd__decap_3
X_12719_ net637 net8 VGND VGND VPWR VPWR _05529_ sky130_fd_sc_hd__nand2_1
Xclkbuf_0_clk clk VGND VGND VPWR VPWR clknet_0_clk sky130_fd_sc_hd__clkbuf_16
X_13699_ clknet_3_0__leaf_clk _00045_ net715 VGND VGND VPWR VPWR net218 sky130_fd_sc_hd__dfrtp_1
XFILLER_117_725 VGND VGND VPWR VPWR sky130_fd_sc_hd__decap_3
XFILLER_7_51 VGND VGND VPWR VPWR sky130_fd_sc_hd__decap_4
XFILLER_116_235 VGND VGND VPWR VPWR sky130_fd_sc_hd__decap_8
X_09930_ _02461_ _02489_ VGND VGND VPWR VPWR _02491_ sky130_fd_sc_hd__xnor2_1
XPHY_EDGE_ROW_15_Right_15 VGND VGND VPWR VPWR sky130_fd_sc_hd__decap_3
XFILLER_131_249 VGND VGND VPWR VPWR sky130_fd_sc_hd__decap_8
X_09861_ net419 net330 VGND VGND VPWR VPWR _02417_ sky130_fd_sc_hd__nand2_1
XFILLER_97_152 VGND VGND VPWR VPWR sky130_fd_sc_hd__fill_1
XFILLER_58_506 VGND VGND VPWR VPWR sky130_fd_sc_hd__decap_4
X_09792_ _02056_ _02210_ _02209_ VGND VGND VPWR VPWR _02341_ sky130_fd_sc_hd__o21ai_1
X_08812_ _01275_ _01276_ _01274_ VGND VGND VPWR VPWR _01278_ sky130_fd_sc_hd__a21bo_1
XTAP_TAPCELL_ROW_51_1038 VGND VPWR sky130_fd_sc_hd__tapvpwrvgnd_1
X_08743_ _01205_ _01209_ _01201_ _01203_ VGND VGND VPWR VPWR _01210_ sky130_fd_sc_hd__a211oi_2
XFILLER_39_753 VPWR VGND VPWR VGND sky130_ef_sc_hd__decap_12
XFILLER_54_701 VGND VGND VPWR VPWR sky130_fd_sc_hd__fill_2
XFILLER_39_797 VGND VGND VPWR VPWR sky130_fd_sc_hd__decap_6
X_08674_ _01139_ _01138_ VGND VGND VPWR VPWR _01141_ sky130_fd_sc_hd__and2b_1
XTAP_TAPCELL_ROW_107_1849 VGND VPWR sky130_fd_sc_hd__tapvpwrvgnd_1
XFILLER_26_27 VGND VGND VPWR VPWR sky130_fd_sc_hd__fill_1
XFILLER_81_564 VPWR VGND VPWR VGND sky130_ef_sc_hd__decap_12
X_07625_ net636 net705 VGND VGND VPWR VPWR _00105_ sky130_fd_sc_hd__nand2_1
XFILLER_53_233 VGND VGND VPWR VPWR sky130_fd_sc_hd__fill_1
XPHY_EDGE_ROW_24_Right_24 VGND VGND VPWR VPWR sky130_fd_sc_hd__decap_3
XFILLER_26_458 VGND VGND VPWR VPWR sky130_fd_sc_hd__fill_2
X_07556_ net684 net486 net476 net686 VGND VGND VPWR VPWR _06785_ sky130_fd_sc_hd__a22o_1
XFILLER_41_439 VGND VGND VPWR VPWR sky130_fd_sc_hd__decap_8
XFILLER_42_15 VPWR VGND VPWR VGND sky130_ef_sc_hd__decap_12
XTAP_TAPCELL_ROW_24_648 VGND VPWR sky130_fd_sc_hd__tapvpwrvgnd_1
X_09226_ net595 net585 net49 VGND VGND VPWR VPWR _01723_ sky130_fd_sc_hd__a21boi_1
X_07487_ _06622_ _06716_ VGND VGND VPWR VPWR _06717_ sky130_fd_sc_hd__nor2_1
X_09157_ _01474_ _01477_ _01476_ VGND VGND VPWR VPWR _01648_ sky130_fd_sc_hd__o21bai_1
X_09088_ net515 net55 net345 net524 VGND VGND VPWR VPWR _01574_ sky130_fd_sc_hd__a22o_1
XFILLER_108_769 VPWR VGND VPWR VGND sky130_ef_sc_hd__decap_12
X_08108_ _00578_ _00583_ VGND VGND VPWR VPWR _00584_ sky130_fd_sc_hd__nand2_1
X_08039_ _00514_ _00515_ VGND VGND VPWR VPWR _00516_ sky130_fd_sc_hd__nor2_1
XPHY_EDGE_ROW_33_Right_33 VGND VGND VPWR VPWR sky130_fd_sc_hd__decap_3
XFILLER_123_739 VGND VGND VPWR VPWR sky130_fd_sc_hd__fill_1
XFILLER_122_238 VGND VGND VPWR VPWR sky130_fd_sc_hd__decap_6
XFILLER_122_227 VGND VGND VPWR VPWR sky130_fd_sc_hd__decap_4
XFILLER_103_441 VGND VGND VPWR VPWR sky130_fd_sc_hd__decap_6
XFILLER_88_141 VGND VGND VPWR VPWR sky130_fd_sc_hd__fill_1
XFILLER_88_130 VGND VGND VPWR VPWR sky130_fd_sc_hd__decap_8
X_11050_ _03709_ _03710_ VGND VGND VPWR VPWR _03711_ sky130_fd_sc_hd__nor2_1
X_10001_ _02567_ _02568_ VGND VGND VPWR VPWR _02569_ sky130_fd_sc_hd__nor2_1
XFILLER_49_528 VPWR VGND VPWR VGND sky130_ef_sc_hd__decap_12
XFILLER_49_517 VGND VGND VPWR VPWR sky130_fd_sc_hd__decap_6
XFILLER_76_347 VGND VGND VPWR VPWR sky130_fd_sc_hd__decap_3
XFILLER_76_336 VGND VGND VPWR VPWR sky130_fd_sc_hd__fill_1
XTAP_TAPCELL_ROW_4_351 VGND VPWR sky130_fd_sc_hd__tapvpwrvgnd_1
XFILLER_123_51 VGND VGND VPWR VPWR sky130_fd_sc_hd__decap_4
XFILLER_57_561 VPWR VGND VPWR VGND sky130_ef_sc_hd__decap_12
XTAP_TAPCELL_ROW_4_362 VGND VPWR sky130_fd_sc_hd__tapvpwrvgnd_1
X_11952_ _04666_ _04689_ VGND VGND VPWR VPWR _04691_ sky130_fd_sc_hd__nand2b_1
XFILLER_72_531 VGND VGND VPWR VPWR sky130_fd_sc_hd__fill_1
XFILLER_57_594 VPWR VGND VPWR VGND sky130_ef_sc_hd__decap_12
XFILLER_44_222 VGND VGND VPWR VPWR sky130_fd_sc_hd__decap_8
XPHY_EDGE_ROW_42_Right_42 VGND VGND VPWR VPWR sky130_fd_sc_hd__decap_3
XFILLER_83_55 VGND VGND VPWR VPWR sky130_fd_sc_hd__fill_1
X_10903_ net263 net311 _03365_ VGND VGND VPWR VPWR _03549_ sky130_fd_sc_hd__o21a_1
X_11883_ _04615_ _04616_ VGND VGND VPWR VPWR _04619_ sky130_fd_sc_hd__xnor2_1
XFILLER_17_447 VGND VGND VPWR VPWR sky130_fd_sc_hd__fill_1
X_13622_ _06509_ _06512_ VGND VGND VPWR VPWR _06513_ sky130_fd_sc_hd__xnor2_1
XFILLER_72_586 VGND VGND VPWR VPWR sky130_fd_sc_hd__fill_2
XFILLER_44_266 VGND VGND VPWR VPWR sky130_fd_sc_hd__decap_8
XTAP_TAPCELL_ROW_43_924 VGND VPWR sky130_fd_sc_hd__tapvpwrvgnd_1
X_10834_ _03462_ _03473_ VGND VGND VPWR VPWR _03474_ sky130_fd_sc_hd__xnor2_1
XFILLER_32_439 VGND VGND VPWR VPWR sky130_fd_sc_hd__decap_8
X_13553_ _06424_ _06437_ VGND VGND VPWR VPWR _06438_ sky130_fd_sc_hd__xnor2_1
XFILLER_13_653 VGND VGND VPWR VPWR sky130_fd_sc_hd__decap_6
X_12504_ _05280_ _05292_ VGND VGND VPWR VPWR _05293_ sky130_fd_sc_hd__xnor2_1
XFILLER_12_141 VGND VGND VPWR VPWR sky130_fd_sc_hd__decap_8
X_10765_ _03396_ _03397_ VGND VGND VPWR VPWR _03398_ sky130_fd_sc_hd__xor2_1
X_13484_ _06043_ _06184_ _06362_ VGND VGND VPWR VPWR _06363_ sky130_fd_sc_hd__a21o_1
XFILLER_12_185 VGND VGND VPWR VPWR sky130_fd_sc_hd__decap_6
XFILLER_13_697 VPWR VGND VPWR VGND sky130_ef_sc_hd__decap_12
X_10696_ _03320_ _03321_ _03322_ VGND VGND VPWR VPWR _03323_ sky130_fd_sc_hd__nand3_1
X_12435_ _04928_ _04933_ _05062_ _05063_ VGND VGND VPWR VPWR _05218_ sky130_fd_sc_hd__nor4_1
XPHY_EDGE_ROW_51_Right_51 VGND VGND VPWR VPWR sky130_fd_sc_hd__decap_3
XFILLER_138_393 VPWR VGND VPWR VGND sky130_ef_sc_hd__decap_12
XFILLER_138_382 VGND VGND VPWR VPWR sky130_fd_sc_hd__decap_8
XFILLER_126_533 VPWR VGND VPWR VGND sky130_ef_sc_hd__decap_12
X_12366_ _05140_ _05141_ VGND VGND VPWR VPWR _05142_ sky130_fd_sc_hd__nor2_1
XPHY_EDGE_ROW_136_Right_136 VGND VGND VPWR VPWR sky130_fd_sc_hd__decap_3
X_11317_ _03800_ _03853_ _03852_ VGND VGND VPWR VPWR _04002_ sky130_fd_sc_hd__a21bo_1
X_12297_ _05062_ _05063_ _05065_ VGND VGND VPWR VPWR _05067_ sky130_fd_sc_hd__o21ai_1
X_11248_ _03770_ net287 _00342_ VGND VGND VPWR VPWR _03927_ sky130_fd_sc_hd__and3b_1
X_11179_ _03849_ _03851_ VGND VGND VPWR VPWR _03852_ sky130_fd_sc_hd__nand2b_1
XFILLER_121_293 VPWR VGND VPWR VGND sky130_ef_sc_hd__decap_12
XFILLER_95_645 VPWR VGND VPWR VGND sky130_ef_sc_hd__decap_12
XFILLER_94_133 VGND VGND VPWR VPWR sky130_fd_sc_hd__decap_6
XPHY_EDGE_ROW_60_Right_60 VGND VGND VPWR VPWR sky130_fd_sc_hd__decap_3
XFILLER_36_701 VGND VGND VPWR VPWR sky130_fd_sc_hd__decap_6
XFILLER_75_391 VGND VGND VPWR VPWR sky130_fd_sc_hd__fill_1
XFILLER_63_564 VGND VGND VPWR VPWR sky130_fd_sc_hd__decap_6
XFILLER_90_383 VPWR VGND VPWR VGND sky130_ef_sc_hd__decap_12
X_07410_ net674 net416 _06334_ _06323_ VGND VGND VPWR VPWR _06640_ sky130_fd_sc_hd__a31o_1
X_08390_ _00861_ _00863_ VGND VGND VPWR VPWR _00864_ sky130_fd_sc_hd__nand2_1
XFILLER_23_406 VPWR VGND VPWR VGND sky130_ef_sc_hd__decap_12
X_07341_ _04177_ _04232_ _05505_ _05516_ _06571_ VGND VGND VPWR VPWR _06572_ sky130_fd_sc_hd__a41o_1
XFILLER_50_225 VPWR VGND VPWR VGND sky130_ef_sc_hd__decap_12
XFILLER_16_491 VPWR VGND VPWR VGND sky130_ef_sc_hd__decap_12
XTAP_TAPCELL_ROW_102_1779 VGND VPWR sky130_fd_sc_hd__tapvpwrvgnd_1
XTAP_TAPCELL_ROW_21_607 VGND VPWR sky130_fd_sc_hd__tapvpwrvgnd_1
XFILLER_137_809 VPWR VGND VPWR VGND sky130_ef_sc_hd__decap_12
X_07272_ _04849_ _04937_ _04926_ VGND VGND VPWR VPWR _06301_ sky130_fd_sc_hd__o21ba_1
XFILLER_31_494 VGND VGND VPWR VPWR sky130_fd_sc_hd__decap_8
XTAP_TAPCELL_ROW_135_2256 VGND VPWR sky130_fd_sc_hd__tapvpwrvgnd_1
X_09011_ _01487_ _01488_ _01468_ VGND VGND VPWR VPWR _01490_ sky130_fd_sc_hd__a21oi_1
XFILLER_12_29 VPWR VGND VPWR VGND sky130_ef_sc_hd__decap_12
XFILLER_129_393 VGND VGND VPWR VPWR sky130_fd_sc_hd__decap_8
XFILLER_128_29 VPWR VGND VPWR VGND sky130_ef_sc_hd__decap_12
XFILLER_117_533 VGND VGND VPWR VPWR sky130_fd_sc_hd__fill_2
XFILLER_8_690 VGND VGND VPWR VPWR sky130_fd_sc_hd__fill_1
XPHY_EDGE_ROW_103_Right_103 VGND VGND VPWR VPWR sky130_fd_sc_hd__decap_3
X_09913_ _02327_ _02471_ VGND VGND VPWR VPWR _02472_ sky130_fd_sc_hd__xnor2_1
Xfanout614 net617 VGND VGND VPWR VPWR net614 sky130_fd_sc_hd__clkbuf_2
Xfanout603 net605 VGND VGND VPWR VPWR net603 sky130_fd_sc_hd__buf_1
XFILLER_113_783 VGND VGND VPWR VPWR sky130_fd_sc_hd__fill_1
X_09844_ net606 net368 VGND VGND VPWR VPWR _02398_ sky130_fd_sc_hd__nand2_1
Xfanout625 net626 VGND VGND VPWR VPWR net625 sky130_fd_sc_hd__buf_2
Xfanout636 net132 VGND VGND VPWR VPWR net636 sky130_fd_sc_hd__buf_4
XFILLER_85_100 VPWR VGND VPWR VGND sky130_ef_sc_hd__decap_12
Xfanout647 net648 VGND VGND VPWR VPWR net647 sky130_fd_sc_hd__buf_8
Xfanout658 net130 VGND VGND VPWR VPWR net658 sky130_fd_sc_hd__buf_4
XFILLER_112_293 VGND VGND VPWR VPWR sky130_fd_sc_hd__fill_2
XFILLER_98_494 VGND VGND VPWR VPWR sky130_fd_sc_hd__fill_2
XFILLER_86_645 VGND VGND VPWR VPWR sky130_fd_sc_hd__decap_4
Xfanout669 net125 VGND VGND VPWR VPWR net669 sky130_fd_sc_hd__buf_2
XFILLER_58_336 VGND VGND VPWR VPWR sky130_fd_sc_hd__decap_8
XPHY_EDGE_ROW_13_Left_152 VGND VGND VPWR VPWR sky130_fd_sc_hd__decap_3
XFILLER_37_15 VPWR VGND VPWR VGND sky130_ef_sc_hd__decap_12
X_09775_ _02220_ _02222_ _02320_ VGND VGND VPWR VPWR _02322_ sky130_fd_sc_hd__or3b_1
XFILLER_100_477 VGND VGND VPWR VPWR sky130_fd_sc_hd__decap_4
X_06987_ net673 net459 net670 net451 VGND VGND VPWR VPWR _03194_ sky130_fd_sc_hd__and4_1
XTAP_TAPCELL_ROW_29_718 VGND VPWR sky130_fd_sc_hd__tapvpwrvgnd_1
XFILLER_39_550 VGND VGND VPWR VPWR sky130_fd_sc_hd__decap_8
XFILLER_39_561 VGND VGND VPWR VPWR sky130_fd_sc_hd__fill_2
X_08726_ _01036_ _01185_ _01192_ VGND VGND VPWR VPWR _01193_ sky130_fd_sc_hd__nand3_1
XFILLER_73_328 VGND VGND VPWR VPWR sky130_fd_sc_hd__decap_8
XFILLER_54_520 VPWR VGND VPWR VGND sky130_ef_sc_hd__decap_12
XTAP_TAPCELL_ROW_1_310 VGND VPWR sky130_fd_sc_hd__tapvpwrvgnd_1
X_08657_ _01120_ _01122_ VGND VGND VPWR VPWR _01124_ sky130_fd_sc_hd__nand2_1
XTAP_TAPCELL_ROW_64_1229 VGND VPWR sky130_fd_sc_hd__tapvpwrvgnd_1
X_07608_ _00068_ _00087_ VGND VGND VPWR VPWR _00088_ sky130_fd_sc_hd__xor2_1
XFILLER_54_586 VGND VGND VPWR VPWR sky130_fd_sc_hd__fill_2
XFILLER_54_575 VGND VGND VPWR VPWR sky130_fd_sc_hd__decap_4
X_08588_ _01050_ _01054_ VGND VGND VPWR VPWR _01056_ sky130_fd_sc_hd__xnor2_1
XFILLER_53_69 VPWR VGND VPWR VGND sky130_ef_sc_hd__decap_12
X_07539_ _06760_ _06766_ VGND VGND VPWR VPWR _06768_ sky130_fd_sc_hd__nand2b_1
XPHY_EDGE_ROW_22_Left_161 VGND VGND VPWR VPWR sky130_fd_sc_hd__decap_3
XFILLER_10_645 VGND VGND VPWR VPWR sky130_fd_sc_hd__fill_1
X_10550_ _03160_ _03162_ _03163_ VGND VGND VPWR VPWR _03164_ sky130_fd_sc_hd__or3_1
X_09209_ net359 _01702_ _01704_ VGND VGND VPWR VPWR _01705_ sky130_fd_sc_hd__a21bo_1
X_10481_ net579 net306 net304 net588 VGND VGND VPWR VPWR _03088_ sky130_fd_sc_hd__a22o_1
XFILLER_6_627 VPWR VGND VPWR VGND sky130_ef_sc_hd__decap_12
XFILLER_6_605 VGND VGND VPWR VPWR sky130_fd_sc_hd__fill_1
X_12220_ _04972_ _04982_ VGND VGND VPWR VPWR _04983_ sky130_fd_sc_hd__xnor2_1
XTAP_TAPCELL_ROW_79_1450 VGND VPWR sky130_fd_sc_hd__tapvpwrvgnd_1
XFILLER_123_503 VGND VGND VPWR VPWR sky130_fd_sc_hd__fill_1
XFILLER_123_525 VPWR VGND VPWR VGND sky130_ef_sc_hd__decap_12
X_12151_ _04899_ _04906_ _04907_ VGND VGND VPWR VPWR _04908_ sky130_fd_sc_hd__and3_2
XTAP_TAPCELL_ROW_9_432 VGND VPWR sky130_fd_sc_hd__tapvpwrvgnd_1
XFILLER_2_811 VGND VGND VPWR VPWR sky130_fd_sc_hd__fill_1
XFILLER_123_569 VPWR VGND VPWR VGND sky130_ef_sc_hd__decap_12
XFILLER_96_409 VGND VGND VPWR VPWR sky130_fd_sc_hd__decap_6
X_12082_ _04828_ _04831_ VGND VGND VPWR VPWR _04832_ sky130_fd_sc_hd__xnor2_1
X_11102_ _03765_ _03766_ VGND VGND VPWR VPWR _03767_ sky130_fd_sc_hd__nand2b_1
XFILLER_89_472 VGND VGND VPWR VPWR sky130_fd_sc_hd__decap_6
XFILLER_89_461 VGND VGND VPWR VPWR sky130_fd_sc_hd__decap_4
XFILLER_78_77 VGND VGND VPWR VPWR sky130_fd_sc_hd__fill_1
XFILLER_49_303 VGND VGND VPWR VPWR sky130_fd_sc_hd__fill_2
X_11033_ _03510_ _03513_ _03690_ _03691_ VGND VGND VPWR VPWR _03692_ sky130_fd_sc_hd__a211oi_1
XPHY_EDGE_ROW_31_Left_170 VGND VGND VPWR VPWR sky130_fd_sc_hd__decap_3
XFILLER_77_645 VGND VGND VPWR VPWR sky130_fd_sc_hd__fill_1
XFILLER_134_83 VGND VGND VPWR VPWR sky130_fd_sc_hd__fill_1
XFILLER_18_701 VPWR VGND VPWR VGND sky130_ef_sc_hd__decap_12
XFILLER_37_509 VGND VGND VPWR VPWR sky130_fd_sc_hd__fill_1
XFILLER_94_65 VPWR VGND VPWR VGND sky130_ef_sc_hd__decap_12
X_12984_ net428 net383 net381 net437 VGND VGND VPWR VPWR _05817_ sky130_fd_sc_hd__a22oi_1
XFILLER_91_169 VGND VGND VPWR VPWR sky130_fd_sc_hd__decap_4
X_11935_ net658 net645 net405 net386 VGND VGND VPWR VPWR _04672_ sky130_fd_sc_hd__and4_1
XFILLER_45_553 VGND VGND VPWR VPWR sky130_fd_sc_hd__decap_6
XFILLER_45_597 VPWR VGND VPWR VGND sky130_ef_sc_hd__decap_12
X_13605_ _06414_ _06419_ _06413_ VGND VGND VPWR VPWR _06494_ sky130_fd_sc_hd__a21boi_1
X_11866_ _04575_ _04599_ VGND VGND VPWR VPWR _04600_ sky130_fd_sc_hd__nand2b_1
XFILLER_32_247 VGND VGND VPWR VPWR sky130_fd_sc_hd__decap_4
XFILLER_33_759 VPWR VGND VPWR VGND sky130_ef_sc_hd__decap_12
X_11797_ _04497_ _04523_ VGND VGND VPWR VPWR _04525_ sky130_fd_sc_hd__xnor2_1
XFILLER_13_461 VPWR VGND VPWR VGND sky130_ef_sc_hd__decap_12
X_10817_ net466 net270 VGND VGND VPWR VPWR _03455_ sky130_fd_sc_hd__and2_2
X_13536_ _06318_ _06417_ VGND VGND VPWR VPWR _06419_ sky130_fd_sc_hd__xnor2_1
X_10748_ net588 net300 _03377_ VGND VGND VPWR VPWR _03380_ sky130_fd_sc_hd__and3_1
X_13467_ _06342_ _06341_ VGND VGND VPWR VPWR _06344_ sky130_fd_sc_hd__nand2b_1
X_12418_ _05043_ _05045_ _05197_ _05198_ VGND VGND VPWR VPWR _05200_ sky130_fd_sc_hd__o211ai_2
X_10679_ net611 net327 _03157_ _03156_ VGND VGND VPWR VPWR _03305_ sky130_fd_sc_hd__a31o_1
X_13398_ _06085_ _06092_ _06091_ VGND VGND VPWR VPWR _06270_ sky130_fd_sc_hd__a21oi_1
Xoutput217 net217 VGND VGND VPWR VPWR y3[13] sky130_fd_sc_hd__buf_2
Xoutput206 net206 VGND VGND VPWR VPWR y2[3] sky130_fd_sc_hd__buf_2
X_12349_ _05121_ _05123_ VGND VGND VPWR VPWR _05124_ sky130_fd_sc_hd__and2_1
Xoutput228 net228 VGND VGND VPWR VPWR y3[8] sky130_fd_sc_hd__buf_2
XFILLER_5_682 VGND VGND VPWR VPWR sky130_fd_sc_hd__decap_8
XFILLER_5_671 VGND VGND VPWR VPWR sky130_fd_sc_hd__fill_1
XTAP_TAPCELL_ROW_130_2186 VGND VPWR sky130_fd_sc_hd__tapvpwrvgnd_1
XFILLER_4_41 VPWR VGND VPWR VGND sky130_ef_sc_hd__decap_12
XFILLER_68_623 VGND VGND VPWR VPWR sky130_fd_sc_hd__decap_3
X_06910_ _02249_ _02336_ VGND VGND VPWR VPWR _02358_ sky130_fd_sc_hd__nand2_1
XFILLER_4_85 VPWR VGND VPWR VGND sky130_ef_sc_hd__decap_12
XFILLER_68_645 VPWR VGND VPWR VGND sky130_ef_sc_hd__decap_12
X_07890_ net665 net425 net664 net434 VGND VGND VPWR VPWR _00368_ sky130_fd_sc_hd__a22oi_1
X_06841_ net655 net267 net642 net98 VGND VGND VPWR VPWR _01605_ sky130_fd_sc_hd__and4_1
X_09560_ _02086_ _02087_ VGND VGND VPWR VPWR _02088_ sky130_fd_sc_hd__and2b_1
XFILLER_83_648 VPWR VGND VPWR VGND sky130_ef_sc_hd__decap_12
X_09491_ _01743_ _01844_ _01843_ VGND VGND VPWR VPWR _02013_ sky130_fd_sc_hd__o21ba_1
XFILLER_82_136 VGND VGND VPWR VPWR sky130_fd_sc_hd__decap_4
X_08511_ _00973_ _00982_ VGND VGND VPWR VPWR _00983_ sky130_fd_sc_hd__xnor2_1
XFILLER_36_531 VGND VGND VPWR VPWR sky130_fd_sc_hd__fill_1
XTAP_TAPCELL_ROW_104_1808 VGND VPWR sky130_fd_sc_hd__tapvpwrvgnd_1
XFILLER_91_670 VGND VGND VPWR VPWR sky130_fd_sc_hd__fill_2
XFILLER_63_372 VPWR VGND VPWR VGND sky130_ef_sc_hd__decap_12
X_08442_ net242 net241 _00825_ VGND VGND VPWR VPWR _00915_ sky130_fd_sc_hd__o21ai_2
XFILLER_23_203 VGND VGND VPWR VPWR sky130_fd_sc_hd__decap_8
XFILLER_23_214 VGND VGND VPWR VPWR sky130_fd_sc_hd__decap_8
XFILLER_90_180 VGND VGND VPWR VPWR sky130_fd_sc_hd__decap_8
XFILLER_23_247 VPWR VGND VPWR VGND sky130_ef_sc_hd__decap_12
X_08373_ _00821_ _00845_ VGND VGND VPWR VPWR _00847_ sky130_fd_sc_hd__xor2_1
X_07324_ _06552_ _06553_ _05264_ _05286_ VGND VGND VPWR VPWR _06555_ sky130_fd_sc_hd__a211o_1
XFILLER_23_39 VPWR VGND VPWR VGND sky130_ef_sc_hd__decap_12
XFILLER_32_781 VPWR VGND VPWR VGND sky130_ef_sc_hd__decap_12
XTAP_TAPCELL_ROW_34_787 VGND VPWR sky130_fd_sc_hd__tapvpwrvgnd_1
XTAP_TAPCELL_ROW_34_798 VGND VPWR sky130_fd_sc_hd__tapvpwrvgnd_1
X_07255_ _06072_ _06083_ _06094_ VGND VGND VPWR VPWR _06116_ sky130_fd_sc_hd__a21o_1
XFILLER_117_352 VGND VGND VPWR VPWR sky130_fd_sc_hd__fill_1
X_07186_ _03861_ _03882_ _05341_ _05352_ VGND VGND VPWR VPWR _05363_ sky130_fd_sc_hd__o211a_1
XFILLER_105_525 VGND VGND VPWR VPWR sky130_fd_sc_hd__fill_1
XFILLER_105_547 VGND VGND VPWR VPWR sky130_fd_sc_hd__fill_1
XFILLER_78_409 VGND VGND VPWR VPWR sky130_fd_sc_hd__fill_2
Xfanout422 net16 VGND VGND VPWR VPWR net422 sky130_fd_sc_hd__buf_2
Xfanout400 net21 VGND VGND VPWR VPWR net400 sky130_fd_sc_hd__buf_2
Xfanout411 net161 VGND VGND VPWR VPWR net411 sky130_fd_sc_hd__clkbuf_4
Xfanout455 net456 VGND VGND VPWR VPWR net455 sky130_fd_sc_hd__buf_2
XFILLER_98_291 VGND VGND VPWR VPWR sky130_fd_sc_hd__fill_1
XFILLER_58_100 VGND VGND VPWR VPWR sky130_fd_sc_hd__fill_1
Xfanout444 net448 VGND VGND VPWR VPWR net444 sky130_fd_sc_hd__clkbuf_2
Xfanout433 net441 VGND VGND VPWR VPWR net433 sky130_fd_sc_hd__buf_2
Xfanout466 net469 VGND VGND VPWR VPWR net466 sky130_fd_sc_hd__buf_4
Xfanout488 net491 VGND VGND VPWR VPWR net488 sky130_fd_sc_hd__buf_2
X_09827_ _02371_ _02378_ VGND VGND VPWR VPWR _02379_ sky130_fd_sc_hd__xnor2_1
Xfanout477 net482 VGND VGND VPWR VPWR net477 sky130_fd_sc_hd__buf_2
Xfanout499 net150 VGND VGND VPWR VPWR net499 sky130_fd_sc_hd__clkbuf_4
X_09758_ _02302_ _02303_ VGND VGND VPWR VPWR _02305_ sky130_fd_sc_hd__nand2b_1
XFILLER_104_53 VPWR VGND VPWR VGND sky130_ef_sc_hd__decap_12
XFILLER_101_797 VPWR VGND VPWR VGND sky130_ef_sc_hd__decap_12
XFILLER_58_177 VGND VGND VPWR VPWR sky130_fd_sc_hd__decap_4
XFILLER_46_328 VGND VGND VPWR VPWR sky130_fd_sc_hd__decap_8
XFILLER_39_380 VPWR VGND VPWR VGND sky130_ef_sc_hd__decap_12
X_08709_ _01169_ _01170_ _01175_ VGND VGND VPWR VPWR _01176_ sky130_fd_sc_hd__nand3_1
X_09689_ _02226_ _02228_ VGND VGND VPWR VPWR _02229_ sky130_fd_sc_hd__nand2b_1
XFILLER_73_169 VGND VGND VPWR VPWR sky130_fd_sc_hd__decap_4
X_11720_ _04350_ _04436_ _04439_ VGND VGND VPWR VPWR _04441_ sky130_fd_sc_hd__and3_1
XFILLER_120_41 VPWR VGND VPWR VGND sky130_ef_sc_hd__decap_12
XFILLER_42_545 VPWR VGND VPWR VGND sky130_ef_sc_hd__decap_12
XFILLER_14_236 VGND VGND VPWR VPWR sky130_fd_sc_hd__fill_2
XFILLER_42_589 VGND VGND VPWR VPWR sky130_fd_sc_hd__decap_4
X_11651_ net415 net270 _04266_ VGND VGND VPWR VPWR _04366_ sky130_fd_sc_hd__a21oi_1
XFILLER_120_85 VPWR VGND VPWR VGND sky130_ef_sc_hd__decap_12
X_11582_ _04288_ _04289_ VGND VGND VPWR VPWR _04291_ sky130_fd_sc_hd__nand2_1
X_10602_ net537 net313 _03218_ VGND VGND VPWR VPWR _03220_ sky130_fd_sc_hd__nand3_1
XFILLER_23_781 VGND VGND VPWR VPWR sky130_fd_sc_hd__decap_3
XFILLER_128_606 VPWR VGND VPWR VGND sky130_ef_sc_hd__decap_12
XFILLER_127_105 VGND VGND VPWR VPWR sky130_fd_sc_hd__decap_6
X_13321_ _06182_ _06183_ _06180_ VGND VGND VPWR VPWR _06185_ sky130_fd_sc_hd__o21ai_1
X_10533_ _03141_ _03142_ _03143_ VGND VGND VPWR VPWR _03145_ sky130_fd_sc_hd__a21oi_1
XTAP_TAPCELL_ROW_77_1409 VGND VPWR sky130_fd_sc_hd__tapvpwrvgnd_1
XFILLER_6_435 VPWR VGND VPWR VGND sky130_ef_sc_hd__decap_12
XFILLER_89_43 VPWR VGND VPWR VGND sky130_ef_sc_hd__decap_12
X_13252_ _06109_ VGND VGND VPWR VPWR _06110_ sky130_fd_sc_hd__inv_2
X_10464_ _03062_ _03068_ VGND VGND VPWR VPWR _03070_ sky130_fd_sc_hd__xnor2_2
X_12203_ _04950_ _04963_ VGND VGND VPWR VPWR _04964_ sky130_fd_sc_hd__xnor2_1
X_13183_ _05911_ _05926_ _05925_ VGND VGND VPWR VPWR _06034_ sky130_fd_sc_hd__o21ai_2
X_10395_ net643 net324 net322 net654 VGND VGND VPWR VPWR _02994_ sky130_fd_sc_hd__a22o_1
XFILLER_97_707 VGND VGND VPWR VPWR sky130_fd_sc_hd__fill_1
XTAP_TAPCELL_ROW_90_1609 VGND VPWR sky130_fd_sc_hd__tapvpwrvgnd_1
X_12134_ _04878_ _04879_ _04886_ VGND VGND VPWR VPWR _04889_ sky130_fd_sc_hd__a21oi_1
XFILLER_97_729 VGND VGND VPWR VPWR sky130_fd_sc_hd__decap_8
XFILLER_2_652 VGND VGND VPWR VPWR sky130_fd_sc_hd__decap_4
X_12065_ _04756_ _04811_ VGND VGND VPWR VPWR _04813_ sky130_fd_sc_hd__nor2_1
XFILLER_77_420 VGND VGND VPWR VPWR sky130_fd_sc_hd__fill_2
XFILLER_1_195 VGND VGND VPWR VPWR sky130_fd_sc_hd__fill_1
XFILLER_1_162 VGND VGND VPWR VPWR sky130_fd_sc_hd__fill_1
XFILLER_77_475 VGND VGND VPWR VPWR sky130_fd_sc_hd__decap_3
XFILLER_65_615 VGND VGND VPWR VPWR sky130_fd_sc_hd__fill_1
XFILLER_49_166 VGND VGND VPWR VPWR sky130_fd_sc_hd__fill_2
X_11016_ _00108_ _03671_ _03672_ VGND VGND VPWR VPWR _03673_ sky130_fd_sc_hd__nand3_1
XFILLER_64_103 VPWR VGND VPWR VGND sky130_ef_sc_hd__decap_12
XFILLER_49_177 VPWR VGND VPWR VGND sky130_ef_sc_hd__decap_12
XFILLER_92_445 VPWR VGND VPWR VGND sky130_ef_sc_hd__decap_12
XFILLER_18_531 VGND VGND VPWR VPWR sky130_fd_sc_hd__fill_1
XFILLER_80_629 VGND VGND VPWR VPWR sky130_fd_sc_hd__decap_4
X_12967_ net388 net412 VGND VGND VPWR VPWR _05798_ sky130_fd_sc_hd__and2b_1
XFILLER_52_309 VGND VGND VPWR VPWR sky130_fd_sc_hd__decap_4
XFILLER_45_372 VPWR VGND VPWR VGND sky130_ef_sc_hd__decap_12
X_12898_ _05397_ _05555_ _05554_ VGND VGND VPWR VPWR _05724_ sky130_fd_sc_hd__a21bo_1
XFILLER_72_180 VGND VGND VPWR VPWR sky130_fd_sc_hd__fill_1
X_11918_ _04605_ _04609_ _04607_ _04604_ VGND VGND VPWR VPWR _04657_ sky130_fd_sc_hd__a211o_1
X_11849_ net249 _04382_ VGND VGND VPWR VPWR _04582_ sky130_fd_sc_hd__nand2_1
XFILLER_21_707 VPWR VGND VPWR VGND sky130_ef_sc_hd__decap_12
XTAP_TAPCELL_ROW_119_2026 VGND VPWR sky130_fd_sc_hd__tapvpwrvgnd_1
XTAP_TAPCELL_ROW_31_746 VGND VPWR sky130_fd_sc_hd__tapvpwrvgnd_1
X_13519_ _06176_ _06401_ VGND VGND VPWR VPWR _06402_ sky130_fd_sc_hd__nand2_1
XTAP_TAPCELL_ROW_132_2215 VGND VPWR sky130_fd_sc_hd__tapvpwrvgnd_1
X_07040_ _03718_ _03740_ _03336_ VGND VGND VPWR VPWR _03773_ sky130_fd_sc_hd__o21a_1
XFILLER_114_344 VGND VGND VPWR VPWR sky130_fd_sc_hd__fill_2
XFILLER_5_490 VGND VGND VPWR VPWR sky130_fd_sc_hd__fill_1
X_08991_ _01462_ _01466_ VGND VGND VPWR VPWR _01468_ sky130_fd_sc_hd__xor2_1
X_07942_ _00149_ _00282_ _00281_ VGND VGND VPWR VPWR _00420_ sky130_fd_sc_hd__a21oi_2
XTAP_TAPCELL_ROW_110_1889 VGND VPWR sky130_fd_sc_hd__tapvpwrvgnd_1
X_07873_ _00226_ _00229_ VGND VGND VPWR VPWR _00351_ sky130_fd_sc_hd__nor2_1
X_06824_ net367 VGND VGND VPWR VPWR _01420_ sky130_fd_sc_hd__inv_2
X_09612_ _02143_ _02144_ VGND VGND VPWR VPWR _02145_ sky130_fd_sc_hd__nor2_1
X_09543_ _02053_ _02068_ VGND VGND VPWR VPWR _02069_ sky130_fd_sc_hd__xor2_1
XFILLER_83_467 VPWR VGND VPWR VGND sky130_ef_sc_hd__decap_12
XTAP_TAPCELL_ROW_39_868 VGND VPWR sky130_fd_sc_hd__tapvpwrvgnd_1
X_09474_ _01819_ _01826_ _01825_ VGND VGND VPWR VPWR _01994_ sky130_fd_sc_hd__a21boi_1
XTAP_TAPCELL_ROW_19_570 VGND VPWR sky130_fd_sc_hd__tapvpwrvgnd_1
XTAP_TAPCELL_ROW_19_581 VGND VPWR sky130_fd_sc_hd__tapvpwrvgnd_1
XFILLER_34_27 VGND VGND VPWR VPWR sky130_fd_sc_hd__fill_1
X_08425_ _00896_ _00897_ VGND VGND VPWR VPWR _00898_ sky130_fd_sc_hd__nand2_1
XFILLER_51_364 VGND VGND VPWR VPWR sky130_fd_sc_hd__fill_1
X_08356_ _06803_ _00829_ VGND VGND VPWR VPWR _00830_ sky130_fd_sc_hd__and2_1
XFILLER_24_589 VPWR VGND VPWR VGND sky130_ef_sc_hd__decap_12
X_07307_ _06535_ _06536_ _06537_ VGND VGND VPWR VPWR _06538_ sky130_fd_sc_hd__or3_1
XFILLER_50_15 VPWR VGND VPWR VGND sky130_ef_sc_hd__decap_12
X_08287_ net665 _06801_ _06803_ _00608_ VGND VGND VPWR VPWR _00762_ sky130_fd_sc_hd__a2bb2o_1
X_07238_ _05733_ _05919_ VGND VGND VPWR VPWR _05930_ sky130_fd_sc_hd__xor2_1
X_07169_ _05144_ _05155_ _05068_ VGND VGND VPWR VPWR _05177_ sky130_fd_sc_hd__a21o_1
XFILLER_133_642 VGND VGND VPWR VPWR sky130_fd_sc_hd__decap_6
XFILLER_105_344 VGND VGND VPWR VPWR sky130_fd_sc_hd__fill_1
XFILLER_133_686 VGND VGND VPWR VPWR sky130_fd_sc_hd__fill_1
X_10180_ _02742_ _02746_ _02741_ VGND VGND VPWR VPWR _02763_ sky130_fd_sc_hd__a21oi_1
XFILLER_132_141 VPWR VGND VPWR VGND sky130_ef_sc_hd__decap_12
XFILLER_79_718 VGND VGND VPWR VPWR sky130_fd_sc_hd__fill_2
XTAP_TAPCELL_ROW_72_1339 VGND VPWR sky130_fd_sc_hd__tapvpwrvgnd_1
XFILLER_59_57 VPWR VGND VPWR VGND sky130_ef_sc_hd__decap_12
XFILLER_120_336 VPWR VGND VPWR VGND sky130_ef_sc_hd__decap_12
XFILLER_59_442 VGND VGND VPWR VPWR sky130_fd_sc_hd__decap_6
Xfanout252 _00174_ VGND VGND VPWR VPWR net252 sky130_fd_sc_hd__clkbuf_4
Xfanout274 net275 VGND VGND VPWR VPWR net274 sky130_fd_sc_hd__buf_2
Xfanout263 _01355_ VGND VGND VPWR VPWR net263 sky130_fd_sc_hd__clkbuf_4
XFILLER_101_572 VGND VGND VPWR VPWR sky130_fd_sc_hd__fill_1
XFILLER_101_561 VGND VGND VPWR VPWR sky130_fd_sc_hd__decap_6
Xfanout285 net9 VGND VGND VPWR VPWR net285 sky130_fd_sc_hd__clkbuf_2
XFILLER_59_497 VGND VGND VPWR VPWR sky130_fd_sc_hd__decap_6
XFILLER_47_615 VGND VGND VPWR VPWR sky130_fd_sc_hd__fill_1
Xfanout296 net84 VGND VGND VPWR VPWR net296 sky130_fd_sc_hd__clkbuf_2
X_12821_ _05637_ _05638_ VGND VGND VPWR VPWR _05639_ sky130_fd_sc_hd__nand2b_1
XFILLER_46_136 VGND VGND VPWR VPWR sky130_fd_sc_hd__decap_4
XFILLER_131_51 VGND VGND VPWR VPWR sky130_fd_sc_hd__decap_4
XTAP_TAPCELL_ROW_87_1560 VGND VPWR sky130_fd_sc_hd__tapvpwrvgnd_1
XFILLER_55_670 VGND VGND VPWR VPWR sky130_fd_sc_hd__fill_2
XFILLER_43_821 VGND VGND VPWR VPWR sky130_fd_sc_hd__decap_3
XFILLER_34_309 VPWR VGND VPWR VGND sky130_ef_sc_hd__decap_12
X_12752_ _05386_ _05562_ _05563_ VGND VGND VPWR VPWR _05564_ sky130_fd_sc_hd__and3_1
XFILLER_70_640 VGND VGND VPWR VPWR sky130_fd_sc_hd__decap_4
XFILLER_15_545 VPWR VGND VPWR VGND sky130_ef_sc_hd__decap_12
XFILLER_91_55 VGND VGND VPWR VPWR sky130_fd_sc_hd__fill_1
X_12683_ _05322_ _05333_ _05331_ VGND VGND VPWR VPWR _05489_ sky130_fd_sc_hd__a21oi_1
X_11703_ _04421_ _04422_ VGND VGND VPWR VPWR _04423_ sky130_fd_sc_hd__nor2_1
X_11634_ _03836_ _03982_ _04241_ VGND VGND VPWR VPWR _04347_ sky130_fd_sc_hd__and3_1
XFILLER_7_700 VGND VGND VPWR VPWR sky130_fd_sc_hd__decap_4
XFILLER_30_559 VPWR VGND VPWR VGND sky130_ef_sc_hd__decap_12
X_11565_ _04261_ _04270_ VGND VGND VPWR VPWR _04272_ sky130_fd_sc_hd__xor2_1
X_13304_ _05728_ _05882_ _06166_ VGND VGND VPWR VPWR _06167_ sky130_fd_sc_hd__nor3b_1
XFILLER_7_777 VGND VGND VPWR VPWR sky130_fd_sc_hd__decap_6
X_11496_ _04190_ _04195_ VGND VGND VPWR VPWR _04197_ sky130_fd_sc_hd__xnor2_1
X_10516_ _03123_ _03125_ VGND VGND VPWR VPWR _03126_ sky130_fd_sc_hd__xnor2_1
X_13235_ _06086_ _06090_ VGND VGND VPWR VPWR _06091_ sky130_fd_sc_hd__and2b_1
X_10447_ _02941_ _03048_ _03049_ VGND VGND VPWR VPWR _03051_ sky130_fd_sc_hd__nand3_1
XFILLER_108_193 VGND VGND VPWR VPWR sky130_fd_sc_hd__decap_3
XFILLER_123_163 VGND VGND VPWR VPWR sky130_fd_sc_hd__decap_4
X_13166_ _06013_ _06014_ VGND VGND VPWR VPWR _06016_ sky130_fd_sc_hd__xor2_2
X_10378_ _02961_ _02974_ VGND VGND VPWR VPWR _02976_ sky130_fd_sc_hd__nand2b_1
XFILLER_124_697 VGND VGND VPWR VPWR sky130_fd_sc_hd__decap_3
X_13097_ _05938_ _05939_ VGND VGND VPWR VPWR _05940_ sky130_fd_sc_hd__nor2_1
X_12117_ net634 net405 VGND VGND VPWR VPWR _04870_ sky130_fd_sc_hd__nand2_1
X_12048_ _04789_ _04793_ VGND VGND VPWR VPWR _04795_ sky130_fd_sc_hd__or2_1
XFILLER_37_125 VPWR VGND VPWR VGND sky130_ef_sc_hd__decap_12
XFILLER_92_253 VGND VGND VPWR VPWR sky130_fd_sc_hd__decap_4
XFILLER_53_629 VPWR VGND VPWR VGND sky130_ef_sc_hd__decap_12
XTAP_TAPCELL_ROW_36_816 VGND VPWR sky130_fd_sc_hd__tapvpwrvgnd_1
XTAP_TAPCELL_ROW_36_827 VGND VPWR sky130_fd_sc_hd__tapvpwrvgnd_1
XFILLER_37_169 VGND VGND VPWR VPWR sky130_fd_sc_hd__decap_4
XFILLER_92_297 VGND VGND VPWR VPWR sky130_fd_sc_hd__decap_8
XFILLER_52_139 VGND VGND VPWR VPWR sky130_fd_sc_hd__fill_1
XFILLER_18_394 VGND VGND VPWR VPWR sky130_fd_sc_hd__decap_6
XFILLER_61_695 VPWR VGND VPWR VGND sky130_ef_sc_hd__decap_12
X_08210_ _00677_ _00684_ VGND VGND VPWR VPWR _00043_ sky130_fd_sc_hd__xnor2_1
X_09190_ _01509_ _01683_ VGND VGND VPWR VPWR _01685_ sky130_fd_sc_hd__xor2_1
XFILLER_119_436 VGND VGND VPWR VPWR sky130_fd_sc_hd__decap_6
X_08141_ _00605_ _00616_ VGND VGND VPWR VPWR _00617_ sky130_fd_sc_hd__xnor2_1
X_08072_ _00433_ _00548_ VGND VGND VPWR VPWR _00549_ sky130_fd_sc_hd__xnor2_2
XFILLER_134_417 VGND VGND VPWR VPWR sky130_fd_sc_hd__decap_3
X_07023_ _03347_ _03565_ _03576_ VGND VGND VPWR VPWR _03587_ sky130_fd_sc_hd__or3_1
XFILLER_20_29 VPWR VGND VPWR VGND sky130_ef_sc_hd__decap_12
XFILLER_136_29 VPWR VGND VPWR VGND sky130_ef_sc_hd__decap_12
XFILLER_115_653 VGND VGND VPWR VPWR sky130_fd_sc_hd__fill_2
XTAP_TAPCELL_ROW_112_1918 VGND VPWR sky130_fd_sc_hd__tapvpwrvgnd_1
XTAP_TAPCELL_ROW_112_1929 VGND VPWR sky130_fd_sc_hd__tapvpwrvgnd_1
XFILLER_130_645 VGND VGND VPWR VPWR sky130_fd_sc_hd__decap_4
XFILLER_130_634 VGND VGND VPWR VPWR sky130_fd_sc_hd__decap_8
X_08974_ net455 net334 net332 net463 VGND VGND VPWR VPWR _01449_ sky130_fd_sc_hd__a22oi_2
XPHY_EDGE_ROW_89_Right_89 VGND VGND VPWR VPWR sky130_fd_sc_hd__decap_3
X_07925_ _00392_ _00402_ VGND VGND VPWR VPWR _00403_ sky130_fd_sc_hd__xor2_2
XFILLER_29_27 VPWR VGND VPWR VGND sky130_ef_sc_hd__decap_12
XFILLER_84_721 VGND VGND VPWR VPWR sky130_fd_sc_hd__decap_6
XFILLER_29_615 VGND VGND VPWR VPWR sky130_fd_sc_hd__fill_1
X_07856_ _00297_ _00332_ VGND VGND VPWR VPWR _00334_ sky130_fd_sc_hd__xnor2_2
XFILLER_28_125 VPWR VGND VPWR VGND sky130_ef_sc_hd__decap_12
X_07787_ _00263_ _00264_ VGND VGND VPWR VPWR _00266_ sky130_fd_sc_hd__xor2_2
XFILLER_56_489 VGND VGND VPWR VPWR sky130_fd_sc_hd__decap_4
XFILLER_56_467 VGND VGND VPWR VPWR sky130_fd_sc_hd__decap_8
XFILLER_45_15 VPWR VGND VPWR VGND sky130_ef_sc_hd__decap_12
XFILLER_16_309 VGND VGND VPWR VPWR sky130_fd_sc_hd__decap_6
XFILLER_37_670 VGND VGND VPWR VPWR sky130_fd_sc_hd__fill_2
X_09526_ _02048_ _02049_ VGND VGND VPWR VPWR _02050_ sky130_fd_sc_hd__xnor2_1
X_09457_ net374 net600 VGND VGND VPWR VPWR _01975_ sky130_fd_sc_hd__nand2b_1
XFILLER_101_54 VGND VGND VPWR VPWR sky130_fd_sc_hd__fill_2
XPHY_EDGE_ROW_98_Right_98 VGND VGND VPWR VPWR sky130_fd_sc_hd__decap_3
X_08408_ _00880_ _00881_ VGND VGND VPWR VPWR _00882_ sky130_fd_sc_hd__and2b_1
XFILLER_40_813 VGND VGND VPWR VPWR sky130_fd_sc_hd__fill_1
XFILLER_138_701 VGND VGND VPWR VPWR sky130_fd_sc_hd__fill_2
X_09388_ _01888_ _01899_ VGND VGND VPWR VPWR _01901_ sky130_fd_sc_hd__xor2_1
XTAP_TAPCELL_ROW_82_1490 VGND VPWR sky130_fd_sc_hd__tapvpwrvgnd_1
XFILLER_8_519 VGND VGND VPWR VPWR sky130_fd_sc_hd__decap_4
X_08339_ _00504_ _00742_ _00377_ VGND VGND VPWR VPWR _00813_ sky130_fd_sc_hd__a21oi_2
X_11350_ net535 net304 net307 net263 VGND VGND VPWR VPWR _04038_ sky130_fd_sc_hd__o2bb2a_1
XFILLER_20_581 VGND VGND VPWR VPWR sky130_fd_sc_hd__fill_1
XFILLER_117_3 VPWR VGND VPWR VGND sky130_ef_sc_hd__decap_12
X_10301_ _02888_ _02890_ VGND VGND VPWR VPWR _02891_ sky130_fd_sc_hd__or2_1
XFILLER_106_620 VPWR VGND VPWR VGND sky130_ef_sc_hd__decap_12
X_13020_ _05855_ _05856_ VGND VGND VPWR VPWR _05857_ sky130_fd_sc_hd__and2_1
XFILLER_4_747 VGND VGND VPWR VPWR sky130_fd_sc_hd__decap_8
XFILLER_3_213 VGND VGND VPWR VPWR sky130_fd_sc_hd__fill_2
X_11281_ _03809_ _03962_ VGND VGND VPWR VPWR _03963_ sky130_fd_sc_hd__xnor2_1
XFILLER_121_601 VGND VGND VPWR VPWR sky130_fd_sc_hd__decap_4
XPHY_EDGE_ROW_5_Left_144 VGND VGND VPWR VPWR sky130_fd_sc_hd__decap_3
XFILLER_4_769 VPWR VGND VPWR VGND sky130_ef_sc_hd__decap_12
X_10232_ net520 net298 net297 net527 VGND VGND VPWR VPWR _02817_ sky130_fd_sc_hd__a22o_1
X_10163_ _02642_ _02645_ _02743_ VGND VGND VPWR VPWR _02745_ sky130_fd_sc_hd__o21a_1
XFILLER_133_483 VGND VGND VPWR VPWR sky130_fd_sc_hd__fill_1
XFILLER_121_612 VGND VGND VPWR VPWR sky130_fd_sc_hd__decap_4
XFILLER_106_697 VGND VGND VPWR VPWR sky130_fd_sc_hd__decap_3
XFILLER_120_133 VGND VGND VPWR VPWR sky130_fd_sc_hd__decap_6
X_10094_ _02667_ _02668_ VGND VGND VPWR VPWR _02670_ sky130_fd_sc_hd__xor2_1
XFILLER_120_177 VPWR VGND VPWR VGND sky130_ef_sc_hd__decap_12
XFILLER_94_529 VGND VGND VPWR VPWR sky130_fd_sc_hd__decap_3
XFILLER_86_77 VGND VGND VPWR VPWR sky130_fd_sc_hd__decap_6
XFILLER_59_294 VGND VGND VPWR VPWR sky130_fd_sc_hd__fill_1
XFILLER_74_253 VPWR VGND VPWR VGND sky130_ef_sc_hd__decap_12
XFILLER_47_467 VGND VGND VPWR VPWR sky130_fd_sc_hd__decap_6
XFILLER_19_93 VPWR VGND VPWR VGND sky130_ef_sc_hd__decap_12
XFILLER_19_169 VPWR VGND VPWR VGND sky130_ef_sc_hd__decap_12
XFILLER_28_670 VGND VGND VPWR VPWR sky130_fd_sc_hd__fill_2
XFILLER_35_629 VGND VGND VPWR VPWR sky130_fd_sc_hd__decap_6
XFILLER_90_757 VGND VGND VPWR VPWR sky130_fd_sc_hd__fill_2
XFILLER_90_735 VGND VGND VPWR VPWR sky130_fd_sc_hd__fill_1
X_12804_ _05469_ _05484_ _05482_ VGND VGND VPWR VPWR _05620_ sky130_fd_sc_hd__a21o_1
XFILLER_34_139 VGND VGND VPWR VPWR sky130_fd_sc_hd__fill_1
X_10996_ _03649_ _03650_ VGND VGND VPWR VPWR _03651_ sky130_fd_sc_hd__nor2_1
X_12735_ _05365_ _05367_ _05544_ _05545_ VGND VGND VPWR VPWR _05546_ sky130_fd_sc_hd__o211a_1
XFILLER_43_673 VPWR VGND VPWR VGND sky130_ef_sc_hd__decap_12
XFILLER_15_364 VGND VGND VPWR VPWR sky130_fd_sc_hd__decap_8
XFILLER_35_81 VGND VGND VPWR VPWR sky130_fd_sc_hd__decap_8
XFILLER_89_7 VPWR VGND VPWR VGND sky130_ef_sc_hd__decap_12
X_12666_ _05295_ _05299_ VGND VGND VPWR VPWR _05470_ sky130_fd_sc_hd__nand2_1
XFILLER_70_492 VPWR VGND VPWR VGND sky130_ef_sc_hd__decap_12
XFILLER_30_345 VGND VGND VPWR VPWR sky130_fd_sc_hd__fill_1
XFILLER_128_211 VPWR VGND VPWR VGND sky130_ef_sc_hd__decap_12
X_12597_ _05270_ _05272_ _05393_ VGND VGND VPWR VPWR _05394_ sky130_fd_sc_hd__a21oi_2
X_11617_ net248 _04326_ VGND VGND VPWR VPWR _04328_ sky130_fd_sc_hd__xor2_1
XFILLER_128_244 VGND VGND VPWR VPWR sky130_fd_sc_hd__decap_8
XTAP_TAPCELL_ROW_41_896 VGND VPWR sky130_fd_sc_hd__tapvpwrvgnd_1
X_11548_ _04248_ _04252_ VGND VGND VPWR VPWR _04254_ sky130_fd_sc_hd__and2b_1
XFILLER_128_288 VGND VGND VPWR VPWR sky130_fd_sc_hd__decap_6
Xmax_cap238 _01221_ VGND VGND VPWR VPWR net238 sky130_fd_sc_hd__clkbuf_2
X_11479_ net544 net301 _04029_ _04178_ _03880_ VGND VGND VPWR VPWR _04179_ sky130_fd_sc_hd__a311o_1
XFILLER_98_813 VGND VGND VPWR VPWR sky130_fd_sc_hd__decap_8
X_13218_ _06034_ _06070_ VGND VGND VPWR VPWR _06073_ sky130_fd_sc_hd__xnor2_2
XFILLER_124_494 VGND VGND VPWR VPWR sky130_fd_sc_hd__fill_1
X_13149_ _05995_ _05997_ VGND VGND VPWR VPWR _05998_ sky130_fd_sc_hd__nor2_1
XFILLER_32_3 VPWR VGND VPWR VGND sky130_ef_sc_hd__decap_12
XTAP_TAPCELL_ROW_127_2136 VGND VPWR sky130_fd_sc_hd__tapvpwrvgnd_1
X_07710_ _00150_ _00187_ VGND VGND VPWR VPWR _00189_ sky130_fd_sc_hd__xnor2_1
XTAP_TAPCELL_ROW_127_2147 VGND VPWR sky130_fd_sc_hd__tapvpwrvgnd_1
X_08690_ _01143_ _01155_ VGND VGND VPWR VPWR _01157_ sky130_fd_sc_hd__xnor2_1
X_07641_ _00088_ _00119_ _00120_ VGND VGND VPWR VPWR _00121_ sky130_fd_sc_hd__and3_1
XTAP_TAPCELL_ROW_109_1880 VGND VPWR sky130_fd_sc_hd__tapvpwrvgnd_1
XFILLER_81_735 VGND VGND VPWR VPWR sky130_fd_sc_hd__fill_1
XFILLER_80_201 VGND VGND VPWR VPWR sky130_fd_sc_hd__fill_1
X_07572_ _01387_ _06633_ VGND VGND VPWR VPWR _06801_ sky130_fd_sc_hd__or2_2
X_09311_ _01815_ _01816_ VGND VGND VPWR VPWR _01817_ sky130_fd_sc_hd__and2b_1
XFILLER_81_768 VPWR VGND VPWR VGND sky130_ef_sc_hd__decap_12
XFILLER_22_813 VGND VGND VPWR VPWR sky130_fd_sc_hd__decap_8
XFILLER_40_109 VPWR VGND VPWR VGND sky130_ef_sc_hd__decap_12
X_09242_ _01740_ _01693_ VGND VGND VPWR VPWR _01741_ sky130_fd_sc_hd__and2b_1
XFILLER_33_183 VGND VGND VPWR VPWR sky130_fd_sc_hd__decap_4
X_09173_ _01663_ _01664_ VGND VGND VPWR VPWR _01666_ sky130_fd_sc_hd__xor2_1
XTAP_TAPCELL_ROW_138_2298 VGND VPWR sky130_fd_sc_hd__tapvpwrvgnd_1
XFILLER_119_244 VPWR VGND VPWR VGND sky130_ef_sc_hd__decap_12
X_08124_ net677 net475 net675 net484 VGND VGND VPWR VPWR _00600_ sky130_fd_sc_hd__a22o_1
XFILLER_31_39 VPWR VGND VPWR VGND sky130_ef_sc_hd__decap_12
XFILLER_134_203 VGND VGND VPWR VPWR sky130_fd_sc_hd__fill_1
X_08055_ _00523_ _00531_ VGND VGND VPWR VPWR _00532_ sky130_fd_sc_hd__xor2_1
XTAP_TAPCELL_ROW_56_1109 VGND VPWR sky130_fd_sc_hd__tapvpwrvgnd_1
X_07006_ net655 net642 net708 net709 VGND VGND VPWR VPWR _03401_ sky130_fd_sc_hd__nand4_1
XFILLER_102_144 VPWR VGND VPWR VGND sky130_ef_sc_hd__decap_12
Xinput117 w32[3] VGND VGND VPWR VPWR net117 sky130_fd_sc_hd__clkbuf_2
Xinput106 w31[0] VGND VGND VPWR VPWR net106 sky130_fd_sc_hd__clkbuf_2
Xinput139 x1[1] VGND VGND VPWR VPWR net139 sky130_fd_sc_hd__clkbuf_1
X_08957_ _01427_ _01428_ VGND VGND VPWR VPWR _01430_ sky130_fd_sc_hd__and2_1
Xinput128 w33[6] VGND VGND VPWR VPWR net128 sky130_fd_sc_hd__buf_1
XFILLER_29_401 VGND VGND VPWR VPWR sky130_fd_sc_hd__decap_4
X_08888_ _01245_ _01353_ _01354_ VGND VGND VPWR VPWR _01356_ sky130_fd_sc_hd__nor3_1
X_07908_ net709 net598 VGND VGND VPWR VPWR _00386_ sky130_fd_sc_hd__nand2b_1
XFILLER_72_713 VPWR VGND VPWR VGND sky130_ef_sc_hd__decap_12
X_07839_ _00172_ _00174_ _00176_ VGND VGND VPWR VPWR _00317_ sky130_fd_sc_hd__a21o_1
XFILLER_72_757 VPWR VGND VPWR VGND sky130_ef_sc_hd__decap_12
XFILLER_71_223 VGND VGND VPWR VPWR sky130_fd_sc_hd__fill_1
X_10850_ _03488_ _03490_ net644 net72 VGND VGND VPWR VPWR _03492_ sky130_fd_sc_hd__and4bb_1
XFILLER_112_53 VPWR VGND VPWR VGND sky130_ef_sc_hd__decap_12
X_09509_ _01887_ _01904_ _01903_ VGND VGND VPWR VPWR _02032_ sky130_fd_sc_hd__o21a_1
XFILLER_24_161 VGND VGND VPWR VPWR sky130_fd_sc_hd__fill_2
X_10781_ _03282_ _03302_ _03300_ VGND VGND VPWR VPWR _03416_ sky130_fd_sc_hd__a21o_1
XFILLER_25_673 VGND VGND VPWR VPWR sky130_fd_sc_hd__decap_6
X_12520_ _05276_ _05309_ VGND VGND VPWR VPWR _05311_ sky130_fd_sc_hd__xnor2_1
XFILLER_52_481 VGND VGND VPWR VPWR sky130_fd_sc_hd__fill_1
XFILLER_24_194 VGND VGND VPWR VPWR sky130_fd_sc_hd__fill_2
XFILLER_40_643 VGND VGND VPWR VPWR sky130_fd_sc_hd__fill_1
XPHY_EDGE_ROW_117_Right_117 VGND VGND VPWR VPWR sky130_fd_sc_hd__decap_3
X_12451_ net565 net578 net501 net573 VGND VGND VPWR VPWR _05235_ sky130_fd_sc_hd__a22o_1
XFILLER_138_553 VGND VGND VPWR VPWR sky130_fd_sc_hd__decap_3
XFILLER_138_531 VGND VGND VPWR VPWR sky130_fd_sc_hd__fill_1
XFILLER_8_349 VGND VGND VPWR VPWR sky130_fd_sc_hd__decap_3
X_11402_ _04093_ _04094_ VGND VGND VPWR VPWR _04095_ sky130_fd_sc_hd__or2_1
X_12382_ _05149_ _05158_ _05159_ VGND VGND VPWR VPWR _05160_ sky130_fd_sc_hd__nand3_1
XFILLER_125_225 VPWR VGND VPWR VGND sky130_ef_sc_hd__decap_12
X_11333_ _03528_ _03707_ _03868_ _03869_ VGND VGND VPWR VPWR _04020_ sky130_fd_sc_hd__o31ai_1
XFILLER_98_109 VGND VGND VPWR VPWR sky130_fd_sc_hd__decap_4
XFILLER_97_21 VPWR VGND VPWR VGND sky130_ef_sc_hd__decap_12
XTAP_TAPCELL_ROW_95_1681 VGND VPWR sky130_fd_sc_hd__tapvpwrvgnd_1
XTAP_TAPCELL_ROW_95_1670 VGND VPWR sky130_fd_sc_hd__tapvpwrvgnd_1
X_11264_ _03782_ _03790_ _03789_ VGND VGND VPWR VPWR _03944_ sky130_fd_sc_hd__a21oi_1
XFILLER_134_781 VPWR VGND VPWR VGND sky130_ef_sc_hd__decap_12
XFILLER_106_494 VGND VGND VPWR VPWR sky130_fd_sc_hd__decap_6
X_13003_ _05316_ _05837_ VGND VGND VPWR VPWR _05838_ sky130_fd_sc_hd__nor2_1
X_10215_ _02796_ _02797_ _02798_ VGND VGND VPWR VPWR _02799_ sky130_fd_sc_hd__nor3_1
X_11195_ _03704_ _03706_ _03867_ VGND VGND VPWR VPWR _03869_ sky130_fd_sc_hd__a21o_1
XFILLER_0_750 VGND VGND VPWR VPWR sky130_fd_sc_hd__fill_2
X_10146_ _02721_ _02724_ VGND VGND VPWR VPWR _02726_ sky130_fd_sc_hd__xor2_1
X_10077_ net250 _02649_ VGND VGND VPWR VPWR _02651_ sky130_fd_sc_hd__xnor2_1
XFILLER_48_754 VGND VGND VPWR VPWR sky130_fd_sc_hd__fill_2
XFILLER_63_702 VGND VGND VPWR VPWR sky130_fd_sc_hd__decap_8
XFILLER_47_242 VGND VGND VPWR VPWR sky130_fd_sc_hd__decap_3
XFILLER_47_275 VGND VGND VPWR VPWR sky130_fd_sc_hd__fill_1
XTAP_TAPCELL_ROW_122_2066 VGND VPWR sky130_fd_sc_hd__tapvpwrvgnd_1
XFILLER_90_565 VGND VGND VPWR VPWR sky130_fd_sc_hd__fill_1
XFILLER_63_768 VGND VGND VPWR VPWR sky130_fd_sc_hd__fill_2
XFILLER_50_407 VGND VGND VPWR VPWR sky130_fd_sc_hd__decap_3
XTAP_TAPCELL_ROW_46_966 VGND VPWR sky130_fd_sc_hd__tapvpwrvgnd_1
XFILLER_90_587 VGND VGND VPWR VPWR sky130_fd_sc_hd__fill_1
XFILLER_62_289 VPWR VGND VPWR VGND sky130_ef_sc_hd__decap_12
X_10979_ net433 net424 net276 net278 VGND VGND VPWR VPWR _03633_ sky130_fd_sc_hd__and4_1
X_12718_ net652 net648 net285 VGND VGND VPWR VPWR _05528_ sky130_fd_sc_hd__and3_1
X_13698_ clknet_3_0__leaf_clk _00044_ net715 VGND VGND VPWR VPWR net217 sky130_fd_sc_hd__dfrtp_1
X_12649_ _05293_ _05307_ _05306_ VGND VGND VPWR VPWR _05452_ sky130_fd_sc_hd__a21bo_1
XPHY_EDGE_ROW_68_Left_207 VGND VGND VPWR VPWR sky130_fd_sc_hd__decap_3
XFILLER_7_393 VPWR VGND VPWR VGND sky130_ef_sc_hd__decap_12
XFILLER_89_109 VGND VGND VPWR VPWR sky130_fd_sc_hd__decap_3
XFILLER_125_781 VGND VGND VPWR VPWR sky130_fd_sc_hd__decap_3
X_09860_ _02414_ _02415_ VGND VGND VPWR VPWR _02416_ sky130_fd_sc_hd__nor2_2
XFILLER_98_632 VGND VGND VPWR VPWR sky130_fd_sc_hd__fill_2
X_09791_ _02196_ _02339_ VGND VGND VPWR VPWR _02340_ sky130_fd_sc_hd__xnor2_1
X_08811_ _01274_ _01275_ _01276_ VGND VGND VPWR VPWR _01277_ sky130_fd_sc_hd__nand3b_1
XFILLER_85_326 VGND VGND VPWR VPWR sky130_fd_sc_hd__decap_8
XFILLER_58_529 VGND VGND VPWR VPWR sky130_fd_sc_hd__decap_3
XTAP_TAPCELL_ROW_51_1039 VGND VPWR sky130_fd_sc_hd__tapvpwrvgnd_1
XFILLER_112_497 VGND VGND VPWR VPWR sky130_fd_sc_hd__fill_1
X_08742_ _01205_ _01207_ _01208_ VGND VGND VPWR VPWR _01209_ sky130_fd_sc_hd__nand3_1
XFILLER_85_337 VGND VGND VPWR VPWR sky130_fd_sc_hd__decap_4
X_08673_ _01138_ _01139_ VGND VGND VPWR VPWR _01140_ sky130_fd_sc_hd__and2b_1
XPHY_EDGE_ROW_77_Left_216 VGND VGND VPWR VPWR sky130_fd_sc_hd__decap_3
XFILLER_38_231 VGND VGND VPWR VPWR sky130_fd_sc_hd__fill_1
XFILLER_38_253 VGND VGND VPWR VPWR sky130_fd_sc_hd__decap_6
XFILLER_39_765 VPWR VGND VPWR VGND sky130_ef_sc_hd__decap_12
XFILLER_81_521 VPWR VGND VPWR VGND sky130_ef_sc_hd__decap_12
X_07624_ net650 net644 VGND VGND VPWR VPWR _00104_ sky130_fd_sc_hd__nor2_4
XFILLER_54_735 VPWR VGND VPWR VGND sky130_ef_sc_hd__decap_12
XFILLER_26_415 VGND VGND VPWR VPWR sky130_fd_sc_hd__decap_4
XFILLER_54_757 VGND VGND VPWR VPWR sky130_fd_sc_hd__decap_8
XFILLER_53_256 VGND VGND VPWR VPWR sky130_fd_sc_hd__fill_1
XFILLER_81_576 VPWR VGND VPWR VGND sky130_ef_sc_hd__decap_12
XTAP_TAPCELL_ROW_66_1260 VGND VPWR sky130_fd_sc_hd__tapvpwrvgnd_1
X_07555_ net686 net684 net486 net476 VGND VGND VPWR VPWR _06784_ sky130_fd_sc_hd__and4_1
X_07486_ _06713_ _06714_ VGND VGND VPWR VPWR _06716_ sky130_fd_sc_hd__xnor2_1
XFILLER_22_643 VGND VGND VPWR VPWR sky130_fd_sc_hd__fill_1
XTAP_TAPCELL_ROW_24_649 VGND VPWR sky130_fd_sc_hd__tapvpwrvgnd_1
X_09225_ net595 net585 net354 VGND VGND VPWR VPWR _01722_ sky130_fd_sc_hd__and3_1
XFILLER_42_27 VGND VGND VPWR VPWR sky130_fd_sc_hd__fill_1
XFILLER_10_805 VGND VGND VPWR VPWR sky130_fd_sc_hd__decap_6
XFILLER_21_131 VGND VGND VPWR VPWR sky130_fd_sc_hd__decap_4
XFILLER_21_142 VGND VGND VPWR VPWR sky130_fd_sc_hd__fill_1
XPHY_EDGE_ROW_86_Left_225 VGND VGND VPWR VPWR sky130_fd_sc_hd__decap_3
XFILLER_21_164 VGND VGND VPWR VPWR sky130_fd_sc_hd__decap_4
X_09156_ _01645_ _01646_ VGND VGND VPWR VPWR _01647_ sky130_fd_sc_hd__nor2_1
X_09087_ net515 net345 _01284_ VGND VGND VPWR VPWR _01572_ sky130_fd_sc_hd__and3_1
X_08107_ net251 _00581_ VGND VGND VPWR VPWR _00583_ sky130_fd_sc_hd__xor2_1
XFILLER_123_729 VGND VGND VPWR VPWR sky130_fd_sc_hd__decap_6
XFILLER_101_6 VPWR VGND VPWR VGND sky130_ef_sc_hd__decap_12
X_08038_ net627 net618 net704 VGND VGND VPWR VPWR _00515_ sky130_fd_sc_hd__o21ai_1
XFILLER_116_781 VPWR VGND VPWR VGND sky130_ef_sc_hd__decap_12
XFILLER_1_503 VGND VGND VPWR VPWR sky130_fd_sc_hd__fill_1
XFILLER_1_514 VGND VGND VPWR VPWR sky130_fd_sc_hd__fill_1
X_10000_ _02432_ _02436_ _02566_ VGND VGND VPWR VPWR _02568_ sky130_fd_sc_hd__and3_1
XFILLER_130_261 VGND VGND VPWR VPWR sky130_fd_sc_hd__decap_8
X_09989_ _02525_ _02555_ VGND VGND VPWR VPWR _02556_ sky130_fd_sc_hd__xor2_1
XFILLER_107_97 VGND VGND VPWR VPWR sky130_fd_sc_hd__fill_1
XFILLER_103_453 VGND VGND VPWR VPWR sky130_fd_sc_hd__fill_1
XFILLER_88_153 VGND VGND VPWR VPWR sky130_fd_sc_hd__fill_1
XFILLER_76_304 VGND VGND VPWR VPWR sky130_fd_sc_hd__decap_4
XFILLER_67_57 VPWR VGND VPWR VGND sky130_ef_sc_hd__decap_12
XPHY_EDGE_ROW_95_Left_234 VGND VGND VPWR VPWR sky130_fd_sc_hd__decap_3
XFILLER_92_819 VGND VGND VPWR VPWR sky130_fd_sc_hd__fill_1
XFILLER_57_573 VGND VGND VPWR VPWR sky130_fd_sc_hd__decap_4
XTAP_TAPCELL_ROW_4_363 VGND VPWR sky130_fd_sc_hd__tapvpwrvgnd_1
XTAP_TAPCELL_ROW_4_352 VGND VPWR sky130_fd_sc_hd__tapvpwrvgnd_1
XFILLER_29_231 VPWR VGND VPWR VGND sky130_ef_sc_hd__decap_12
XFILLER_91_329 VGND VGND VPWR VPWR sky130_fd_sc_hd__decap_4
X_11951_ _04662_ _04663_ _04664_ _04689_ VGND VGND VPWR VPWR _04690_ sky130_fd_sc_hd__or4_1
X_10902_ net264 net311 _03365_ VGND VGND VPWR VPWR _03548_ sky130_fd_sc_hd__or3_1
X_11882_ _04615_ _04616_ VGND VGND VPWR VPWR _04618_ sky130_fd_sc_hd__and2b_1
X_13621_ _06510_ _06511_ VGND VGND VPWR VPWR _06512_ sky130_fd_sc_hd__xnor2_1
XTAP_TAPCELL_ROW_43_925 VGND VPWR sky130_fd_sc_hd__tapvpwrvgnd_1
X_10833_ _03471_ _03472_ VGND VGND VPWR VPWR _03473_ sky130_fd_sc_hd__nor2_1
X_13552_ _06425_ _06435_ VGND VGND VPWR VPWR _06437_ sky130_fd_sc_hd__xnor2_1
X_10764_ net476 net297 _03108_ VGND VGND VPWR VPWR _03397_ sky130_fd_sc_hd__and3_1
XFILLER_16_83 VGND VGND VPWR VPWR sky130_fd_sc_hd__fill_1
X_12503_ _05290_ _05291_ VGND VGND VPWR VPWR _05292_ sky130_fd_sc_hd__nand2_1
XFILLER_9_625 VGND VGND VPWR VPWR sky130_fd_sc_hd__fill_1
X_13483_ _06180_ _06361_ VGND VGND VPWR VPWR _06362_ sky130_fd_sc_hd__xor2_1
X_10695_ _03160_ _03163_ _03162_ VGND VGND VPWR VPWR _03322_ sky130_fd_sc_hd__o21bai_1
XFILLER_40_484 VGND VGND VPWR VPWR sky130_fd_sc_hd__decap_3
XTAP_TAPCELL_ROW_97_1710 VGND VPWR sky130_fd_sc_hd__tapvpwrvgnd_1
X_12434_ _05215_ _05216_ VGND VGND VPWR VPWR _05217_ sky130_fd_sc_hd__nand2b_1
XFILLER_126_545 VGND VGND VPWR VPWR sky130_fd_sc_hd__fill_1
X_12365_ _05139_ _05113_ VGND VGND VPWR VPWR _05141_ sky130_fd_sc_hd__and2b_1
XFILLER_114_718 VGND VGND VPWR VPWR sky130_fd_sc_hd__fill_1
X_11316_ _03951_ _04000_ VGND VGND VPWR VPWR _04001_ sky130_fd_sc_hd__xnor2_1
XFILLER_126_589 VPWR VGND VPWR VGND sky130_ef_sc_hd__decap_12
XFILLER_114_729 VPWR VGND VPWR VGND sky130_ef_sc_hd__decap_12
XFILLER_113_206 VGND VGND VPWR VPWR sky130_fd_sc_hd__fill_2
X_12296_ _05062_ _05063_ _05065_ VGND VGND VPWR VPWR _05066_ sky130_fd_sc_hd__or3_1
XFILLER_4_363 VGND VGND VPWR VPWR sky130_fd_sc_hd__fill_1
XFILLER_68_805 VGND VGND VPWR VPWR sky130_fd_sc_hd__decap_6
XFILLER_4_396 VGND VGND VPWR VPWR sky130_fd_sc_hd__fill_1
X_11247_ _03923_ _03924_ VGND VGND VPWR VPWR _03925_ sky130_fd_sc_hd__nor2_1
XFILLER_121_261 VGND VGND VPWR VPWR sky130_fd_sc_hd__decap_8
XFILLER_95_624 VGND VGND VPWR VPWR sky130_fd_sc_hd__fill_1
XFILLER_67_304 VGND VGND VPWR VPWR sky130_fd_sc_hd__decap_3
X_11178_ _03652_ _03684_ _03683_ VGND VGND VPWR VPWR _03851_ sky130_fd_sc_hd__a21bo_1
X_10129_ _02700_ _02707_ VGND VGND VPWR VPWR _02708_ sky130_fd_sc_hd__xnor2_1
XFILLER_95_657 VGND VGND VPWR VPWR sky130_fd_sc_hd__decap_4
XFILLER_67_337 VGND VGND VPWR VPWR sky130_fd_sc_hd__decap_4
XFILLER_35_223 VGND VGND VPWR VPWR sky130_fd_sc_hd__fill_1
XFILLER_36_757 VPWR VGND VPWR VGND sky130_ef_sc_hd__decap_12
XFILLER_90_351 VPWR VGND VPWR VGND sky130_ef_sc_hd__decap_12
XFILLER_23_418 VGND VGND VPWR VPWR sky130_fd_sc_hd__decap_6
XFILLER_90_395 VGND VGND VPWR VPWR sky130_fd_sc_hd__decap_8
X_07340_ _04134_ _04166_ _05461_ _05472_ VGND VGND VPWR VPWR _06571_ sky130_fd_sc_hd__and4_1
XFILLER_50_237 VPWR VGND VPWR VGND sky130_ef_sc_hd__decap_12
XTAP_TAPCELL_ROW_21_608 VGND VPWR sky130_fd_sc_hd__tapvpwrvgnd_1
X_09010_ _01468_ _01487_ _01488_ VGND VGND VPWR VPWR _01489_ sky130_fd_sc_hd__and3_1
X_07271_ _06269_ _06280_ VGND VGND VPWR VPWR _06291_ sky130_fd_sc_hd__nor2_1
XFILLER_136_309 VPWR VGND VPWR VGND sky130_ef_sc_hd__decap_12
XTAP_TAPCELL_ROW_61_1190 VGND VPWR sky130_fd_sc_hd__tapvpwrvgnd_1
XTAP_TAPCELL_ROW_135_2257 VGND VPWR sky130_fd_sc_hd__tapvpwrvgnd_1
XFILLER_117_578 VGND VGND VPWR VPWR sky130_fd_sc_hd__decap_6
XTAP_TAPCELL_ROW_117_1990 VGND VPWR sky130_fd_sc_hd__tapvpwrvgnd_1
XFILLER_105_729 VPWR VGND VPWR VGND sky130_ef_sc_hd__decap_12
X_09912_ _02468_ _02469_ VGND VGND VPWR VPWR _02471_ sky130_fd_sc_hd__xnor2_1
XFILLER_113_751 VPWR VGND VPWR VGND sky130_ef_sc_hd__decap_12
Xfanout615 net617 VGND VGND VPWR VPWR net615 sky130_fd_sc_hd__clkbuf_4
Xfanout604 net605 VGND VGND VPWR VPWR net604 sky130_fd_sc_hd__clkbuf_4
Xfanout637 net132 VGND VGND VPWR VPWR net637 sky130_fd_sc_hd__clkbuf_2
Xfanout626 net134 VGND VGND VPWR VPWR net626 sky130_fd_sc_hd__buf_4
X_09843_ net614 net368 _02274_ _02273_ VGND VGND VPWR VPWR _02397_ sky130_fd_sc_hd__a31oi_2
Xfanout648 net649 VGND VGND VPWR VPWR net648 sky130_fd_sc_hd__buf_12
Xfanout659 net13 VGND VGND VPWR VPWR net659 sky130_fd_sc_hd__buf_2
X_09774_ _02220_ _02222_ _02320_ VGND VGND VPWR VPWR _02321_ sky130_fd_sc_hd__o21ba_1
X_06986_ _03139_ _03172_ VGND VGND VPWR VPWR _03183_ sky130_fd_sc_hd__xnor2_1
XTAP_TAPCELL_ROW_29_719 VGND VPWR sky130_fd_sc_hd__tapvpwrvgnd_1
XFILLER_37_27 VPWR VGND VPWR VGND sky130_ef_sc_hd__decap_12
X_08725_ _01182_ _01184_ _01183_ VGND VGND VPWR VPWR _01192_ sky130_fd_sc_hd__o21ai_1
XTAP_TAPCELL_ROW_1_311 VGND VPWR sky130_fd_sc_hd__tapvpwrvgnd_1
XFILLER_26_212 VGND VGND VPWR VPWR sky130_fd_sc_hd__fill_1
X_08656_ _01120_ _01122_ VGND VGND VPWR VPWR _01123_ sky130_fd_sc_hd__or2_1
X_08587_ _01050_ _01054_ VGND VGND VPWR VPWR _01055_ sky130_fd_sc_hd__nand2b_1
X_07607_ _00085_ _00086_ VGND VGND VPWR VPWR _00087_ sky130_fd_sc_hd__and2b_1
XFILLER_53_15 VPWR VGND VPWR VGND sky130_ef_sc_hd__decap_12
X_07538_ _06766_ _06760_ VGND VGND VPWR VPWR _06767_ sky130_fd_sc_hd__and2b_1
XFILLER_10_602 VPWR VGND VPWR VGND sky130_ef_sc_hd__decap_12
X_07469_ _06534_ _06542_ _06541_ VGND VGND VPWR VPWR _06699_ sky130_fd_sc_hd__a21bo_1
XFILLER_22_484 VGND VGND VPWR VPWR sky130_fd_sc_hd__decap_8
X_09208_ net555 net359 net358 net564 VGND VGND VPWR VPWR _01704_ sky130_fd_sc_hd__a22o_1
XFILLER_108_501 VGND VGND VPWR VPWR sky130_fd_sc_hd__fill_1
X_10480_ net588 net579 net306 net304 VGND VGND VPWR VPWR _03087_ sky130_fd_sc_hd__and4_1
XFILLER_136_821 VGND VGND VPWR VPWR sky130_fd_sc_hd__decap_3
X_09139_ _01617_ _01628_ VGND VGND VPWR VPWR _01629_ sky130_fd_sc_hd__xnor2_1
XFILLER_108_512 VPWR VGND VPWR VGND sky130_ef_sc_hd__decap_12
XTAP_TAPCELL_ROW_79_1451 VGND VPWR sky130_fd_sc_hd__tapvpwrvgnd_1
XTAP_TAPCELL_ROW_79_1440 VGND VPWR sky130_fd_sc_hd__tapvpwrvgnd_1
XFILLER_5_105 VGND VGND VPWR VPWR sky130_fd_sc_hd__decap_6
XFILLER_135_331 VGND VGND VPWR VPWR sky130_fd_sc_hd__fill_1
XFILLER_118_41 VPWR VGND VPWR VGND sky130_ef_sc_hd__decap_12
X_12150_ _04895_ _04898_ _04897_ VGND VGND VPWR VPWR _04907_ sky130_fd_sc_hd__a21o_1
XFILLER_135_375 VGND VGND VPWR VPWR sky130_fd_sc_hd__fill_1
XFILLER_123_537 VGND VGND VPWR VPWR sky130_fd_sc_hd__decap_3
XTAP_TAPCELL_ROW_9_433 VGND VPWR sky130_fd_sc_hd__tapvpwrvgnd_1
XFILLER_1_300 VGND VGND VPWR VPWR sky130_fd_sc_hd__decap_8
X_11101_ net483 net291 net293 net474 VGND VGND VPWR VPWR _03766_ sky130_fd_sc_hd__a22o_1
XFILLER_118_96 VPWR VGND VPWR VGND sky130_ef_sc_hd__decap_12
XFILLER_118_85 VGND VGND VPWR VPWR sky130_fd_sc_hd__fill_1
XTAP_TAPCELL_ROW_92_1640 VGND VPWR sky130_fd_sc_hd__tapvpwrvgnd_1
X_12081_ _04829_ _04830_ VGND VGND VPWR VPWR _04831_ sky130_fd_sc_hd__and2b_1
XFILLER_77_613 VGND VGND VPWR VPWR sky130_fd_sc_hd__decap_3
X_11032_ _03688_ _03689_ _03629_ VGND VGND VPWR VPWR _03691_ sky130_fd_sc_hd__o21a_1
XFILLER_49_337 VGND VGND VPWR VPWR sky130_fd_sc_hd__decap_3
XFILLER_1_399 VGND VGND VPWR VPWR sky130_fd_sc_hd__decap_4
XFILLER_76_156 VPWR VGND VPWR VGND sky130_ef_sc_hd__decap_12
XFILLER_94_77 VGND VGND VPWR VPWR sky130_fd_sc_hd__decap_6
X_12983_ net437 net428 net383 net381 VGND VGND VPWR VPWR _05816_ sky130_fd_sc_hd__and4_1
XFILLER_17_212 VGND VGND VPWR VPWR sky130_fd_sc_hd__decap_3
XFILLER_18_713 VGND VGND VPWR VPWR sky130_fd_sc_hd__fill_2
X_11934_ net645 net405 net386 net658 VGND VGND VPWR VPWR _04671_ sky130_fd_sc_hd__a22oi_1
XFILLER_18_757 VPWR VGND VPWR VGND sky130_ef_sc_hd__decap_12
XFILLER_60_502 VGND VGND VPWR VPWR sky130_fd_sc_hd__decap_8
X_13604_ _06239_ _06416_ _06418_ VGND VGND VPWR VPWR _06493_ sky130_fd_sc_hd__a21oi_1
X_11865_ _04576_ _04597_ VGND VGND VPWR VPWR _04599_ sky130_fd_sc_hd__xnor2_1
X_11796_ _04497_ _04523_ VGND VGND VPWR VPWR _04524_ sky130_fd_sc_hd__or2_1
X_10816_ _03453_ VGND VGND VPWR VPWR _03454_ sky130_fd_sc_hd__inv_2
X_13535_ _06318_ _06417_ VGND VGND VPWR VPWR _06418_ sky130_fd_sc_hd__and2b_1
XFILLER_43_81 VPWR VGND VPWR VGND sky130_ef_sc_hd__decap_12
XFILLER_9_433 VGND VGND VPWR VPWR sky130_fd_sc_hd__fill_1
X_10747_ net588 net299 VGND VGND VPWR VPWR _03378_ sky130_fd_sc_hd__nand2_1
XFILLER_13_473 VGND VGND VPWR VPWR sky130_fd_sc_hd__fill_1
XFILLER_13_484 VGND VGND VPWR VPWR sky130_fd_sc_hd__decap_4
XFILLER_118_309 VPWR VGND VPWR VGND sky130_ef_sc_hd__decap_12
X_13466_ _06341_ _06342_ VGND VGND VPWR VPWR _06343_ sky130_fd_sc_hd__nand2b_1
XFILLER_71_7 VPWR VGND VPWR VGND sky130_ef_sc_hd__decap_12
X_10678_ _03282_ _03302_ VGND VGND VPWR VPWR _03304_ sky130_fd_sc_hd__xor2_1
XFILLER_127_821 VGND VGND VPWR VPWR sky130_fd_sc_hd__decap_3
X_12417_ _05195_ _05196_ _05165_ VGND VGND VPWR VPWR _05198_ sky130_fd_sc_hd__a21o_1
X_13397_ _06260_ _06266_ VGND VGND VPWR VPWR _06268_ sky130_fd_sc_hd__xnor2_1
Xoutput207 net207 VGND VGND VPWR VPWR y2[4] sky130_fd_sc_hd__buf_2
X_12348_ _05119_ _05120_ _05117_ VGND VGND VPWR VPWR _05123_ sky130_fd_sc_hd__a21bo_1
Xoutput229 net229 VGND VGND VPWR VPWR y3[9] sky130_fd_sc_hd__buf_2
Xoutput218 net218 VGND VGND VPWR VPWR y3[14] sky130_fd_sc_hd__buf_2
X_12279_ _04888_ _04891_ _05045_ _05047_ VGND VGND VPWR VPWR _05048_ sky130_fd_sc_hd__a211oi_4
XTAP_TAPCELL_ROW_130_2187 VGND VPWR sky130_fd_sc_hd__tapvpwrvgnd_1
XFILLER_4_53 VPWR VGND VPWR VGND sky130_ef_sc_hd__decap_12
XFILLER_95_410 VGND VGND VPWR VPWR sky130_fd_sc_hd__fill_1
XFILLER_68_657 VPWR VGND VPWR VGND sky130_ef_sc_hd__decap_12
X_06840_ net655 net267 net642 net269 VGND VGND VPWR VPWR _01594_ sky130_fd_sc_hd__a22oi_1
XFILLER_4_97 VGND VGND VPWR VPWR sky130_fd_sc_hd__decap_4
XFILLER_95_454 VPWR VGND VPWR VGND sky130_ef_sc_hd__decap_12
XFILLER_67_134 VGND VGND VPWR VPWR sky130_fd_sc_hd__decap_6
XFILLER_95_487 VPWR VGND VPWR VGND sky130_ef_sc_hd__decap_12
XFILLER_55_329 VGND VGND VPWR VPWR sky130_fd_sc_hd__decap_6
X_09490_ _01910_ _02011_ VGND VGND VPWR VPWR _02012_ sky130_fd_sc_hd__xnor2_1
X_08510_ _00980_ _00981_ VGND VGND VPWR VPWR _00982_ sky130_fd_sc_hd__xnor2_1
XTAP_TAPCELL_ROW_104_1809 VGND VPWR sky130_fd_sc_hd__tapvpwrvgnd_1
X_08441_ _00825_ _00912_ _00913_ VGND VGND VPWR VPWR _00914_ sky130_fd_sc_hd__or3_1
XFILLER_24_716 VPWR VGND VPWR VGND sky130_ef_sc_hd__decap_12
XFILLER_63_384 VGND VGND VPWR VPWR sky130_fd_sc_hd__fill_1
XFILLER_24_738 VGND VGND VPWR VPWR sky130_fd_sc_hd__decap_6
X_08372_ _00821_ _00845_ VGND VGND VPWR VPWR _00846_ sky130_fd_sc_hd__nor2_1
XFILLER_23_259 VGND VGND VPWR VPWR sky130_fd_sc_hd__decap_4
X_07323_ _05264_ _05286_ _06552_ _06553_ VGND VGND VPWR VPWR _06554_ sky130_fd_sc_hd__o211ai_2
XFILLER_32_793 VPWR VGND VPWR VGND sky130_ef_sc_hd__decap_12
XTAP_TAPCELL_ROW_34_788 VGND VPWR sky130_fd_sc_hd__tapvpwrvgnd_1
XTAP_TAPCELL_ROW_34_799 VGND VPWR sky130_fd_sc_hd__tapvpwrvgnd_1
X_07254_ _06072_ _06083_ _06094_ VGND VGND VPWR VPWR _06105_ sky130_fd_sc_hd__and3_1
XFILLER_31_281 VGND VGND VPWR VPWR sky130_fd_sc_hd__decap_8
XFILLER_136_139 VGND VGND VPWR VPWR sky130_fd_sc_hd__fill_1
XFILLER_118_821 VGND VGND VPWR VPWR sky130_fd_sc_hd__decap_3
X_07185_ _05308_ _05319_ _04816_ VGND VGND VPWR VPWR _05352_ sky130_fd_sc_hd__o21ai_1
XFILLER_105_559 VGND VGND VPWR VPWR sky130_fd_sc_hd__fill_1
XFILLER_99_760 VPWR VGND VPWR VGND sky130_ef_sc_hd__decap_12
Xfanout423 net16 VGND VGND VPWR VPWR net423 sky130_fd_sc_hd__clkbuf_2
Xfanout401 net21 VGND VGND VPWR VPWR net401 sky130_fd_sc_hd__buf_1
XTAP_TAPCELL_ROW_74_1370 VGND VPWR sky130_fd_sc_hd__tapvpwrvgnd_1
Xfanout412 net414 VGND VGND VPWR VPWR net412 sky130_fd_sc_hd__buf_2
XFILLER_48_15 VPWR VGND VPWR VGND sky130_ef_sc_hd__decap_12
XFILLER_101_743 VPWR VGND VPWR VGND sky130_ef_sc_hd__decap_12
XFILLER_86_432 VGND VGND VPWR VPWR sky130_fd_sc_hd__fill_1
XFILLER_86_421 VGND VGND VPWR VPWR sky130_fd_sc_hd__fill_1
Xfanout445 net448 VGND VGND VPWR VPWR net445 sky130_fd_sc_hd__buf_4
Xfanout456 net156 VGND VGND VPWR VPWR net456 sky130_fd_sc_hd__clkbuf_4
Xfanout434 net441 VGND VGND VPWR VPWR net434 sky130_fd_sc_hd__buf_2
X_09826_ _02372_ _02376_ VGND VGND VPWR VPWR _02378_ sky130_fd_sc_hd__xnor2_1
XFILLER_100_253 VPWR VGND VPWR VGND sky130_ef_sc_hd__decap_12
Xfanout489 net491 VGND VGND VPWR VPWR net489 sky130_fd_sc_hd__clkbuf_4
Xfanout478 net482 VGND VGND VPWR VPWR net478 sky130_fd_sc_hd__clkbuf_4
XFILLER_86_454 VGND VGND VPWR VPWR sky130_fd_sc_hd__fill_2
Xfanout467 net469 VGND VGND VPWR VPWR net467 sky130_fd_sc_hd__buf_2
X_09757_ _02108_ _02158_ _02157_ VGND VGND VPWR VPWR _02303_ sky130_fd_sc_hd__a21bo_1
XFILLER_74_649 VGND VGND VPWR VPWR sky130_fd_sc_hd__fill_1
X_06969_ _02975_ _02986_ VGND VGND VPWR VPWR _02997_ sky130_fd_sc_hd__or2_1
X_08708_ _01172_ _01173_ _01171_ VGND VGND VPWR VPWR _01175_ sky130_fd_sc_hd__a21bo_1
XFILLER_104_65 VPWR VGND VPWR VGND sky130_ef_sc_hd__decap_12
X_09688_ net479 net346 net344 net488 VGND VGND VPWR VPWR _02228_ sky130_fd_sc_hd__a22o_1
X_08639_ _01100_ _01105_ VGND VGND VPWR VPWR _01106_ sky130_fd_sc_hd__and2_1
XFILLER_120_53 VPWR VGND VPWR VGND sky130_ef_sc_hd__decap_12
XFILLER_42_557 VPWR VGND VPWR VGND sky130_ef_sc_hd__decap_12
X_11650_ _04105_ _04268_ _03964_ VGND VGND VPWR VPWR _04365_ sky130_fd_sc_hd__o21ai_1
XFILLER_120_97 VPWR VGND VPWR VGND sky130_ef_sc_hd__decap_12
X_11581_ _04288_ _04289_ VGND VGND VPWR VPWR _04290_ sky130_fd_sc_hd__or2_1
X_10601_ net537 net313 _03218_ VGND VGND VPWR VPWR _03219_ sky130_fd_sc_hd__a21o_1
XFILLER_128_618 VGND VGND VPWR VPWR sky130_fd_sc_hd__decap_8
X_13320_ _06180_ _06182_ _06183_ VGND VGND VPWR VPWR _06184_ sky130_fd_sc_hd__or3_1
XFILLER_10_421 VGND VGND VPWR VPWR sky130_fd_sc_hd__fill_2
XFILLER_10_443 VPWR VGND VPWR VGND sky130_ef_sc_hd__decap_12
XFILLER_13_51 VGND VGND VPWR VPWR sky130_fd_sc_hd__decap_4
X_10532_ _03141_ _03142_ _03143_ VGND VGND VPWR VPWR _03144_ sky130_fd_sc_hd__and3_1
XFILLER_129_51 VGND VGND VPWR VPWR sky130_fd_sc_hd__decap_4
XFILLER_109_821 VGND VGND VPWR VPWR sky130_fd_sc_hd__decap_3
XFILLER_10_465 VGND VGND VPWR VPWR sky130_fd_sc_hd__fill_1
XFILLER_108_342 VGND VGND VPWR VPWR sky130_fd_sc_hd__decap_8
X_13251_ _06106_ _06107_ VGND VGND VPWR VPWR _06109_ sky130_fd_sc_hd__xor2_1
X_10463_ _02868_ _02880_ _03059_ _03064_ VGND VGND VPWR VPWR _03069_ sky130_fd_sc_hd__o211ai_1
XFILLER_135_161 VGND VGND VPWR VPWR sky130_fd_sc_hd__decap_6
XFILLER_124_813 VGND VGND VPWR VPWR sky130_fd_sc_hd__decap_6
X_12202_ _04961_ _04962_ VGND VGND VPWR VPWR _04963_ sky130_fd_sc_hd__xnor2_1
X_13182_ _06031_ _06032_ VGND VGND VPWR VPWR _06033_ sky130_fd_sc_hd__and2b_1
XFILLER_89_55 VGND VGND VPWR VPWR sky130_fd_sc_hd__fill_1
X_10394_ net641 net326 VGND VGND VPWR VPWR _02993_ sky130_fd_sc_hd__and2_1
XFILLER_123_323 VGND VGND VPWR VPWR sky130_fd_sc_hd__fill_1
X_12133_ _04887_ VGND VGND VPWR VPWR _04888_ sky130_fd_sc_hd__inv_2
X_12064_ _04756_ _04811_ VGND VGND VPWR VPWR _04812_ sky130_fd_sc_hd__and2_1
XFILLER_2_664 VPWR VGND VPWR VGND sky130_ef_sc_hd__decap_12
XFILLER_123_389 VGND VGND VPWR VPWR sky130_fd_sc_hd__decap_3
XFILLER_89_281 VGND VGND VPWR VPWR sky130_fd_sc_hd__decap_8
X_11015_ _01442_ _00104_ _03669_ _03670_ VGND VGND VPWR VPWR _03672_ sky130_fd_sc_hd__or4_1
XFILLER_38_819 VGND VGND VPWR VPWR sky130_fd_sc_hd__fill_1
XFILLER_64_115 VGND VGND VPWR VPWR sky130_fd_sc_hd__fill_1
XFILLER_49_189 VPWR VGND VPWR VGND sky130_ef_sc_hd__decap_12
XFILLER_92_457 VGND VGND VPWR VPWR sky130_fd_sc_hd__decap_6
X_12966_ net420 net388 _05663_ _05662_ VGND VGND VPWR VPWR _05797_ sky130_fd_sc_hd__a31o_1
XFILLER_18_554 VPWR VGND VPWR VGND sky130_ef_sc_hd__decap_12
XFILLER_18_587 VGND VGND VPWR VPWR sky130_fd_sc_hd__fill_1
X_12897_ _05575_ _05721_ VGND VGND VPWR VPWR _05722_ sky130_fd_sc_hd__xnor2_1
XFILLER_45_384 VGND VGND VPWR VPWR sky130_fd_sc_hd__decap_8
X_11917_ _04625_ _04654_ VGND VGND VPWR VPWR _04655_ sky130_fd_sc_hd__xnor2_1
XFILLER_60_365 VGND VGND VPWR VPWR sky130_fd_sc_hd__fill_2
X_11848_ _04212_ _04466_ _04080_ VGND VGND VPWR VPWR _04581_ sky130_fd_sc_hd__o21a_1
XFILLER_21_719 VGND VGND VPWR VPWR sky130_fd_sc_hd__decap_8
XTAP_TAPCELL_ROW_119_2027 VGND VPWR sky130_fd_sc_hd__tapvpwrvgnd_1
X_13518_ _06397_ _06398_ VGND VGND VPWR VPWR _06401_ sky130_fd_sc_hd__xor2_1
X_11779_ _04325_ _04327_ VGND VGND VPWR VPWR _04506_ sky130_fd_sc_hd__nand2_1
XFILLER_13_281 VPWR VGND VPWR VGND sky130_ef_sc_hd__decap_12
XTAP_TAPCELL_ROW_31_747 VGND VPWR sky130_fd_sc_hd__tapvpwrvgnd_1
XTAP_TAPCELL_ROW_132_2216 VGND VPWR sky130_fd_sc_hd__tapvpwrvgnd_1
X_13449_ _06317_ _06324_ VGND VGND VPWR VPWR _06325_ sky130_fd_sc_hd__nand2b_1
XTAP_TAPCELL_ROW_11_460 VGND VPWR sky130_fd_sc_hd__tapvpwrvgnd_1
XFILLER_127_673 VPWR VGND VPWR VGND sky130_ef_sc_hd__decap_12
XFILLER_126_194 VGND VGND VPWR VPWR sky130_fd_sc_hd__fill_2
XFILLER_5_480 VGND VGND VPWR VPWR sky130_fd_sc_hd__decap_6
XFILLER_130_805 VGND VGND VPWR VPWR sky130_fd_sc_hd__decap_6
X_08990_ _01462_ _01466_ VGND VGND VPWR VPWR _01467_ sky130_fd_sc_hd__nand2_1
XFILLER_87_218 VGND VGND VPWR VPWR sky130_fd_sc_hd__decap_6
XFILLER_87_229 VGND VGND VPWR VPWR sky130_fd_sc_hd__fill_1
X_07941_ _00296_ _00418_ VGND VGND VPWR VPWR _00419_ sky130_fd_sc_hd__xnor2_2
X_07872_ net671 _06801_ _06803_ _00211_ VGND VGND VPWR VPWR _00350_ sky130_fd_sc_hd__a2bb2o_1
X_06823_ net377 VGND VGND VPWR VPWR _01409_ sky130_fd_sc_hd__inv_2
X_09611_ _02141_ _02142_ net614 net370 VGND VGND VPWR VPWR _02144_ sky130_fd_sc_hd__and4bb_1
XFILLER_95_262 VGND VGND VPWR VPWR sky130_fd_sc_hd__fill_1
XFILLER_18_29 VPWR VGND VPWR VGND sky130_ef_sc_hd__decap_12
XFILLER_28_307 VGND VGND VPWR VPWR sky130_fd_sc_hd__fill_1
X_09542_ _02065_ _02066_ VGND VGND VPWR VPWR _02068_ sky130_fd_sc_hd__xnor2_1
XFILLER_55_148 VPWR VGND VPWR VGND sky130_ef_sc_hd__decap_12
XFILLER_55_126 VGND VGND VPWR VPWR sky130_fd_sc_hd__decap_8
XPHY_EDGE_ROW_50_Left_189 VGND VGND VPWR VPWR sky130_fd_sc_hd__decap_3
XTAP_TAPCELL_ROW_39_858 VGND VPWR sky130_fd_sc_hd__tapvpwrvgnd_1
XTAP_TAPCELL_ROW_39_869 VGND VPWR sky130_fd_sc_hd__tapvpwrvgnd_1
XFILLER_83_479 VGND VGND VPWR VPWR sky130_fd_sc_hd__fill_1
XFILLER_64_660 VGND VGND VPWR VPWR sky130_fd_sc_hd__fill_1
X_09473_ _01988_ _01992_ VGND VGND VPWR VPWR _01993_ sky130_fd_sc_hd__xnor2_2
XTAP_TAPCELL_ROW_19_571 VGND VPWR sky130_fd_sc_hd__tapvpwrvgnd_1
X_08424_ _00724_ _00806_ VGND VGND VPWR VPWR _00897_ sky130_fd_sc_hd__xor2_1
XFILLER_12_708 VGND VGND VPWR VPWR sky130_fd_sc_hd__fill_1
X_08355_ _00827_ _00828_ VGND VGND VPWR VPWR _00829_ sky130_fd_sc_hd__nor2_1
XFILLER_51_387 VGND VGND VPWR VPWR sky130_fd_sc_hd__fill_1
X_07306_ net642 net707 net104 net651 VGND VGND VPWR VPWR _06537_ sky130_fd_sc_hd__a22oi_2
XFILLER_50_27 VGND VGND VPWR VPWR sky130_fd_sc_hd__fill_1
X_08286_ _00759_ _00760_ VGND VGND VPWR VPWR _00761_ sky130_fd_sc_hd__nor2_1
X_07237_ _05897_ _05908_ VGND VGND VPWR VPWR _05919_ sky130_fd_sc_hd__or2_1
XFILLER_133_610 VGND VGND VPWR VPWR sky130_fd_sc_hd__fill_2
XFILLER_124_109 VGND VGND VPWR VPWR sky130_fd_sc_hd__decap_8
XFILLER_118_662 VGND VGND VPWR VPWR sky130_fd_sc_hd__fill_1
XFILLER_106_813 VGND VGND VPWR VPWR sky130_fd_sc_hd__decap_8
X_07168_ _05068_ _05144_ _05155_ VGND VGND VPWR VPWR _05166_ sky130_fd_sc_hd__nand3_1
XFILLER_132_153 VGND VGND VPWR VPWR sky130_fd_sc_hd__decap_8
X_07099_ _02695_ _02717_ VGND VGND VPWR VPWR _04417_ sky130_fd_sc_hd__nor2_1
XFILLER_132_197 VGND VGND VPWR VPWR sky130_fd_sc_hd__decap_4
XFILLER_59_69 VPWR VGND VPWR VGND sky130_ef_sc_hd__decap_12
XFILLER_120_348 VPWR VGND VPWR VGND sky130_ef_sc_hd__decap_12
XFILLER_87_741 VGND VGND VPWR VPWR sky130_fd_sc_hd__decap_4
Xfanout264 _01355_ VGND VGND VPWR VPWR net264 sky130_fd_sc_hd__buf_2
X_09809_ _02239_ _02252_ _02251_ VGND VGND VPWR VPWR _02360_ sky130_fd_sc_hd__o21ai_1
XFILLER_87_785 VPWR VGND VPWR VGND sky130_ef_sc_hd__decap_12
XFILLER_86_251 VGND VGND VPWR VPWR sky130_fd_sc_hd__fill_1
XFILLER_74_424 VGND VGND VPWR VPWR sky130_fd_sc_hd__decap_8
XFILLER_59_487 VGND VGND VPWR VPWR sky130_fd_sc_hd__decap_3
Xfanout286 net89 VGND VGND VPWR VPWR net286 sky130_fd_sc_hd__clkbuf_4
Xfanout297 net83 VGND VGND VPWR VPWR net297 sky130_fd_sc_hd__buf_2
Xfanout275 net95 VGND VGND VPWR VPWR net275 sky130_fd_sc_hd__buf_2
X_12820_ _05633_ _05634_ _05636_ VGND VGND VPWR VPWR _05638_ sky130_fd_sc_hd__a21o_1
XFILLER_75_57 VGND VGND VPWR VPWR sky130_fd_sc_hd__decap_4
XTAP_TAPCELL_ROW_87_1561 VGND VPWR sky130_fd_sc_hd__tapvpwrvgnd_1
XFILLER_27_362 VGND VGND VPWR VPWR sky130_fd_sc_hd__decap_8
X_12751_ _05558_ _05561_ _05222_ VGND VGND VPWR VPWR _05563_ sky130_fd_sc_hd__o21ai_1
XFILLER_61_118 VGND VGND VPWR VPWR sky130_fd_sc_hd__decap_4
XFILLER_42_321 VGND VGND VPWR VPWR sky130_fd_sc_hd__decap_4
X_12682_ _05452_ _05487_ VGND VGND VPWR VPWR _05488_ sky130_fd_sc_hd__xnor2_1
X_11702_ _04419_ _04420_ VGND VGND VPWR VPWR _04422_ sky130_fd_sc_hd__and2_1
XFILLER_15_557 VGND VGND VPWR VPWR sky130_fd_sc_hd__decap_3
XFILLER_42_365 VPWR VGND VPWR VGND sky130_ef_sc_hd__decap_12
X_11633_ _04345_ VGND VGND VPWR VPWR _04346_ sky130_fd_sc_hd__inv_2
XFILLER_30_505 VGND VGND VPWR VPWR sky130_fd_sc_hd__fill_1
XFILLER_24_83 VGND VGND VPWR VPWR sky130_fd_sc_hd__fill_1
XFILLER_11_785 VPWR VGND VPWR VGND sky130_ef_sc_hd__decap_12
X_11564_ _04270_ _04261_ VGND VGND VPWR VPWR _04271_ sky130_fd_sc_hd__nand2b_1
XFILLER_128_459 VPWR VGND VPWR VGND sky130_ef_sc_hd__decap_12
X_13303_ _05879_ _06027_ _05880_ VGND VGND VPWR VPWR _06166_ sky130_fd_sc_hd__nor3b_1
X_11495_ _04190_ _04195_ VGND VGND VPWR VPWR _04196_ sky130_fd_sc_hd__nand2_1
X_10515_ _02951_ _03124_ VGND VGND VPWR VPWR _03125_ sky130_fd_sc_hd__or2_1
XFILLER_109_673 VPWR VGND VPWR VGND sky130_ef_sc_hd__decap_12
X_13234_ _05476_ _06089_ VGND VGND VPWR VPWR _06090_ sky130_fd_sc_hd__xnor2_1
X_10446_ _02941_ _03048_ _03049_ VGND VGND VPWR VPWR _03050_ sky130_fd_sc_hd__and3_1
XFILLER_123_120 VPWR VGND VPWR VGND sky130_ef_sc_hd__decap_12
XFILLER_6_299 VGND VGND VPWR VPWR sky130_fd_sc_hd__fill_1
XFILLER_124_676 VGND VGND VPWR VPWR sky130_fd_sc_hd__fill_2
XFILLER_112_805 VGND VGND VPWR VPWR sky130_fd_sc_hd__decap_6
X_13165_ _06013_ _06014_ VGND VGND VPWR VPWR _06015_ sky130_fd_sc_hd__nor2_1
X_10377_ _02967_ _02972_ VGND VGND VPWR VPWR _02974_ sky130_fd_sc_hd__xor2_1
XFILLER_111_337 VGND VGND VPWR VPWR sky130_fd_sc_hd__decap_8
XFILLER_97_527 VPWR VGND VPWR VGND sky130_ef_sc_hd__decap_12
X_13096_ net259 net398 _05936_ _05937_ VGND VGND VPWR VPWR _05939_ sky130_fd_sc_hd__nor4_1
X_12116_ _04861_ _04867_ _04868_ VGND VGND VPWR VPWR _04869_ sky130_fd_sc_hd__and3_1
X_12047_ _04736_ _04739_ _04788_ VGND VGND VPWR VPWR _04793_ sky130_fd_sc_hd__nor3_1
XFILLER_93_744 VGND VGND VPWR VPWR sky130_fd_sc_hd__decap_4
XFILLER_37_137 VPWR VGND VPWR VGND sky130_ef_sc_hd__decap_12
XFILLER_93_777 VGND VGND VPWR VPWR sky130_fd_sc_hd__decap_6
XFILLER_92_265 VGND VGND VPWR VPWR sky130_fd_sc_hd__fill_1
XFILLER_18_340 VPWR VGND VPWR VGND sky130_ef_sc_hd__decap_12
XFILLER_34_811 VGND VGND VPWR VPWR sky130_fd_sc_hd__fill_1
XTAP_TAPCELL_ROW_36_817 VGND VPWR sky130_fd_sc_hd__tapvpwrvgnd_1
X_12949_ _05640_ _05653_ _05652_ VGND VGND VPWR VPWR _05779_ sky130_fd_sc_hd__o21ai_1
XTAP_TAPCELL_ROW_36_828 VGND VPWR sky130_fd_sc_hd__tapvpwrvgnd_1
XTAP_TAPCELL_ROW_16_530 VGND VPWR sky130_fd_sc_hd__tapvpwrvgnd_1
XFILLER_33_354 VGND VGND VPWR VPWR sky130_fd_sc_hd__decap_8
XFILLER_61_685 VGND VGND VPWR VPWR sky130_fd_sc_hd__decap_6
XFILLER_21_527 VGND VGND VPWR VPWR sky130_fd_sc_hd__fill_2
X_08140_ _00613_ _00614_ VGND VGND VPWR VPWR _00616_ sky130_fd_sc_hd__xor2_1
X_08071_ _00545_ _00546_ VGND VGND VPWR VPWR _00548_ sky130_fd_sc_hd__xor2_2
XFILLER_115_610 VGND VGND VPWR VPWR sky130_fd_sc_hd__decap_6
X_07022_ _03478_ _03554_ _03543_ VGND VGND VPWR VPWR _03576_ sky130_fd_sc_hd__a21oi_1
XTAP_TAPCELL_ROW_58_1140 VGND VPWR sky130_fd_sc_hd__tapvpwrvgnd_1
XFILLER_115_665 VGND VGND VPWR VPWR sky130_fd_sc_hd__decap_6
XTAP_TAPCELL_ROW_112_1919 VGND VPWR sky130_fd_sc_hd__tapvpwrvgnd_1
XFILLER_88_505 VPWR VGND VPWR VGND sky130_ef_sc_hd__decap_12
XFILLER_115_687 VPWR VGND VPWR VGND sky130_ef_sc_hd__decap_12
X_08973_ net463 net455 net334 net332 VGND VGND VPWR VPWR _01448_ sky130_fd_sc_hd__and4_1
XFILLER_88_527 VGND VGND VPWR VPWR sky130_fd_sc_hd__decap_4
XFILLER_130_679 VPWR VGND VPWR VGND sky130_ef_sc_hd__decap_12
XFILLER_114_197 VGND VGND VPWR VPWR sky130_fd_sc_hd__decap_4
XFILLER_69_741 VPWR VGND VPWR VGND sky130_ef_sc_hd__decap_12
X_07924_ _00399_ _00400_ VGND VGND VPWR VPWR _00402_ sky130_fd_sc_hd__xnor2_2
XFILLER_29_39 VPWR VGND VPWR VGND sky130_ef_sc_hd__decap_12
XFILLER_96_582 VGND VGND VPWR VPWR sky130_fd_sc_hd__decap_6
XFILLER_69_785 VPWR VGND VPWR VGND sky130_ef_sc_hd__decap_12
XFILLER_83_221 VGND VGND VPWR VPWR sky130_fd_sc_hd__decap_3
XFILLER_56_446 VGND VGND VPWR VPWR sky130_fd_sc_hd__fill_2
X_07855_ _00297_ _00332_ VGND VGND VPWR VPWR _00333_ sky130_fd_sc_hd__nand2b_1
XFILLER_28_137 VGND VGND VPWR VPWR sky130_fd_sc_hd__decap_3
XFILLER_83_276 VGND VGND VPWR VPWR sky130_fd_sc_hd__decap_4
X_07786_ _00263_ _00264_ VGND VGND VPWR VPWR _00265_ sky130_fd_sc_hd__nand2b_1
XFILLER_45_27 VPWR VGND VPWR VGND sky130_ef_sc_hd__decap_12
XFILLER_44_619 VGND VGND VPWR VPWR sky130_fd_sc_hd__fill_2
X_09525_ _01879_ _01882_ _01876_ VGND VGND VPWR VPWR _02049_ sky130_fd_sc_hd__a21oi_1
XFILLER_71_438 VGND VGND VPWR VPWR sky130_fd_sc_hd__decap_3
X_09456_ net608 net373 VGND VGND VPWR VPWR _01974_ sky130_fd_sc_hd__nand2_1
XFILLER_52_630 VGND VGND VPWR VPWR sky130_fd_sc_hd__decap_8
X_08407_ _00721_ _00782_ _00781_ VGND VGND VPWR VPWR _00881_ sky130_fd_sc_hd__a21bo_1
XFILLER_24_365 VPWR VGND VPWR VGND sky130_ef_sc_hd__decap_12
X_09387_ _01890_ _01897_ VGND VGND VPWR VPWR _01899_ sky130_fd_sc_hd__xor2_1
XTAP_TAPCELL_ROW_82_1491 VGND VPWR sky130_fd_sc_hd__tapvpwrvgnd_1
XFILLER_138_735 VPWR VGND VPWR VGND sky130_ef_sc_hd__decap_12
XFILLER_138_713 VGND VGND VPWR VPWR sky130_fd_sc_hd__decap_4
X_08338_ _00810_ _00811_ VGND VGND VPWR VPWR _00812_ sky130_fd_sc_hd__nor2_1
XFILLER_138_757 VPWR VGND VPWR VGND sky130_ef_sc_hd__decap_12
X_08269_ _00634_ _00636_ _00743_ VGND VGND VPWR VPWR _00744_ sky130_fd_sc_hd__a21oi_1
XFILLER_137_278 VGND VGND VPWR VPWR sky130_fd_sc_hd__fill_2
XFILLER_125_418 VGND VGND VPWR VPWR sky130_fd_sc_hd__decap_6
X_10300_ net298 _02889_ VGND VGND VPWR VPWR _02890_ sky130_fd_sc_hd__and2_1
X_11280_ net442 net271 VGND VGND VPWR VPWR _03962_ sky130_fd_sc_hd__nand2_1
XFILLER_106_643 VGND VGND VPWR VPWR sky130_fd_sc_hd__fill_1
XFILLER_106_632 VGND VGND VPWR VPWR sky130_fd_sc_hd__decap_4
XFILLER_3_225 VGND VGND VPWR VPWR sky130_fd_sc_hd__decap_8
X_10231_ _02814_ _02815_ VGND VGND VPWR VPWR _02816_ sky130_fd_sc_hd__nor2_1
XFILLER_10_41 VPWR VGND VPWR VGND sky130_ef_sc_hd__decap_12
X_10162_ _02642_ _02645_ VGND VGND VPWR VPWR _02744_ sky130_fd_sc_hd__nor2_1
XFILLER_133_495 VGND VGND VPWR VPWR sky130_fd_sc_hd__decap_8
XFILLER_126_41 VPWR VGND VPWR VGND sky130_ef_sc_hd__decap_12
XFILLER_105_175 VGND VGND VPWR VPWR sky130_fd_sc_hd__fill_1
XFILLER_105_164 VGND VGND VPWR VPWR sky130_fd_sc_hd__decap_4
XFILLER_10_85 VPWR VGND VPWR VGND sky130_ef_sc_hd__decap_12
X_10093_ _02667_ _02668_ VGND VGND VPWR VPWR _02669_ sky130_fd_sc_hd__nand2b_1
XFILLER_126_85 VPWR VGND VPWR VGND sky130_ef_sc_hd__decap_12
XFILLER_120_189 VGND VGND VPWR VPWR sky130_fd_sc_hd__decap_4
XFILLER_59_251 VGND VGND VPWR VPWR sky130_fd_sc_hd__decap_8
XFILLER_75_733 VPWR VGND VPWR VGND sky130_ef_sc_hd__decap_12
XFILLER_90_714 VGND VGND VPWR VPWR sky130_fd_sc_hd__fill_2
XFILLER_74_265 VPWR VGND VPWR VGND sky130_ef_sc_hd__decap_12
XFILLER_47_479 VPWR VGND VPWR VGND sky130_ef_sc_hd__decap_12
X_12803_ _05576_ _05617_ VGND VGND VPWR VPWR _05619_ sky130_fd_sc_hd__xnor2_1
XFILLER_62_438 VPWR VGND VPWR VGND sky130_ef_sc_hd__decap_12
XFILLER_15_310 VGND VGND VPWR VPWR sky130_fd_sc_hd__fill_2
XFILLER_90_769 VPWR VGND VPWR VGND sky130_ef_sc_hd__decap_12
X_12734_ _05542_ _05543_ _05511_ VGND VGND VPWR VPWR _05545_ sky130_fd_sc_hd__a21o_1
XFILLER_55_490 VGND VGND VPWR VPWR sky130_fd_sc_hd__decap_4
X_10995_ _03647_ _03648_ _03632_ VGND VGND VPWR VPWR _03650_ sky130_fd_sc_hd__a21oi_1
XPHY_EDGE_ROW_106_Left_245 VGND VGND VPWR VPWR sky130_fd_sc_hd__decap_3
XFILLER_43_685 VGND VGND VPWR VPWR sky130_fd_sc_hd__decap_4
XFILLER_35_93 VGND VGND VPWR VPWR sky130_fd_sc_hd__fill_2
XFILLER_129_702 VGND VGND VPWR VPWR sky130_fd_sc_hd__fill_1
X_12665_ _05458_ _05468_ VGND VGND VPWR VPWR _05469_ sky130_fd_sc_hd__xnor2_1
X_12596_ _05233_ _05250_ _05248_ VGND VGND VPWR VPWR _05393_ sky130_fd_sc_hd__o21a_1
X_11616_ net248 _04326_ VGND VGND VPWR VPWR _04327_ sky130_fd_sc_hd__nand2b_1
XFILLER_128_223 VGND VGND VPWR VPWR sky130_fd_sc_hd__decap_8
XTAP_TAPCELL_ROW_41_897 VGND VPWR sky130_fd_sc_hd__tapvpwrvgnd_1
X_11547_ _03457_ _04251_ VGND VGND VPWR VPWR _04252_ sky130_fd_sc_hd__xnor2_1
Xmax_cap239 _03970_ VGND VGND VPWR VPWR net239 sky130_fd_sc_hd__buf_1
X_11478_ _04029_ _04176_ VGND VGND VPWR VPWR _04178_ sky130_fd_sc_hd__xnor2_1
XFILLER_124_462 VPWR VGND VPWR VGND sky130_ef_sc_hd__decap_12
XPHY_EDGE_ROW_115_Left_254 VGND VGND VPWR VPWR sky130_fd_sc_hd__decap_3
X_13217_ _06070_ _06034_ VGND VGND VPWR VPWR _06071_ sky130_fd_sc_hd__and2b_1
X_10429_ _02979_ _03031_ VGND VGND VPWR VPWR _03032_ sky130_fd_sc_hd__nor2_1
XFILLER_112_635 VGND VGND VPWR VPWR sky130_fd_sc_hd__decap_4
X_13148_ net338 net601 VGND VGND VPWR VPWR _05997_ sky130_fd_sc_hd__nand2b_1
XFILLER_97_346 VGND VGND VPWR VPWR sky130_fd_sc_hd__decap_4
XTAP_TAPCELL_ROW_127_2137 VGND VPWR sky130_fd_sc_hd__tapvpwrvgnd_1
XFILLER_111_167 VGND VGND VPWR VPWR sky130_fd_sc_hd__fill_1
XFILLER_100_819 VGND VGND VPWR VPWR sky130_fd_sc_hd__fill_1
X_13079_ _05913_ _05918_ VGND VGND VPWR VPWR _05921_ sky130_fd_sc_hd__xnor2_1
XTAP_TAPCELL_ROW_53_1070 VGND VPWR sky130_fd_sc_hd__tapvpwrvgnd_1
XFILLER_25_3 VPWR VGND VPWR VGND sky130_ef_sc_hd__decap_12
XFILLER_38_413 VGND VGND VPWR VPWR sky130_fd_sc_hd__decap_3
XFILLER_93_541 VGND VGND VPWR VPWR sky130_fd_sc_hd__decap_3
XFILLER_66_755 VGND VGND VPWR VPWR sky130_fd_sc_hd__fill_1
XFILLER_65_221 VGND VGND VPWR VPWR sky130_fd_sc_hd__decap_3
X_07640_ _00116_ _00117_ _06700_ _06702_ VGND VGND VPWR VPWR _00120_ sky130_fd_sc_hd__a211o_1
XFILLER_53_405 VPWR VGND VPWR VGND sky130_ef_sc_hd__decap_12
XFILLER_26_608 VPWR VGND VPWR VGND sky130_ef_sc_hd__decap_12
XTAP_TAPCELL_ROW_109_1881 VGND VPWR sky130_fd_sc_hd__tapvpwrvgnd_1
XFILLER_93_585 VGND VGND VPWR VPWR sky130_fd_sc_hd__fill_1
X_07571_ net672 net411 VGND VGND VPWR VPWR _06800_ sky130_fd_sc_hd__and2b_1
XFILLER_53_427 VGND VGND VPWR VPWR sky130_fd_sc_hd__decap_6
XFILLER_18_170 VGND VGND VPWR VPWR sky130_fd_sc_hd__fill_1
XFILLER_19_682 VGND VGND VPWR VPWR sky130_fd_sc_hd__decap_3
XPHY_EDGE_ROW_124_Left_263 VGND VGND VPWR VPWR sky130_fd_sc_hd__decap_3
X_09310_ net620 net372 net370 net630 VGND VGND VPWR VPWR _01816_ sky130_fd_sc_hd__a22o_1
XFILLER_80_257 VGND VGND VPWR VPWR sky130_fd_sc_hd__fill_1
XFILLER_80_246 VGND VGND VPWR VPWR sky130_fd_sc_hd__decap_6
XFILLER_53_449 VPWR VGND VPWR VGND sky130_ef_sc_hd__decap_12
XFILLER_34_630 VGND VGND VPWR VPWR sky130_fd_sc_hd__decap_6
X_09241_ _01718_ _01739_ VGND VGND VPWR VPWR _01740_ sky130_fd_sc_hd__xnor2_1
XFILLER_21_313 VGND VGND VPWR VPWR sky130_fd_sc_hd__decap_4
X_09172_ _01663_ _01664_ VGND VGND VPWR VPWR _01665_ sky130_fd_sc_hd__nand2b_1
XTAP_TAPCELL_ROW_138_2299 VGND VPWR sky130_fd_sc_hd__tapvpwrvgnd_1
X_08123_ net484 net677 net475 net675 VGND VGND VPWR VPWR _00599_ sky130_fd_sc_hd__and4_1
XFILLER_119_256 VGND VGND VPWR VPWR sky130_fd_sc_hd__fill_1
X_08054_ _00524_ _00529_ VGND VGND VPWR VPWR _00531_ sky130_fd_sc_hd__xnor2_1
XPHY_EDGE_ROW_133_Left_272 VGND VGND VPWR VPWR sky130_fd_sc_hd__decap_3
X_07005_ net710 net638 VGND VGND VPWR VPWR _03390_ sky130_fd_sc_hd__and2_1
XFILLER_0_217 VGND VGND VPWR VPWR sky130_fd_sc_hd__decap_6
XFILLER_1_729 VPWR VGND VPWR VGND sky130_ef_sc_hd__decap_12
XFILLER_130_454 VPWR VGND VPWR VGND sky130_ef_sc_hd__decap_12
XFILLER_130_421 VPWR VGND VPWR VGND sky130_ef_sc_hd__decap_12
XFILLER_103_657 VPWR VGND VPWR VGND sky130_ef_sc_hd__decap_12
XFILLER_102_123 VGND VGND VPWR VPWR sky130_fd_sc_hd__decap_8
XFILLER_88_357 VGND VGND VPWR VPWR sky130_fd_sc_hd__decap_4
Xinput118 w32[4] VGND VGND VPWR VPWR net118 sky130_fd_sc_hd__clkbuf_2
XFILLER_0_239 VGND VGND VPWR VPWR sky130_fd_sc_hd__fill_2
Xinput107 w31[1] VGND VGND VPWR VPWR net107 sky130_fd_sc_hd__clkbuf_1
X_08956_ _01285_ _01428_ VGND VGND VPWR VPWR _01429_ sky130_fd_sc_hd__nor2_1
XFILLER_102_156 VPWR VGND VPWR VGND sky130_ef_sc_hd__decap_12
Xinput129 w33[7] VGND VGND VPWR VPWR net129 sky130_fd_sc_hd__buf_1
X_08887_ _01350_ _01352_ _01222_ _01225_ VGND VGND VPWR VPWR _01354_ sky130_fd_sc_hd__o211a_1
X_07907_ net708 net602 VGND VGND VPWR VPWR _00385_ sky130_fd_sc_hd__nand2_1
XFILLER_56_221 VGND VGND VPWR VPWR sky130_fd_sc_hd__decap_8
XFILLER_56_15 VPWR VGND VPWR VGND sky130_ef_sc_hd__decap_12
X_07838_ _00160_ _00314_ VGND VGND VPWR VPWR _00316_ sky130_fd_sc_hd__xnor2_2
XTAP_TAPCELL_ROW_84_1520 VGND VPWR sky130_fd_sc_hd__tapvpwrvgnd_1
XFILLER_72_725 VPWR VGND VPWR VGND sky130_ef_sc_hd__decap_12
X_09508_ _02028_ _02029_ VGND VGND VPWR VPWR _02031_ sky130_fd_sc_hd__nor2_1
XFILLER_112_65 VPWR VGND VPWR VGND sky130_ef_sc_hd__decap_12
XFILLER_72_769 VPWR VGND VPWR VGND sky130_ef_sc_hd__decap_12
XFILLER_71_246 VPWR VGND VPWR VGND sky130_ef_sc_hd__decap_12
X_07769_ _06659_ _00247_ VGND VGND VPWR VPWR _00248_ sky130_fd_sc_hd__nor2_1
XFILLER_37_490 VGND VGND VPWR VPWR sky130_fd_sc_hd__decap_3
XFILLER_80_780 VPWR VGND VPWR VGND sky130_ef_sc_hd__decap_12
X_10780_ _02951_ _03123_ _03271_ _03274_ VGND VGND VPWR VPWR _03415_ sky130_fd_sc_hd__a31o_1
X_09439_ _01953_ _01955_ VGND VGND VPWR VPWR _01956_ sky130_fd_sc_hd__nand2b_1
X_12450_ net573 net565 net577 net501 VGND VGND VPWR VPWR _05234_ sky130_fd_sc_hd__and4_1
X_11401_ _03934_ _03942_ _03941_ VGND VGND VPWR VPWR _04094_ sky130_fd_sc_hd__a21oi_1
XFILLER_138_587 VGND VGND VPWR VPWR sky130_fd_sc_hd__fill_1
X_12381_ _05154_ _05156_ _05157_ VGND VGND VPWR VPWR _05159_ sky130_fd_sc_hd__a21o_1
XFILLER_125_237 VPWR VGND VPWR VGND sky130_ef_sc_hd__decap_12
X_11332_ _04016_ _04017_ VGND VGND VPWR VPWR _04019_ sky130_fd_sc_hd__xnor2_1
XFILLER_21_51 VGND VGND VPWR VPWR sky130_fd_sc_hd__decap_4
XFILLER_137_51 VGND VGND VPWR VPWR sky130_fd_sc_hd__decap_4
XTAP_TAPCELL_ROW_95_1682 VGND VPWR sky130_fd_sc_hd__tapvpwrvgnd_1
XTAP_TAPCELL_ROW_95_1671 VGND VPWR sky130_fd_sc_hd__tapvpwrvgnd_1
X_11263_ _03934_ _03942_ VGND VGND VPWR VPWR _03943_ sky130_fd_sc_hd__xnor2_1
XFILLER_21_95 VGND VGND VPWR VPWR sky130_fd_sc_hd__decap_8
XFILLER_134_793 VPWR VGND VPWR VGND sky130_ef_sc_hd__decap_12
XFILLER_97_33 VPWR VGND VPWR VGND sky130_ef_sc_hd__decap_12
XFILLER_79_313 VGND VGND VPWR VPWR sky130_fd_sc_hd__fill_2
X_13002_ _05835_ _05836_ VGND VGND VPWR VPWR _05837_ sky130_fd_sc_hd__xnor2_1
X_11194_ _03704_ _03706_ _03867_ VGND VGND VPWR VPWR _03868_ sky130_fd_sc_hd__and3_1
XFILLER_4_589 VGND VGND VPWR VPWR sky130_fd_sc_hd__decap_4
XFILLER_4_578 VGND VGND VPWR VPWR sky130_fd_sc_hd__decap_8
X_10214_ net527 net298 VGND VGND VPWR VPWR _02798_ sky130_fd_sc_hd__nand2_1
XFILLER_133_281 VGND VGND VPWR VPWR sky130_fd_sc_hd__decap_6
X_10145_ _02721_ _02724_ VGND VGND VPWR VPWR _02725_ sky130_fd_sc_hd__and2_1
XFILLER_79_335 VGND VGND VPWR VPWR sky130_fd_sc_hd__fill_1
XFILLER_79_379 VGND VGND VPWR VPWR sky130_fd_sc_hd__fill_1
X_10076_ net250 _02649_ VGND VGND VPWR VPWR _02650_ sky130_fd_sc_hd__nand2_1
XFILLER_48_722 VGND VGND VPWR VPWR sky130_fd_sc_hd__decap_4
XTAP_TAPCELL_ROW_7_394 VGND VPWR sky130_fd_sc_hd__tapvpwrvgnd_1
XFILLER_90_533 VGND VGND VPWR VPWR sky130_fd_sc_hd__decap_8
XFILLER_75_585 VPWR VGND VPWR VGND sky130_ef_sc_hd__decap_12
XFILLER_62_224 VGND VGND VPWR VPWR sky130_fd_sc_hd__fill_1
XFILLER_35_416 VGND VGND VPWR VPWR sky130_fd_sc_hd__fill_2
XTAP_TAPCELL_ROW_122_2067 VGND VPWR sky130_fd_sc_hd__tapvpwrvgnd_1
XTAP_TAPCELL_ROW_46_967 VGND VPWR sky130_fd_sc_hd__tapvpwrvgnd_1
XFILLER_43_460 VGND VGND VPWR VPWR sky130_fd_sc_hd__fill_1
X_10978_ _03307_ _03485_ _03484_ VGND VGND VPWR VPWR _03632_ sky130_fd_sc_hd__a21o_1
X_12717_ _05524_ _05525_ VGND VGND VPWR VPWR _05526_ sky130_fd_sc_hd__xnor2_1
X_13697_ clknet_3_3__leaf_clk _00043_ net713 VGND VGND VPWR VPWR net216 sky130_fd_sc_hd__dfrtp_1
XTAP_TAPCELL_ROW_26_680 VGND VPWR sky130_fd_sc_hd__tapvpwrvgnd_1
XFILLER_30_110 VGND VGND VPWR VPWR sky130_fd_sc_hd__decap_4
XFILLER_31_633 VPWR VGND VPWR VGND sky130_ef_sc_hd__decap_12
X_12648_ _05398_ _05449_ VGND VGND VPWR VPWR _05451_ sky130_fd_sc_hd__xnor2_1
XFILLER_117_705 VPWR VGND VPWR VGND sky130_ef_sc_hd__decap_12
X_12579_ _05373_ _05375_ VGND VGND VPWR VPWR _05376_ sky130_fd_sc_hd__nand2b_1
XFILLER_116_259 VPWR VGND VPWR VGND sky130_ef_sc_hd__decap_12
X_08810_ net508 net350 net53 net517 VGND VGND VPWR VPWR _01276_ sky130_fd_sc_hd__a22o_1
XFILLER_112_421 VPWR VGND VPWR VGND sky130_ef_sc_hd__decap_12
XFILLER_97_132 VPWR VGND VPWR VGND sky130_ef_sc_hd__decap_12
X_09790_ _02337_ _02338_ VGND VGND VPWR VPWR _02339_ sky130_fd_sc_hd__nand2_1
X_08741_ _01196_ _01204_ _01039_ VGND VGND VPWR VPWR _01208_ sky130_fd_sc_hd__a21o_1
XFILLER_66_530 VGND VGND VPWR VPWR sky130_fd_sc_hd__fill_2
X_08672_ net350 _01018_ _01084_ _01088_ VGND VGND VPWR VPWR _01139_ sky130_fd_sc_hd__o31ai_1
XFILLER_39_777 VGND VGND VPWR VPWR sky130_fd_sc_hd__decap_6
XFILLER_93_382 VGND VGND VPWR VPWR sky130_fd_sc_hd__decap_8
X_07623_ net650 net644 net105 VGND VGND VPWR VPWR _00103_ sky130_fd_sc_hd__and3_1
XFILLER_54_747 VGND VGND VPWR VPWR sky130_fd_sc_hd__decap_8
XFILLER_26_29 VPWR VGND VPWR VGND sky130_ef_sc_hd__decap_12
XFILLER_38_265 VGND VGND VPWR VPWR sky130_fd_sc_hd__decap_8
XFILLER_81_533 VPWR VGND VPWR VGND sky130_ef_sc_hd__decap_12
XPHY_EDGE_ROW_5_Right_5 VGND VGND VPWR VPWR sky130_fd_sc_hd__decap_3
XFILLER_81_588 VGND VGND VPWR VPWR sky130_fd_sc_hd__fill_2
XTAP_TAPCELL_ROW_66_1261 VGND VPWR sky130_fd_sc_hd__tapvpwrvgnd_1
XTAP_TAPCELL_ROW_66_1250 VGND VPWR sky130_fd_sc_hd__tapvpwrvgnd_1
X_07554_ _06657_ _06676_ _06675_ VGND VGND VPWR VPWR _06783_ sky130_fd_sc_hd__a21oi_1
X_07485_ _06713_ _06714_ VGND VGND VPWR VPWR _06715_ sky130_fd_sc_hd__nor2_1
X_09224_ net506 net54 _01574_ _01572_ VGND VGND VPWR VPWR _01721_ sky130_fd_sc_hd__a31o_1
XFILLER_22_666 VPWR VGND VPWR VGND sky130_ef_sc_hd__decap_12
XFILLER_22_699 VGND VGND VPWR VPWR sky130_fd_sc_hd__fill_1
X_09155_ _01643_ _01644_ net648 net40 VGND VGND VPWR VPWR _01646_ sky130_fd_sc_hd__and4bb_1
XFILLER_135_546 VPWR VGND VPWR VGND sky130_ef_sc_hd__decap_12
X_09086_ _01439_ _01460_ _01458_ VGND VGND VPWR VPWR _01571_ sky130_fd_sc_hd__a21o_1
X_08106_ net251 _00581_ VGND VGND VPWR VPWR _00582_ sky130_fd_sc_hd__or2_1
X_08037_ net627 net618 net704 VGND VGND VPWR VPWR _00514_ sky130_fd_sc_hd__and3_1
XFILLER_116_793 VPWR VGND VPWR VGND sky130_ef_sc_hd__decap_12
XFILLER_89_611 VGND VGND VPWR VPWR sky130_fd_sc_hd__decap_4
XFILLER_115_281 VGND VGND VPWR VPWR sky130_fd_sc_hd__decap_8
XFILLER_1_559 VGND VGND VPWR VPWR sky130_fd_sc_hd__fill_1
XFILLER_131_785 VPWR VGND VPWR VGND sky130_ef_sc_hd__decap_12
X_09988_ _02526_ _02553_ VGND VGND VPWR VPWR _02555_ sky130_fd_sc_hd__xor2_1
X_08939_ _01408_ _01410_ VGND VGND VPWR VPWR _01411_ sky130_fd_sc_hd__or2_1
XFILLER_69_390 VGND VGND VPWR VPWR sky130_fd_sc_hd__fill_2
XFILLER_67_69 VGND VGND VPWR VPWR sky130_fd_sc_hd__decap_4
X_11950_ _04687_ _04688_ VGND VGND VPWR VPWR _04689_ sky130_fd_sc_hd__or2_1
XTAP_TAPCELL_ROW_4_364 VGND VPWR sky130_fd_sc_hd__tapvpwrvgnd_1
XTAP_TAPCELL_ROW_4_353 VGND VPWR sky130_fd_sc_hd__tapvpwrvgnd_1
XFILLER_29_243 VPWR VGND VPWR VGND sky130_ef_sc_hd__decap_12
XFILLER_44_202 VPWR VGND VPWR VGND sky130_ef_sc_hd__decap_12
X_10901_ net263 net311 _03365_ VGND VGND VPWR VPWR _03547_ sky130_fd_sc_hd__nor3_1
XFILLER_83_57 VPWR VGND VPWR VGND sky130_ef_sc_hd__decap_12
XFILLER_72_533 VGND VGND VPWR VPWR sky130_fd_sc_hd__decap_8
XFILLER_44_246 VGND VGND VPWR VPWR sky130_fd_sc_hd__decap_6
X_11881_ _04616_ _04615_ VGND VGND VPWR VPWR _04617_ sky130_fd_sc_hd__nand2b_1
XFILLER_17_449 VGND VGND VPWR VPWR sky130_fd_sc_hd__decap_3
X_13620_ _06444_ _06445_ _06457_ _06456_ VGND VGND VPWR VPWR _06511_ sky130_fd_sc_hd__a31oi_1
XFILLER_72_599 VGND VGND VPWR VPWR sky130_fd_sc_hd__fill_1
XFILLER_44_257 VGND VGND VPWR VPWR sky130_fd_sc_hd__decap_4
XTAP_TAPCELL_ROW_43_926 VGND VPWR sky130_fd_sc_hd__tapvpwrvgnd_1
X_10832_ _03468_ _03469_ _03470_ VGND VGND VPWR VPWR _03472_ sky130_fd_sc_hd__a21oi_1
XFILLER_32_408 VPWR VGND VPWR VGND sky130_ef_sc_hd__decap_12
X_13551_ _06425_ _06435_ VGND VGND VPWR VPWR _06436_ sky130_fd_sc_hd__nand2b_1
X_10763_ _03394_ _03395_ VGND VGND VPWR VPWR _03396_ sky130_fd_sc_hd__or2_1
X_12502_ _05288_ _05289_ VGND VGND VPWR VPWR _05291_ sky130_fd_sc_hd__or2_1
XFILLER_9_615 VGND VGND VPWR VPWR sky130_fd_sc_hd__fill_1
XFILLER_8_103 VGND VGND VPWR VPWR sky130_fd_sc_hd__decap_3
X_13482_ net533 net539 net408 VGND VGND VPWR VPWR _06361_ sky130_fd_sc_hd__mux2_1
XTAP_TAPCELL_ROW_97_1700 VGND VPWR sky130_fd_sc_hd__tapvpwrvgnd_1
XFILLER_12_165 VPWR VGND VPWR VGND sky130_ef_sc_hd__decap_12
X_10694_ _03318_ _03319_ _03317_ VGND VGND VPWR VPWR _03321_ sky130_fd_sc_hd__o21ai_1
XFILLER_138_362 VGND VGND VPWR VPWR sky130_fd_sc_hd__fill_2
XTAP_TAPCELL_ROW_97_1711 VGND VPWR sky130_fd_sc_hd__tapvpwrvgnd_1
X_12433_ _04925_ _05064_ _05213_ _05214_ VGND VGND VPWR VPWR _05216_ sky130_fd_sc_hd__a22o_1
XFILLER_32_83 VGND VGND VPWR VPWR sky130_fd_sc_hd__fill_1
X_12364_ _05113_ _05139_ VGND VGND VPWR VPWR _05140_ sky130_fd_sc_hd__and2b_1
XFILLER_5_821 VGND VGND VPWR VPWR sky130_fd_sc_hd__decap_3
X_11315_ _03997_ _03998_ VGND VGND VPWR VPWR _04000_ sky130_fd_sc_hd__xnor2_1
X_12295_ _04927_ _04930_ _04932_ _04925_ VGND VGND VPWR VPWR _05065_ sky130_fd_sc_hd__a31oi_1
X_11246_ net257 net293 _03921_ _03922_ VGND VGND VPWR VPWR _03924_ sky130_fd_sc_hd__nor4_1
XFILLER_79_143 VGND VGND VPWR VPWR sky130_fd_sc_hd__fill_1
X_11177_ _03819_ _03848_ VGND VGND VPWR VPWR _03849_ sky130_fd_sc_hd__xnor2_1
X_10128_ _02609_ _02704_ VGND VGND VPWR VPWR _02707_ sky130_fd_sc_hd__xor2_1
X_10059_ _02631_ _02629_ VGND VGND VPWR VPWR _02632_ sky130_fd_sc_hd__and2b_1
XFILLER_48_552 VGND VGND VPWR VPWR sky130_fd_sc_hd__fill_2
XTAP_TAPCELL_ROW_106_1840 VGND VPWR sky130_fd_sc_hd__tapvpwrvgnd_1
XFILLER_75_393 VGND VGND VPWR VPWR sky130_fd_sc_hd__fill_2
XFILLER_35_235 VPWR VGND VPWR VGND sky130_ef_sc_hd__decap_12
XFILLER_36_769 VPWR VGND VPWR VGND sky130_ef_sc_hd__decap_12
XFILLER_90_363 VGND VGND VPWR VPWR sky130_fd_sc_hd__fill_1
XFILLER_35_268 VPWR VGND VPWR VGND sky130_ef_sc_hd__decap_12
XFILLER_50_249 VGND VGND VPWR VPWR sky130_fd_sc_hd__decap_3
XFILLER_92_3 VPWR VGND VPWR VGND sky130_ef_sc_hd__decap_12
X_07270_ _05974_ _06258_ VGND VGND VPWR VPWR _06280_ sky130_fd_sc_hd__and2_1
XTAP_TAPCELL_ROW_21_609 VGND VPWR sky130_fd_sc_hd__tapvpwrvgnd_1
XTAP_TAPCELL_ROW_61_1180 VGND VPWR sky130_fd_sc_hd__tapvpwrvgnd_1
XTAP_TAPCELL_ROW_135_2258 VGND VPWR sky130_fd_sc_hd__tapvpwrvgnd_1
XFILLER_8_670 VGND VGND VPWR VPWR sky130_fd_sc_hd__decap_4
X_09911_ _02468_ _02469_ VGND VGND VPWR VPWR _02470_ sky130_fd_sc_hd__and2b_1
XFILLER_132_505 VGND VGND VPWR VPWR sky130_fd_sc_hd__fill_1
XTAP_TAPCELL_ROW_117_1991 VGND VPWR sky130_fd_sc_hd__tapvpwrvgnd_1
Xfanout605 net136 VGND VGND VPWR VPWR net605 sky130_fd_sc_hd__buf_2
XFILLER_113_785 VPWR VGND VPWR VGND sky130_ef_sc_hd__decap_12
XFILLER_113_763 VPWR VGND VPWR VGND sky130_ef_sc_hd__decap_12
XFILLER_112_251 VGND VGND VPWR VPWR sky130_fd_sc_hd__fill_1
Xfanout616 net617 VGND VGND VPWR VPWR net616 sky130_fd_sc_hd__buf_1
X_09842_ _02285_ _02286_ _02288_ VGND VGND VPWR VPWR _02396_ sky130_fd_sc_hd__o21bai_1
Xfanout638 net641 VGND VGND VPWR VPWR net638 sky130_fd_sc_hd__buf_4
Xfanout627 net635 VGND VGND VPWR VPWR net627 sky130_fd_sc_hd__buf_2
XFILLER_58_305 VGND VGND VPWR VPWR sky130_fd_sc_hd__decap_3
Xfanout649 net131 VGND VGND VPWR VPWR net649 sky130_fd_sc_hd__buf_8
X_09773_ _02044_ _02203_ _02201_ VGND VGND VPWR VPWR _02320_ sky130_fd_sc_hd__a21oi_1
XFILLER_112_273 VPWR VGND VPWR VGND sky130_ef_sc_hd__decap_12
XFILLER_85_113 VPWR VGND VPWR VGND sky130_ef_sc_hd__decap_12
X_08724_ net473 net333 _01188_ _01189_ VGND VGND VPWR VPWR _01191_ sky130_fd_sc_hd__a22o_1
XFILLER_86_669 VGND VGND VPWR VPWR sky130_fd_sc_hd__fill_1
X_06985_ _03150_ _03161_ VGND VGND VPWR VPWR _03172_ sky130_fd_sc_hd__and2b_1
XFILLER_37_39 VPWR VGND VPWR VGND sky130_ef_sc_hd__decap_12
XTAP_TAPCELL_ROW_1_312 VGND VPWR sky130_fd_sc_hd__tapvpwrvgnd_1
X_08655_ net566 net42 _01121_ VGND VGND VPWR VPWR _01122_ sky130_fd_sc_hd__nand3_1
XFILLER_66_393 VGND VGND VPWR VPWR sky130_fd_sc_hd__decap_3
X_08586_ _01051_ _01052_ VGND VGND VPWR VPWR _01054_ sky130_fd_sc_hd__xnor2_1
X_07606_ _00083_ _00084_ _00069_ VGND VGND VPWR VPWR _00086_ sky130_fd_sc_hd__a21o_1
XFILLER_53_27 VPWR VGND VPWR VGND sky130_ef_sc_hd__decap_12
XFILLER_42_717 VGND VGND VPWR VPWR sky130_fd_sc_hd__fill_1
XFILLER_14_408 VGND VGND VPWR VPWR sky130_fd_sc_hd__decap_8
XFILLER_26_279 VGND VGND VPWR VPWR sky130_fd_sc_hd__fill_1
X_07537_ _06763_ _06764_ VGND VGND VPWR VPWR _06766_ sky130_fd_sc_hd__xor2_1
XFILLER_41_238 VPWR VGND VPWR VGND sky130_ef_sc_hd__decap_12
X_07468_ _06691_ _06697_ VGND VGND VPWR VPWR _06698_ sky130_fd_sc_hd__xnor2_1
XFILLER_10_614 VGND VGND VPWR VPWR sky130_fd_sc_hd__fill_2
XFILLER_22_463 VGND VGND VPWR VPWR sky130_fd_sc_hd__decap_3
XFILLER_22_474 VGND VGND VPWR VPWR sky130_fd_sc_hd__fill_2
X_09207_ net564 net555 net358 VGND VGND VPWR VPWR _01702_ sky130_fd_sc_hd__and3_1
XFILLER_136_811 VGND VGND VPWR VPWR sky130_fd_sc_hd__fill_1
X_07399_ net672 net416 VGND VGND VPWR VPWR _06629_ sky130_fd_sc_hd__nand2_1
XFILLER_22_496 VPWR VGND VPWR VGND sky130_ef_sc_hd__decap_12
X_09138_ _01625_ _01626_ VGND VGND VPWR VPWR _01628_ sky130_fd_sc_hd__nor2_1
XFILLER_108_524 VGND VGND VPWR VPWR sky130_fd_sc_hd__decap_4
XTAP_TAPCELL_ROW_79_1441 VGND VPWR sky130_fd_sc_hd__tapvpwrvgnd_1
XFILLER_123_505 VGND VGND VPWR VPWR sky130_fd_sc_hd__decap_3
X_09069_ net490 net349 net348 net498 VGND VGND VPWR VPWR _01553_ sky130_fd_sc_hd__a22o_1
XFILLER_118_53 VPWR VGND VPWR VGND sky130_ef_sc_hd__decap_12
XTAP_TAPCELL_ROW_92_1630 VGND VPWR sky130_fd_sc_hd__tapvpwrvgnd_1
XTAP_TAPCELL_ROW_9_434 VGND VPWR sky130_fd_sc_hd__tapvpwrvgnd_1
XTAP_TAPCELL_ROW_9_423 VGND VPWR sky130_fd_sc_hd__tapvpwrvgnd_1
XFILLER_2_813 VGND VGND VPWR VPWR sky130_fd_sc_hd__decap_8
X_11100_ net483 net474 net291 net293 VGND VGND VPWR VPWR _03765_ sky130_fd_sc_hd__and4_1
X_12080_ net454 net390 net388 net462 VGND VGND VPWR VPWR _04830_ sky130_fd_sc_hd__a22o_1
XFILLER_1_356 VGND VGND VPWR VPWR sky130_fd_sc_hd__fill_2
X_11031_ _03629_ _03688_ _03689_ VGND VGND VPWR VPWR _03690_ sky130_fd_sc_hd__nor3_1
XFILLER_134_41 VPWR VGND VPWR VGND sky130_ef_sc_hd__decap_12
XFILLER_131_571 VPWR VGND VPWR VGND sky130_ef_sc_hd__decap_12
XFILLER_76_124 VGND VGND VPWR VPWR sky130_fd_sc_hd__fill_1
XFILLER_49_327 VGND VGND VPWR VPWR sky130_fd_sc_hd__decap_8
XFILLER_134_85 VPWR VGND VPWR VGND sky130_ef_sc_hd__decap_12
XFILLER_65_809 VGND VGND VPWR VPWR sky130_fd_sc_hd__decap_8
XFILLER_92_628 VPWR VGND VPWR VGND sky130_ef_sc_hd__decap_12
XFILLER_76_168 VPWR VGND VPWR VGND sky130_ef_sc_hd__decap_12
X_12982_ _05678_ _05687_ _05686_ VGND VGND VPWR VPWR _05815_ sky130_fd_sc_hd__a21oi_1
XFILLER_18_736 VGND VGND VPWR VPWR sky130_fd_sc_hd__decap_3
XFILLER_91_138 VGND VGND VPWR VPWR sky130_fd_sc_hd__fill_1
X_11933_ _04669_ _04670_ VGND VGND VPWR VPWR _00003_ sky130_fd_sc_hd__and2_1
XFILLER_57_393 VGND VGND VPWR VPWR sky130_fd_sc_hd__decap_6
XFILLER_18_769 VPWR VGND VPWR VGND sky130_ef_sc_hd__decap_12
XFILLER_27_61 VGND VGND VPWR VPWR sky130_fd_sc_hd__fill_1
XFILLER_72_363 VGND VGND VPWR VPWR sky130_fd_sc_hd__fill_1
X_11864_ _04576_ _04597_ VGND VGND VPWR VPWR _04598_ sky130_fd_sc_hd__and2b_1
XFILLER_27_94 VPWR VGND VPWR VGND sky130_ef_sc_hd__decap_12
X_13603_ _06428_ _06491_ VGND VGND VPWR VPWR _06492_ sky130_fd_sc_hd__xnor2_1
XFILLER_72_396 VGND VGND VPWR VPWR sky130_fd_sc_hd__fill_2
X_10815_ _03296_ _03298_ VGND VGND VPWR VPWR _03453_ sky130_fd_sc_hd__and2_1
XFILLER_32_216 VGND VGND VPWR VPWR sky130_fd_sc_hd__fill_1
XFILLER_32_227 VPWR VGND VPWR VGND sky130_ef_sc_hd__decap_12
X_11795_ _04521_ _04522_ VGND VGND VPWR VPWR _04523_ sky130_fd_sc_hd__nand2_1
XTAP_TAPCELL_ROW_101_1770 VGND VPWR sky130_fd_sc_hd__tapvpwrvgnd_1
X_13534_ _06239_ _06416_ VGND VGND VPWR VPWR _06417_ sky130_fd_sc_hd__xor2_1
XFILLER_43_93 VPWR VGND VPWR VGND sky130_ef_sc_hd__decap_12
X_10746_ net298 net153 VGND VGND VPWR VPWR _03377_ sky130_fd_sc_hd__and2b_1
X_13465_ _05476_ _06262_ _06263_ VGND VGND VPWR VPWR _06342_ sky130_fd_sc_hd__o21ba_1
XFILLER_9_467 VGND VGND VPWR VPWR sky130_fd_sc_hd__fill_1
X_10677_ _03300_ _03301_ VGND VGND VPWR VPWR _03302_ sky130_fd_sc_hd__nor2_1
X_12416_ _05165_ _05195_ _05196_ VGND VGND VPWR VPWR _05197_ sky130_fd_sc_hd__nand3_1
XFILLER_138_181 VPWR VGND VPWR VGND sky130_ef_sc_hd__decap_12
XFILLER_126_332 VGND VGND VPWR VPWR sky130_fd_sc_hd__fill_1
X_13396_ _06260_ _06266_ VGND VGND VPWR VPWR _06267_ sky130_fd_sc_hd__nand2_1
XFILLER_64_7 VPWR VGND VPWR VGND sky130_ef_sc_hd__decap_12
Xoutput208 net208 VGND VGND VPWR VPWR y2[5] sky130_fd_sc_hd__buf_2
X_12347_ _05117_ _05119_ _05120_ VGND VGND VPWR VPWR _05121_ sky130_fd_sc_hd__nand3b_1
Xoutput219 net219 VGND VGND VPWR VPWR y3[15] sky130_fd_sc_hd__buf_2
XTAP_TAPCELL_ROW_130_2177 VGND VPWR sky130_fd_sc_hd__tapvpwrvgnd_1
XFILLER_99_249 VGND VGND VPWR VPWR sky130_fd_sc_hd__decap_8
X_12278_ _05043_ _05044_ _05015_ VGND VGND VPWR VPWR _05047_ sky130_fd_sc_hd__o21a_4
XFILLER_4_183 VGND VGND VPWR VPWR sky130_fd_sc_hd__fill_1
XTAP_TAPCELL_ROW_130_2188 VGND VPWR sky130_fd_sc_hd__tapvpwrvgnd_1
XFILLER_68_603 VPWR VGND VPWR VGND sky130_ef_sc_hd__decap_12
XFILLER_4_65 VPWR VGND VPWR VGND sky130_ef_sc_hd__decap_12
X_11229_ net248 _03905_ VGND VGND VPWR VPWR _03906_ sky130_fd_sc_hd__xor2_1
XFILLER_110_755 VGND VGND VPWR VPWR sky130_fd_sc_hd__fill_1
XFILLER_95_466 VGND VGND VPWR VPWR sky130_fd_sc_hd__fill_1
XFILLER_68_669 VPWR VGND VPWR VGND sky130_ef_sc_hd__decap_12
XFILLER_95_499 VGND VGND VPWR VPWR sky130_fd_sc_hd__decap_4
XFILLER_83_617 VGND VGND VPWR VPWR sky130_fd_sc_hd__decap_3
XFILLER_82_105 VGND VGND VPWR VPWR sky130_fd_sc_hd__fill_1
XFILLER_55_319 VGND VGND VPWR VPWR sky130_fd_sc_hd__fill_2
XFILLER_36_533 VGND VGND VPWR VPWR sky130_fd_sc_hd__decap_4
XFILLER_91_661 VGND VGND VPWR VPWR sky130_fd_sc_hd__fill_2
X_08440_ _00828_ _00830_ _00835_ _00834_ VGND VGND VPWR VPWR _00913_ sky130_fd_sc_hd__nor4b_1
XFILLER_51_503 VGND VGND VPWR VPWR sky130_fd_sc_hd__fill_1
XFILLER_24_728 VGND VGND VPWR VPWR sky130_fd_sc_hd__decap_6
XFILLER_90_160 VGND VGND VPWR VPWR sky130_fd_sc_hd__fill_1
XFILLER_51_525 VGND VGND VPWR VPWR sky130_fd_sc_hd__decap_6
XFILLER_36_599 VGND VGND VPWR VPWR sky130_fd_sc_hd__fill_1
X_08371_ _00822_ _00843_ VGND VGND VPWR VPWR _00845_ sky130_fd_sc_hd__xor2_1
X_07322_ _06550_ _06551_ _06519_ VGND VGND VPWR VPWR _06553_ sky130_fd_sc_hd__a21o_1
XTAP_TAPCELL_ROW_34_789 VGND VPWR sky130_fd_sc_hd__tapvpwrvgnd_1
XFILLER_137_608 VGND VGND VPWR VPWR sky130_fd_sc_hd__decap_8
X_07253_ _04580_ _04602_ _04591_ VGND VGND VPWR VPWR _06094_ sky130_fd_sc_hd__o21bai_1
XFILLER_118_811 VGND VGND VPWR VPWR sky130_fd_sc_hd__fill_1
X_07184_ _04816_ _05308_ _05319_ VGND VGND VPWR VPWR _05341_ sky130_fd_sc_hd__or3_1
XFILLER_2_109 VPWR VGND VPWR VGND sky130_ef_sc_hd__decap_12
XFILLER_132_335 VPWR VGND VPWR VGND sky130_ef_sc_hd__decap_12
Xfanout413 net414 VGND VGND VPWR VPWR net413 sky130_fd_sc_hd__buf_2
XFILLER_99_772 VPWR VGND VPWR VGND sky130_ef_sc_hd__decap_12
Xfanout402 net20 VGND VGND VPWR VPWR net402 sky130_fd_sc_hd__buf_2
XTAP_TAPCELL_ROW_74_1371 VGND VPWR sky130_fd_sc_hd__tapvpwrvgnd_1
X_09825_ _02372_ _02376_ VGND VGND VPWR VPWR _02377_ sky130_fd_sc_hd__and2b_1
XFILLER_98_271 VPWR VGND VPWR VGND sky130_ef_sc_hd__decap_12
Xfanout446 net448 VGND VGND VPWR VPWR net446 sky130_fd_sc_hd__clkbuf_4
XFILLER_59_636 VGND VGND VPWR VPWR sky130_fd_sc_hd__decap_4
Xfanout435 net441 VGND VGND VPWR VPWR net435 sky130_fd_sc_hd__clkbuf_4
XFILLER_48_27 VGND VGND VPWR VPWR sky130_fd_sc_hd__fill_1
Xfanout424 net427 VGND VGND VPWR VPWR net424 sky130_fd_sc_hd__buf_2
Xfanout457 net460 VGND VGND VPWR VPWR net457 sky130_fd_sc_hd__clkbuf_4
Xfanout479 net482 VGND VGND VPWR VPWR net479 sky130_fd_sc_hd__dlymetal6s2s_1
XFILLER_101_755 VPWR VGND VPWR VGND sky130_ef_sc_hd__decap_12
XFILLER_100_232 VGND VGND VPWR VPWR sky130_fd_sc_hd__fill_1
XFILLER_47_809 VGND VGND VPWR VPWR sky130_fd_sc_hd__decap_4
Xfanout468 net469 VGND VGND VPWR VPWR net468 sky130_fd_sc_hd__clkbuf_2
X_09756_ _02257_ _02301_ VGND VGND VPWR VPWR _02302_ sky130_fd_sc_hd__xnor2_2
XFILLER_100_265 VGND VGND VPWR VPWR sky130_fd_sc_hd__decap_3
XFILLER_86_499 VGND VGND VPWR VPWR sky130_fd_sc_hd__fill_2
XFILLER_86_477 VGND VGND VPWR VPWR sky130_fd_sc_hd__fill_1
XFILLER_74_617 VGND VGND VPWR VPWR sky130_fd_sc_hd__decap_8
X_06968_ _02445_ _02964_ VGND VGND VPWR VPWR _02986_ sky130_fd_sc_hd__nor2_1
XFILLER_27_500 VGND VGND VPWR VPWR sky130_fd_sc_hd__decap_4
X_09687_ net488 net479 net346 net344 VGND VGND VPWR VPWR _02226_ sky130_fd_sc_hd__and4_1
XFILLER_104_88 VGND VGND VPWR VPWR sky130_fd_sc_hd__fill_1
XFILLER_104_77 VGND VGND VPWR VPWR sky130_fd_sc_hd__decap_6
X_08707_ _01171_ _01172_ _01173_ VGND VGND VPWR VPWR _01174_ sky130_fd_sc_hd__nand3_1
XFILLER_39_393 VGND VGND VPWR VPWR sky130_fd_sc_hd__fill_1
X_08638_ net575 net365 _01103_ _01101_ VGND VGND VPWR VPWR _01105_ sky130_fd_sc_hd__a31o_1
X_06899_ _01769_ _02227_ VGND VGND VPWR VPWR _02238_ sky130_fd_sc_hd__nand2b_1
XFILLER_54_374 VGND VGND VPWR VPWR sky130_fd_sc_hd__decap_6
XFILLER_120_65 VPWR VGND VPWR VGND sky130_ef_sc_hd__decap_12
X_08569_ _01006_ _01035_ VGND VGND VPWR VPWR _01037_ sky130_fd_sc_hd__xor2_1
XFILLER_42_569 VPWR VGND VPWR VGND sky130_ef_sc_hd__decap_12
X_11580_ _04026_ _04154_ _04153_ VGND VGND VPWR VPWR _04289_ sky130_fd_sc_hd__a21oi_1
X_10600_ _03214_ _03216_ VGND VGND VPWR VPWR _03218_ sky130_fd_sc_hd__xnor2_1
X_10531_ net443 net282 _02965_ _02963_ VGND VGND VPWR VPWR _03143_ sky130_fd_sc_hd__a31o_1
X_13250_ _06106_ _06107_ VGND VGND VPWR VPWR _06108_ sky130_fd_sc_hd__nand2_1
X_12201_ _04786_ _04790_ VGND VGND VPWR VPWR _04962_ sky130_fd_sc_hd__nor2_1
X_10462_ _03065_ _03067_ VGND VGND VPWR VPWR _03068_ sky130_fd_sc_hd__and2_1
X_13181_ _05929_ _05932_ _06030_ VGND VGND VPWR VPWR _06032_ sky130_fd_sc_hd__or3b_1
X_10393_ net654 net643 net323 net322 VGND VGND VPWR VPWR _02992_ sky130_fd_sc_hd__nand4_1
XFILLER_89_89 VPWR VGND VPWR VGND sky130_ef_sc_hd__decap_12
X_12132_ _04878_ _04886_ _04879_ VGND VGND VPWR VPWR _04887_ sky130_fd_sc_hd__and3_1
XFILLER_2_621 VGND VGND VPWR VPWR sky130_fd_sc_hd__decap_8
X_12063_ _04808_ _04810_ VGND VGND VPWR VPWR _04811_ sky130_fd_sc_hd__xor2_1
XFILLER_2_676 VPWR VGND VPWR VGND sky130_ef_sc_hd__decap_12
XFILLER_49_113 VGND VGND VPWR VPWR sky130_fd_sc_hd__decap_6
X_11014_ _01442_ _00104_ _03669_ _03670_ VGND VGND VPWR VPWR _03671_ sky130_fd_sc_hd__o31ai_1
XFILLER_92_403 VGND VGND VPWR VPWR sky130_fd_sc_hd__decap_3
XFILLER_77_488 VGND VGND VPWR VPWR sky130_fd_sc_hd__fill_1
XFILLER_65_628 VGND VGND VPWR VPWR sky130_fd_sc_hd__decap_8
X_12965_ net522 net395 _05645_ _05644_ net414 VGND VGND VPWR VPWR _05796_ sky130_fd_sc_hd__a32o_1
XFILLER_18_533 VGND VGND VPWR VPWR sky130_fd_sc_hd__decap_3
XFILLER_73_650 VGND VGND VPWR VPWR sky130_fd_sc_hd__decap_4
X_11916_ _04646_ _04653_ VGND VGND VPWR VPWR _04654_ sky130_fd_sc_hd__xnor2_1
XFILLER_18_566 VPWR VGND VPWR VGND sky130_ef_sc_hd__decap_12
X_12896_ _05718_ _05719_ VGND VGND VPWR VPWR _05721_ sky130_fd_sc_hd__xnor2_1
XFILLER_60_322 VGND VGND VPWR VPWR sky130_fd_sc_hd__decap_4
XFILLER_18_599 VGND VGND VPWR VPWR sky130_fd_sc_hd__decap_4
X_11847_ _04577_ _04578_ VGND VGND VPWR VPWR _04579_ sky130_fd_sc_hd__nand2_1
XFILLER_60_377 VGND VGND VPWR VPWR sky130_fd_sc_hd__fill_1
X_11778_ _04502_ _04503_ VGND VGND VPWR VPWR _04505_ sky130_fd_sc_hd__or2_1
XTAP_TAPCELL_ROW_119_2028 VGND VPWR sky130_fd_sc_hd__tapvpwrvgnd_1
X_13517_ _06397_ _06398_ VGND VGND VPWR VPWR _06399_ sky130_fd_sc_hd__or2_1
X_10729_ _03356_ _03359_ VGND VGND VPWR VPWR _00022_ sky130_fd_sc_hd__xnor2_1
XTAP_TAPCELL_ROW_31_748 VGND VPWR sky130_fd_sc_hd__tapvpwrvgnd_1
XTAP_TAPCELL_ROW_132_2217 VGND VPWR sky130_fd_sc_hd__tapvpwrvgnd_1
XTAP_TAPCELL_ROW_132_2206 VGND VPWR sky130_fd_sc_hd__tapvpwrvgnd_1
X_13448_ _06318_ _06321_ VGND VGND VPWR VPWR _06324_ sky130_fd_sc_hd__xnor2_1
XTAP_TAPCELL_ROW_11_461 VGND VPWR sky130_fd_sc_hd__tapvpwrvgnd_1
XFILLER_127_685 VGND VGND VPWR VPWR sky130_fd_sc_hd__decap_6
XFILLER_127_663 VGND VGND VPWR VPWR sky130_fd_sc_hd__decap_8
XFILLER_115_803 VGND VGND VPWR VPWR sky130_fd_sc_hd__fill_1
X_13379_ _06084_ _06097_ _06096_ VGND VGND VPWR VPWR _06249_ sky130_fd_sc_hd__a21o_1
XFILLER_127_696 VGND VGND VPWR VPWR sky130_fd_sc_hd__decap_4
XFILLER_126_184 VGND VGND VPWR VPWR sky130_fd_sc_hd__fill_1
XTAP_TAPCELL_ROW_114_1950 VGND VPWR sky130_fd_sc_hd__tapvpwrvgnd_1
XFILLER_87_208 VGND VGND VPWR VPWR sky130_fd_sc_hd__decap_3
X_07940_ _00415_ _00416_ VGND VGND VPWR VPWR _00418_ sky130_fd_sc_hd__xor2_2
XFILLER_96_742 VGND VGND VPWR VPWR sky130_fd_sc_hd__fill_1
XFILLER_68_444 VPWR VGND VPWR VGND sky130_ef_sc_hd__decap_12
X_07871_ _00341_ _00348_ VGND VGND VPWR VPWR _00349_ sky130_fd_sc_hd__xnor2_1
XFILLER_29_809 VPWR VGND VPWR VGND sky130_ef_sc_hd__decap_12
X_09610_ net614 net370 _02141_ _02142_ VGND VGND VPWR VPWR _02143_ sky130_fd_sc_hd__o2bb2a_1
X_06822_ net704 VGND VGND VPWR VPWR _01398_ sky130_fd_sc_hd__inv_2
XFILLER_55_105 VGND VGND VPWR VPWR sky130_fd_sc_hd__decap_6
X_09541_ _02065_ _02066_ VGND VGND VPWR VPWR _02067_ sky130_fd_sc_hd__or2_1
XFILLER_83_447 VGND VGND VPWR VPWR sky130_fd_sc_hd__fill_1
XTAP_TAPCELL_ROW_39_859 VGND VPWR sky130_fd_sc_hd__tapvpwrvgnd_1
XFILLER_52_801 VGND VGND VPWR VPWR sky130_fd_sc_hd__decap_8
XFILLER_36_341 VPWR VGND VPWR VGND sky130_ef_sc_hd__decap_12
X_09472_ _00261_ _01991_ _01823_ VGND VGND VPWR VPWR _01992_ sky130_fd_sc_hd__a21bo_1
XFILLER_64_694 VGND VGND VPWR VPWR sky130_fd_sc_hd__decap_6
XFILLER_51_322 VGND VGND VPWR VPWR sky130_fd_sc_hd__fill_1
XTAP_TAPCELL_ROW_19_572 VGND VPWR sky130_fd_sc_hd__tapvpwrvgnd_1
X_08423_ _00724_ _00808_ _00723_ VGND VGND VPWR VPWR _00896_ sky130_fd_sc_hd__o21ai_1
XFILLER_34_29 VPWR VGND VPWR VGND sky130_ef_sc_hd__decap_12
X_08354_ net256 net661 _06633_ VGND VGND VPWR VPWR _00828_ sky130_fd_sc_hd__nor3_1
X_07305_ net651 net642 net707 net104 VGND VGND VPWR VPWR _06536_ sky130_fd_sc_hd__and4_1
X_08285_ _00598_ net253 _00758_ VGND VGND VPWR VPWR _00760_ sky130_fd_sc_hd__nor3_1
XFILLER_118_652 VGND VGND VPWR VPWR sky130_fd_sc_hd__decap_4
XTAP_TAPCELL_ROW_76_1400 VGND VPWR sky130_fd_sc_hd__tapvpwrvgnd_1
X_07236_ _05865_ _05886_ VGND VGND VPWR VPWR _05908_ sky130_fd_sc_hd__and2b_1
X_07167_ _05111_ _05122_ _05133_ VGND VGND VPWR VPWR _05155_ sky130_fd_sc_hd__a21o_1
XFILLER_132_121 VPWR VGND VPWR VGND sky130_ef_sc_hd__decap_12
XFILLER_133_655 VPWR VGND VPWR VGND sky130_ef_sc_hd__decap_12
XFILLER_121_817 VGND VGND VPWR VPWR sky130_fd_sc_hd__decap_3
X_07098_ _04384_ _04395_ VGND VGND VPWR VPWR _04406_ sky130_fd_sc_hd__xnor2_1
Xfanout265 _01355_ VGND VGND VPWR VPWR net265 sky130_fd_sc_hd__buf_4
Xfanout254 _05287_ VGND VGND VPWR VPWR net254 sky130_fd_sc_hd__clkbuf_4
X_09808_ _02324_ _02356_ VGND VGND VPWR VPWR _02359_ sky130_fd_sc_hd__xnor2_1
XFILLER_87_797 VPWR VGND VPWR VGND sky130_ef_sc_hd__decap_12
Xfanout298 net82 VGND VGND VPWR VPWR net298 sky130_fd_sc_hd__buf_2
Xfanout287 net89 VGND VGND VPWR VPWR net287 sky130_fd_sc_hd__buf_2
Xfanout276 net94 VGND VGND VPWR VPWR net276 sky130_fd_sc_hd__clkbuf_4
X_09739_ _02141_ _02144_ VGND VGND VPWR VPWR _02284_ sky130_fd_sc_hd__nor2_1
XTAP_TAPCELL_ROW_87_1562 VGND VPWR sky130_fd_sc_hd__tapvpwrvgnd_1
XFILLER_39_190 VPWR VGND VPWR VGND sky130_ef_sc_hd__decap_12
X_12750_ _05222_ _05558_ _05561_ VGND VGND VPWR VPWR _05562_ sky130_fd_sc_hd__or3_1
XFILLER_91_57 VPWR VGND VPWR VGND sky130_ef_sc_hd__decap_12
X_12681_ _05453_ _05485_ VGND VGND VPWR VPWR _05487_ sky130_fd_sc_hd__xnor2_1
X_11701_ _04419_ _04420_ VGND VGND VPWR VPWR _04421_ sky130_fd_sc_hd__nor2_1
XFILLER_42_377 VGND VGND VPWR VPWR sky130_fd_sc_hd__decap_8
X_11632_ _03836_ _04241_ VGND VGND VPWR VPWR _04345_ sky130_fd_sc_hd__or2_1
XFILLER_128_405 VPWR VGND VPWR VGND sky130_ef_sc_hd__decap_12
X_13302_ _06164_ VGND VGND VPWR VPWR _06165_ sky130_fd_sc_hd__inv_2
XFILLER_10_241 VGND VGND VPWR VPWR sky130_fd_sc_hd__decap_3
X_11563_ _04262_ _04269_ VGND VGND VPWR VPWR _04270_ sky130_fd_sc_hd__xnor2_1
XFILLER_6_223 VPWR VGND VPWR VGND sky130_ef_sc_hd__decap_12
X_11494_ net248 _04193_ VGND VGND VPWR VPWR _04195_ sky130_fd_sc_hd__xor2_1
XFILLER_11_797 VPWR VGND VPWR VGND sky130_ef_sc_hd__decap_12
X_10514_ _02859_ _02893_ _02951_ VGND VGND VPWR VPWR _03124_ sky130_fd_sc_hd__nor3_1
XFILLER_109_685 VGND VGND VPWR VPWR sky130_fd_sc_hd__decap_4
X_13233_ net254 _06087_ VGND VGND VPWR VPWR _06089_ sky130_fd_sc_hd__xnor2_1
XFILLER_6_256 VPWR VGND VPWR VGND sky130_ef_sc_hd__decap_12
X_10445_ _03038_ _03039_ _03043_ net237 VGND VGND VPWR VPWR _03049_ sky130_fd_sc_hd__a211o_1
X_13164_ _05813_ _05862_ _05861_ VGND VGND VPWR VPWR _06014_ sky130_fd_sc_hd__a21oi_2
XFILLER_40_83 VGND VGND VPWR VPWR sky130_fd_sc_hd__fill_1
XFILLER_123_132 VGND VGND VPWR VPWR sky130_fd_sc_hd__decap_6
X_12115_ _04857_ _04859_ _04858_ VGND VGND VPWR VPWR _04868_ sky130_fd_sc_hd__a21o_1
X_10376_ _02967_ _02972_ VGND VGND VPWR VPWR _02973_ sky130_fd_sc_hd__nand2_1
XFILLER_111_316 VGND VGND VPWR VPWR sky130_fd_sc_hd__fill_1
XFILLER_97_539 VPWR VGND VPWR VGND sky130_ef_sc_hd__decap_12
X_13095_ net259 net398 _05936_ _05937_ VGND VGND VPWR VPWR _05938_ sky130_fd_sc_hd__o22a_1
XFILLER_78_720 VGND VGND VPWR VPWR sky130_fd_sc_hd__decap_6
XFILLER_69_219 VGND VGND VPWR VPWR sky130_fd_sc_hd__decap_4
X_12046_ _04790_ _04791_ VGND VGND VPWR VPWR _04792_ sky130_fd_sc_hd__nor2_1
XFILLER_49_81 VPWR VGND VPWR VGND sky130_ef_sc_hd__decap_12
XFILLER_37_105 VGND VGND VPWR VPWR sky130_fd_sc_hd__decap_6
XFILLER_65_447 VGND VGND VPWR VPWR sky130_fd_sc_hd__fill_1
XFILLER_1_55 VGND VGND VPWR VPWR sky130_fd_sc_hd__fill_1
XFILLER_18_352 VGND VGND VPWR VPWR sky130_fd_sc_hd__fill_1
XTAP_TAPCELL_ROW_36_818 VGND VPWR sky130_fd_sc_hd__tapvpwrvgnd_1
XFILLER_37_149 VGND VGND VPWR VPWR sky130_fd_sc_hd__decap_4
X_12948_ _05738_ _05775_ VGND VGND VPWR VPWR _05778_ sky130_fd_sc_hd__xnor2_1
XFILLER_18_363 VGND VGND VPWR VPWR sky130_fd_sc_hd__fill_1
XFILLER_18_385 VGND VGND VPWR VPWR sky130_fd_sc_hd__decap_3
X_12879_ _05699_ _05700_ VGND VGND VPWR VPWR _05703_ sky130_fd_sc_hd__nand2_1
XTAP_TAPCELL_ROW_16_531 VGND VPWR sky130_fd_sc_hd__tapvpwrvgnd_1
XFILLER_60_141 VGND VGND VPWR VPWR sky130_fd_sc_hd__decap_8
XFILLER_33_388 VGND VGND VPWR VPWR sky130_fd_sc_hd__decap_4
X_08070_ _00545_ _00546_ VGND VGND VPWR VPWR _00547_ sky130_fd_sc_hd__nor2_1
X_07021_ _03478_ _03543_ _03554_ VGND VGND VPWR VPWR _03565_ sky130_fd_sc_hd__and3_1
XTAP_TAPCELL_ROW_58_1141 VGND VPWR sky130_fd_sc_hd__tapvpwrvgnd_1
XFILLER_88_517 VGND VGND VPWR VPWR sky130_fd_sc_hd__decap_3
XFILLER_115_699 VGND VGND VPWR VPWR sky130_fd_sc_hd__fill_2
X_08972_ net453 net332 VGND VGND VPWR VPWR _01447_ sky130_fd_sc_hd__nand2_1
XTAP_TAPCELL_ROW_71_1330 VGND VPWR sky130_fd_sc_hd__tapvpwrvgnd_1
XFILLER_69_753 VPWR VGND VPWR VGND sky130_ef_sc_hd__decap_12
X_07923_ _00400_ _00399_ VGND VGND VPWR VPWR _00401_ sky130_fd_sc_hd__and2b_1
XFILLER_84_701 VGND VGND VPWR VPWR sky130_fd_sc_hd__decap_8
XFILLER_69_797 VGND VGND VPWR VPWR sky130_fd_sc_hd__decap_6
XFILLER_68_241 VGND VGND VPWR VPWR sky130_fd_sc_hd__decap_3
X_07854_ _00298_ _00330_ VGND VGND VPWR VPWR _00332_ sky130_fd_sc_hd__xnor2_2
X_07785_ _00102_ _00110_ _00109_ VGND VGND VPWR VPWR _00264_ sky130_fd_sc_hd__a21bo_1
X_09524_ net244 _02047_ VGND VGND VPWR VPWR _02048_ sky130_fd_sc_hd__nor2_1
XFILLER_45_39 VPWR VGND VPWR VGND sky130_ef_sc_hd__decap_12
X_09455_ net613 net373 _01816_ _01815_ VGND VGND VPWR VPWR _01973_ sky130_fd_sc_hd__a31oi_1
XFILLER_52_653 VGND VGND VPWR VPWR sky130_fd_sc_hd__fill_1
X_08406_ _00850_ _00879_ VGND VGND VPWR VPWR _00880_ sky130_fd_sc_hd__xnor2_1
XFILLER_12_506 VPWR VGND VPWR VGND sky130_ef_sc_hd__decap_12
XFILLER_24_377 VPWR VGND VPWR VGND sky130_ef_sc_hd__decap_12
X_09386_ _01890_ _01897_ VGND VGND VPWR VPWR _01898_ sky130_fd_sc_hd__nor2_1
XTAP_TAPCELL_ROW_82_1492 VGND VPWR sky130_fd_sc_hd__tapvpwrvgnd_1
XTAP_TAPCELL_ROW_82_1481 VGND VPWR sky130_fd_sc_hd__tapvpwrvgnd_1
X_08337_ _00723_ _00735_ _00809_ VGND VGND VPWR VPWR _00811_ sky130_fd_sc_hd__a21oi_1
XFILLER_138_769 VPWR VGND VPWR VGND sky130_ef_sc_hd__decap_12
XFILLER_138_747 VGND VGND VPWR VPWR sky130_fd_sc_hd__decap_4
X_08268_ _00504_ _00742_ VGND VGND VPWR VPWR _00743_ sky130_fd_sc_hd__xnor2_4
XFILLER_118_460 VGND VGND VPWR VPWR sky130_fd_sc_hd__fill_1
X_07219_ _04329_ _05701_ VGND VGND VPWR VPWR _05723_ sky130_fd_sc_hd__and2_1
XFILLER_105_110 VGND VGND VPWR VPWR sky130_fd_sc_hd__fill_2
X_10230_ net458 net283 _02813_ VGND VGND VPWR VPWR _02815_ sky130_fd_sc_hd__a21oi_1
X_08199_ _00673_ _00674_ VGND VGND VPWR VPWR _00675_ sky130_fd_sc_hd__nor2_1
XFILLER_10_53 VPWR VGND VPWR VGND sky130_ef_sc_hd__decap_12
X_10161_ _02634_ _02665_ _02664_ VGND VGND VPWR VPWR _02743_ sky130_fd_sc_hd__a21o_1
XFILLER_126_53 VPWR VGND VPWR VGND sky130_ef_sc_hd__decap_12
XFILLER_10_97 VPWR VGND VPWR VGND sky130_ef_sc_hd__decap_12
X_10092_ _02491_ _02559_ _02558_ VGND VGND VPWR VPWR _02668_ sky130_fd_sc_hd__a21o_1
XFILLER_121_647 VGND VGND VPWR VPWR sky130_fd_sc_hd__fill_1
XFILLER_87_561 VGND VGND VPWR VPWR sky130_fd_sc_hd__decap_6
XFILLER_19_105 VGND VGND VPWR VPWR sky130_fd_sc_hd__decap_6
XFILLER_101_393 VGND VGND VPWR VPWR sky130_fd_sc_hd__fill_2
XFILLER_75_745 VGND VGND VPWR VPWR sky130_fd_sc_hd__decap_3
XFILLER_47_447 VGND VGND VPWR VPWR sky130_fd_sc_hd__fill_1
XFILLER_19_51 VGND VGND VPWR VPWR sky130_fd_sc_hd__decap_4
XFILLER_75_778 VGND VGND VPWR VPWR sky130_fd_sc_hd__decap_6
X_12802_ _05617_ _05576_ VGND VGND VPWR VPWR _05618_ sky130_fd_sc_hd__nand2b_1
XFILLER_74_277 VPWR VGND VPWR VGND sky130_ef_sc_hd__decap_12
XFILLER_43_620 VPWR VGND VPWR VGND sky130_ef_sc_hd__decap_12
X_10994_ _03632_ _03647_ _03648_ VGND VGND VPWR VPWR _03649_ sky130_fd_sc_hd__and3_1
X_12733_ _05511_ _05542_ _05543_ VGND VGND VPWR VPWR _05544_ sky130_fd_sc_hd__nand3_1
XFILLER_15_344 VPWR VGND VPWR VGND sky130_ef_sc_hd__decap_12
XFILLER_42_141 VPWR VGND VPWR VGND sky130_ef_sc_hd__decap_12
X_12664_ _05465_ _05466_ VGND VGND VPWR VPWR _05468_ sky130_fd_sc_hd__xnor2_1
X_12595_ _05389_ _05391_ _05392_ VGND VGND VPWR VPWR _00037_ sky130_fd_sc_hd__o21a_1
X_11615_ net249 _04324_ VGND VGND VPWR VPWR _04326_ sky130_fd_sc_hd__xnor2_1
XTAP_TAPCELL_ROW_41_898 VGND VPWR sky130_fd_sc_hd__tapvpwrvgnd_1
XTAP_TAPCELL_ROW_41_887 VGND VPWR sky130_fd_sc_hd__tapvpwrvgnd_1
X_11546_ _04249_ _04250_ VGND VGND VPWR VPWR _04251_ sky130_fd_sc_hd__nor2_1
XFILLER_116_419 VGND VGND VPWR VPWR sky130_fd_sc_hd__fill_1
XFILLER_7_576 VGND VGND VPWR VPWR sky130_fd_sc_hd__fill_1
X_13216_ _06035_ _06068_ VGND VGND VPWR VPWR _06070_ sky130_fd_sc_hd__xnor2_1
X_11477_ net544 net299 VGND VGND VPWR VPWR _04176_ sky130_fd_sc_hd__nand2_1
XFILLER_124_452 VGND VGND VPWR VPWR sky130_fd_sc_hd__decap_4
X_10428_ _02851_ _02978_ VGND VGND VPWR VPWR _03031_ sky130_fd_sc_hd__nor2_1
XFILLER_124_474 VGND VGND VPWR VPWR sky130_fd_sc_hd__fill_2
X_13147_ net606 net320 VGND VGND VPWR VPWR _05995_ sky130_fd_sc_hd__nand2_1
X_10359_ _02952_ _02954_ VGND VGND VPWR VPWR _02955_ sky130_fd_sc_hd__xor2_1
XFILLER_111_124 VPWR VGND VPWR VGND sky130_ef_sc_hd__decap_12
XFILLER_111_113 VGND VGND VPWR VPWR sky130_fd_sc_hd__decap_4
X_13078_ _05913_ _05918_ VGND VGND VPWR VPWR _05920_ sky130_fd_sc_hd__nand2_1
XFILLER_2_270 VGND VGND VPWR VPWR sky130_fd_sc_hd__decap_3
X_12029_ _04771_ _04773_ VGND VGND VPWR VPWR _04774_ sky130_fd_sc_hd__nor2_1
XFILLER_66_701 VPWR VGND VPWR VGND sky130_ef_sc_hd__decap_12
XTAP_TAPCELL_ROW_53_1071 VGND VPWR sky130_fd_sc_hd__tapvpwrvgnd_1
XTAP_TAPCELL_ROW_127_2138 VGND VPWR sky130_fd_sc_hd__tapvpwrvgnd_1
XFILLER_18_3 VPWR VGND VPWR VGND sky130_ef_sc_hd__decap_12
XFILLER_76_90 VGND VGND VPWR VPWR sky130_fd_sc_hd__decap_4
XFILLER_65_266 VGND VGND VPWR VPWR sky130_fd_sc_hd__fill_1
XFILLER_65_233 VGND VGND VPWR VPWR sky130_fd_sc_hd__decap_6
XTAP_TAPCELL_ROW_109_1882 VGND VPWR sky130_fd_sc_hd__tapvpwrvgnd_1
XFILLER_80_225 VGND VGND VPWR VPWR sky130_fd_sc_hd__fill_1
XFILLER_80_214 VGND VGND VPWR VPWR sky130_fd_sc_hd__fill_1
X_07570_ net449 net665 _06662_ _06661_ VGND VGND VPWR VPWR _06799_ sky130_fd_sc_hd__a31o_1
XFILLER_53_417 VGND VGND VPWR VPWR sky130_fd_sc_hd__decap_4
XFILLER_25_119 VPWR VGND VPWR VGND sky130_ef_sc_hd__decap_12
X_09240_ _01735_ _01737_ VGND VGND VPWR VPWR _01739_ sky130_fd_sc_hd__xnor2_1
XFILLER_33_174 VGND VGND VPWR VPWR sky130_fd_sc_hd__decap_4
X_09171_ _01461_ _01492_ _01491_ VGND VGND VPWR VPWR _01664_ sky130_fd_sc_hd__a21bo_1
X_08122_ net493 _00342_ _00482_ net675 VGND VGND VPWR VPWR _00598_ sky130_fd_sc_hd__o211ai_4
XFILLER_119_279 VGND VGND VPWR VPWR sky130_fd_sc_hd__fill_1
XFILLER_107_408 VGND VGND VPWR VPWR sky130_fd_sc_hd__decap_8
X_08053_ _00524_ _00529_ VGND VGND VPWR VPWR _00530_ sky130_fd_sc_hd__and2b_1
X_07004_ _03358_ _03368_ VGND VGND VPWR VPWR _03379_ sky130_fd_sc_hd__nor2_1
XPHY_EDGE_ROW_131_Right_131 VGND VGND VPWR VPWR sky130_fd_sc_hd__decap_3
XFILLER_130_433 VGND VGND VPWR VPWR sky130_fd_sc_hd__decap_4
X_08955_ _01081_ _01134_ _01285_ VGND VGND VPWR VPWR _01428_ sky130_fd_sc_hd__nor3_1
XFILLER_103_669 VGND VGND VPWR VPWR sky130_fd_sc_hd__decap_3
Xinput108 w31[2] VGND VGND VPWR VPWR net108 sky130_fd_sc_hd__buf_1
XFILLER_130_477 VGND VGND VPWR VPWR sky130_fd_sc_hd__fill_1
XFILLER_130_466 VGND VGND VPWR VPWR sky130_fd_sc_hd__decap_8
XFILLER_102_168 VGND VGND VPWR VPWR sky130_fd_sc_hd__decap_4
XFILLER_69_561 VGND VGND VPWR VPWR sky130_fd_sc_hd__decap_3
X_07906_ _00253_ _00256_ VGND VGND VPWR VPWR _00384_ sky130_fd_sc_hd__nor2_1
Xinput119 w32[5] VGND VGND VPWR VPWR net119 sky130_fd_sc_hd__buf_2
X_08886_ _01222_ _01225_ net235 _01352_ VGND VGND VPWR VPWR _01353_ sky130_fd_sc_hd__a211oi_4
XFILLER_84_531 VGND VGND VPWR VPWR sky130_fd_sc_hd__fill_1
XFILLER_56_27 VGND VGND VPWR VPWR sky130_fd_sc_hd__fill_1
XFILLER_29_447 VGND VGND VPWR VPWR sky130_fd_sc_hd__fill_1
X_07837_ _00160_ _00314_ VGND VGND VPWR VPWR _00315_ sky130_fd_sc_hd__nand2_1
XTAP_TAPCELL_ROW_84_1510 VGND VPWR sky130_fd_sc_hd__tapvpwrvgnd_1
XFILLER_72_737 VPWR VGND VPWR VGND sky130_ef_sc_hd__decap_12
XFILLER_71_203 VGND VGND VPWR VPWR sky130_fd_sc_hd__decap_4
X_07768_ _00245_ _00246_ VGND VGND VPWR VPWR _00247_ sky130_fd_sc_hd__xnor2_1
X_09507_ _01907_ _01909_ _02027_ VGND VGND VPWR VPWR _02029_ sky130_fd_sc_hd__and3_1
XTAP_TAPCELL_ROW_84_1521 VGND VPWR sky130_fd_sc_hd__tapvpwrvgnd_1
XFILLER_71_258 VGND VGND VPWR VPWR sky130_fd_sc_hd__decap_8
XFILLER_71_225 VGND VGND VPWR VPWR sky130_fd_sc_hd__decap_8
XFILLER_37_480 VGND VGND VPWR VPWR sky130_fd_sc_hd__fill_2
XFILLER_112_99 VPWR VGND VPWR VGND sky130_ef_sc_hd__decap_12
X_07699_ _00170_ _00177_ VGND VGND VPWR VPWR _00178_ sky130_fd_sc_hd__nor2_1
XFILLER_25_686 VPWR VGND VPWR VGND sky130_ef_sc_hd__decap_12
XFILLER_40_601 VGND VGND VPWR VPWR sky130_fd_sc_hd__decap_4
X_09438_ net428 net333 net332 net438 VGND VGND VPWR VPWR _01955_ sky130_fd_sc_hd__a22o_1
XFILLER_80_792 VPWR VGND VPWR VGND sky130_ef_sc_hd__decap_12
XFILLER_40_645 VPWR VGND VPWR VGND sky130_ef_sc_hd__decap_12
X_09369_ net363 net361 net542 net533 VGND VGND VPWR VPWR _01880_ sky130_fd_sc_hd__and4b_1
XFILLER_12_347 VGND VGND VPWR VPWR sky130_fd_sc_hd__decap_3
X_12380_ _05154_ _05156_ _05157_ VGND VGND VPWR VPWR _05158_ sky130_fd_sc_hd__nand3_1
X_11400_ _04084_ _04092_ VGND VGND VPWR VPWR _04093_ sky130_fd_sc_hd__xnor2_1
XFILLER_126_717 VGND VGND VPWR VPWR sky130_fd_sc_hd__fill_1
XFILLER_122_3 VPWR VGND VPWR VGND sky130_ef_sc_hd__decap_12
X_11331_ _04016_ _04017_ VGND VGND VPWR VPWR _04018_ sky130_fd_sc_hd__nor2_1
XFILLER_4_502 VGND VGND VPWR VPWR sky130_fd_sc_hd__decap_8
XFILLER_125_249 VPWR VGND VPWR VGND sky130_ef_sc_hd__decap_12
XFILLER_106_452 VPWR VGND VPWR VGND sky130_ef_sc_hd__decap_12
XTAP_TAPCELL_ROW_95_1683 VGND VPWR sky130_fd_sc_hd__tapvpwrvgnd_1
XTAP_TAPCELL_ROW_95_1672 VGND VPWR sky130_fd_sc_hd__tapvpwrvgnd_1
X_11262_ _03935_ _03940_ VGND VGND VPWR VPWR _03942_ sky130_fd_sc_hd__xor2_1
XFILLER_97_45 VGND VGND VPWR VPWR sky130_fd_sc_hd__decap_8
X_13001_ net353 net601 VGND VGND VPWR VPWR _05836_ sky130_fd_sc_hd__nand2b_1
X_11193_ _03536_ _03866_ VGND VGND VPWR VPWR _03867_ sky130_fd_sc_hd__xnor2_1
X_10213_ net468 net658 net327 net283 VGND VGND VPWR VPWR _02797_ sky130_fd_sc_hd__and4_1
X_10144_ _02057_ _02723_ VGND VGND VPWR VPWR _02724_ sky130_fd_sc_hd__xnor2_1
XFILLER_94_306 VGND VGND VPWR VPWR sky130_fd_sc_hd__fill_2
XFILLER_48_701 VPWR VGND VPWR VGND sky130_ef_sc_hd__decap_12
X_10075_ _02530_ _02531_ _02528_ VGND VGND VPWR VPWR _02649_ sky130_fd_sc_hd__a21o_1
XFILLER_121_499 VGND VGND VPWR VPWR sky130_fd_sc_hd__decap_4
XFILLER_87_391 VGND VGND VPWR VPWR sky130_fd_sc_hd__fill_1
XTAP_TAPCELL_ROW_7_395 VGND VPWR sky130_fd_sc_hd__tapvpwrvgnd_1
XFILLER_0_785 VPWR VGND VPWR VGND sky130_ef_sc_hd__decap_12
XFILLER_75_597 VGND VGND VPWR VPWR sky130_fd_sc_hd__fill_1
XFILLER_63_726 VGND VGND VPWR VPWR sky130_fd_sc_hd__fill_2
XTAP_TAPCELL_ROW_46_968 VGND VPWR sky130_fd_sc_hd__tapvpwrvgnd_1
XTAP_TAPCELL_ROW_122_2068 VGND VPWR sky130_fd_sc_hd__tapvpwrvgnd_1
XFILLER_90_589 VGND VGND VPWR VPWR sky130_fd_sc_hd__decap_3
XFILLER_15_152 VPWR VGND VPWR VGND sky130_ef_sc_hd__decap_12
X_10977_ _03462_ _03473_ _03471_ VGND VGND VPWR VPWR _03630_ sky130_fd_sc_hd__a21oi_1
XFILLER_70_280 VPWR VGND VPWR VGND sky130_ef_sc_hd__decap_12
X_12716_ net615 net353 VGND VGND VPWR VPWR _05525_ sky130_fd_sc_hd__nand2_1
XTAP_TAPCELL_ROW_26_670 VGND VPWR sky130_fd_sc_hd__tapvpwrvgnd_1
XTAP_TAPCELL_ROW_26_681 VGND VPWR sky130_fd_sc_hd__tapvpwrvgnd_1
XFILLER_31_645 VPWR VGND VPWR VGND sky130_ef_sc_hd__decap_12
X_13696_ clknet_3_1__leaf_clk _00042_ net713 VGND VGND VPWR VPWR net215 sky130_fd_sc_hd__dfrtp_1
X_12647_ _05399_ _05447_ VGND VGND VPWR VPWR _05449_ sky130_fd_sc_hd__xnor2_1
XFILLER_30_155 VGND VGND VPWR VPWR sky130_fd_sc_hd__decap_3
XFILLER_30_177 VGND VGND VPWR VPWR sky130_fd_sc_hd__fill_1
XFILLER_117_717 VGND VGND VPWR VPWR sky130_fd_sc_hd__decap_8
X_12578_ _05142_ _05201_ _05200_ VGND VGND VPWR VPWR _05375_ sky130_fd_sc_hd__a21bo_1
XFILLER_11_391 VGND VGND VPWR VPWR sky130_fd_sc_hd__fill_1
X_11529_ _04230_ _04231_ VGND VGND VPWR VPWR _04234_ sky130_fd_sc_hd__xor2_1
XTAP_TAPCELL_ROW_55_1100 VGND VPWR sky130_fd_sc_hd__tapvpwrvgnd_1
XFILLER_7_98 VGND VGND VPWR VPWR sky130_fd_sc_hd__fill_2
XFILLER_98_601 VPWR VGND VPWR VGND sky130_ef_sc_hd__decap_12
XFILLER_112_433 VGND VGND VPWR VPWR sky130_fd_sc_hd__decap_3
XFILLER_98_689 VGND VGND VPWR VPWR sky130_fd_sc_hd__fill_1
XFILLER_97_144 VGND VGND VPWR VPWR sky130_fd_sc_hd__decap_8
X_08740_ _01159_ _01206_ VGND VGND VPWR VPWR _01207_ sky130_fd_sc_hd__nor2_1
X_08671_ _01132_ _01137_ VGND VGND VPWR VPWR _01138_ sky130_fd_sc_hd__xnor2_1
XFILLER_38_244 VGND VGND VPWR VPWR sky130_fd_sc_hd__decap_8
XFILLER_93_372 VGND VGND VPWR VPWR sky130_fd_sc_hd__decap_4
X_07622_ _00100_ _00101_ VGND VGND VPWR VPWR _00102_ sky130_fd_sc_hd__xnor2_1
XFILLER_81_545 VPWR VGND VPWR VGND sky130_ef_sc_hd__decap_12
XFILLER_53_225 VGND VGND VPWR VPWR sky130_fd_sc_hd__decap_8
XFILLER_26_439 VGND VGND VPWR VPWR sky130_fd_sc_hd__decap_6
XTAP_TAPCELL_ROW_66_1262 VGND VPWR sky130_fd_sc_hd__tapvpwrvgnd_1
XTAP_TAPCELL_ROW_66_1251 VGND VPWR sky130_fd_sc_hd__tapvpwrvgnd_1
X_07553_ _06650_ _06652_ VGND VGND VPWR VPWR _06782_ sky130_fd_sc_hd__nand2_1
XFILLER_62_781 VGND VGND VPWR VPWR sky130_fd_sc_hd__fill_1
X_07484_ _06291_ _06555_ _06554_ VGND VGND VPWR VPWR _06714_ sky130_fd_sc_hd__a21boi_1
X_09223_ _01576_ _01586_ _01585_ VGND VGND VPWR VPWR _01720_ sky130_fd_sc_hd__a21bo_1
XFILLER_42_29 VPWR VGND VPWR VGND sky130_ef_sc_hd__decap_12
XFILLER_22_645 VGND VGND VPWR VPWR sky130_fd_sc_hd__fill_1
XFILLER_22_678 VPWR VGND VPWR VGND sky130_ef_sc_hd__decap_12
X_09154_ net648 net40 _01643_ _01644_ VGND VGND VPWR VPWR _01645_ sky130_fd_sc_hd__o2bb2a_1
XFILLER_21_155 VGND VGND VPWR VPWR sky130_fd_sc_hd__fill_2
X_08105_ _00579_ _00580_ VGND VGND VPWR VPWR _00581_ sky130_fd_sc_hd__nand2_1
X_09085_ _01422_ _01432_ _01430_ VGND VGND VPWR VPWR _01570_ sky130_fd_sc_hd__a21o_1
XFILLER_107_216 VGND VGND VPWR VPWR sky130_fd_sc_hd__fill_1
XFILLER_135_558 VGND VGND VPWR VPWR sky130_fd_sc_hd__fill_2
X_08036_ _00502_ _00512_ VGND VGND VPWR VPWR _00513_ sky130_fd_sc_hd__xnor2_1
Xinput90 w23[0] VGND VGND VPWR VPWR net90 sky130_fd_sc_hd__buf_2
XFILLER_103_400 VGND VGND VPWR VPWR sky130_fd_sc_hd__decap_8
XFILLER_107_55 VGND VGND VPWR VPWR sky130_fd_sc_hd__fill_1
X_09987_ _02527_ _02551_ VGND VGND VPWR VPWR _02553_ sky130_fd_sc_hd__xnor2_1
XFILLER_131_797 VPWR VGND VPWR VGND sky130_ef_sc_hd__decap_12
XFILLER_130_285 VPWR VGND VPWR VGND sky130_ef_sc_hd__decap_12
X_08938_ net480 net352 net351 net490 VGND VGND VPWR VPWR _01410_ sky130_fd_sc_hd__a22oi_1
XFILLER_76_317 VGND VGND VPWR VPWR sky130_fd_sc_hd__decap_3
X_08869_ _01331_ _01333_ _01314_ VGND VGND VPWR VPWR _01335_ sky130_fd_sc_hd__o21ai_1
XTAP_TAPCELL_ROW_4_354 VGND VPWR sky130_fd_sc_hd__tapvpwrvgnd_1
XFILLER_84_350 VPWR VGND VPWR VGND sky130_ef_sc_hd__decap_12
XFILLER_72_523 VGND VGND VPWR VPWR sky130_fd_sc_hd__decap_8
XFILLER_44_214 VGND VGND VPWR VPWR sky130_fd_sc_hd__fill_2
X_10900_ _03544_ _03545_ VGND VGND VPWR VPWR _03546_ sky130_fd_sc_hd__or2_1
XFILLER_29_255 VPWR VGND VPWR VGND sky130_ef_sc_hd__decap_12
XFILLER_83_69 VGND VGND VPWR VPWR sky130_fd_sc_hd__decap_4
X_11880_ _04306_ _04536_ _04535_ VGND VGND VPWR VPWR _04616_ sky130_fd_sc_hd__a21o_1
XFILLER_17_439 VGND VGND VPWR VPWR sky130_fd_sc_hd__decap_8
XFILLER_72_589 VGND VGND VPWR VPWR sky130_fd_sc_hd__fill_1
XFILLER_60_707 VGND VGND VPWR VPWR sky130_fd_sc_hd__decap_4
XTAP_TAPCELL_ROW_43_927 VGND VPWR sky130_fd_sc_hd__tapvpwrvgnd_1
XTAP_TAPCELL_ROW_43_916 VGND VPWR sky130_fd_sc_hd__tapvpwrvgnd_1
XFILLER_16_41 VPWR VGND VPWR VGND sky130_ef_sc_hd__decap_12
X_10831_ _03468_ _03469_ _03470_ VGND VGND VPWR VPWR _03471_ sky130_fd_sc_hd__and3_1
X_13550_ _06433_ _06434_ VGND VGND VPWR VPWR _06435_ sky130_fd_sc_hd__and2_1
XPHY_EDGE_ROW_11_Right_11 VGND VGND VPWR VPWR sky130_fd_sc_hd__decap_3
X_10762_ net494 net485 net295 net294 VGND VGND VPWR VPWR _03395_ sky130_fd_sc_hd__and4_1
X_12501_ _05288_ _05289_ VGND VGND VPWR VPWR _05290_ sky130_fd_sc_hd__nand2_1
X_13481_ _06274_ _06276_ VGND VGND VPWR VPWR _06360_ sky130_fd_sc_hd__nor2_1
XFILLER_13_667 VGND VGND VPWR VPWR sky130_fd_sc_hd__decap_4
X_12432_ _04925_ _05064_ _05213_ _05214_ VGND VGND VPWR VPWR _05215_ sky130_fd_sc_hd__and4_1
XFILLER_12_155 VGND VGND VPWR VPWR sky130_fd_sc_hd__decap_6
XFILLER_12_177 VGND VGND VPWR VPWR sky130_fd_sc_hd__decap_3
X_10693_ _03317_ _03318_ _03319_ VGND VGND VPWR VPWR _03320_ sky130_fd_sc_hd__or3_1
XTAP_TAPCELL_ROW_97_1712 VGND VPWR sky130_fd_sc_hd__tapvpwrvgnd_1
XTAP_TAPCELL_ROW_97_1701 VGND VPWR sky130_fd_sc_hd__tapvpwrvgnd_1
X_12363_ _05012_ _05137_ VGND VGND VPWR VPWR _05139_ sky130_fd_sc_hd__xnor2_1
X_12294_ _05062_ _05063_ VGND VGND VPWR VPWR _05064_ sky130_fd_sc_hd__nor2_1
X_11314_ _03997_ _03998_ VGND VGND VPWR VPWR _03999_ sky130_fd_sc_hd__and2b_1
XFILLER_107_783 VGND VGND VPWR VPWR sky130_fd_sc_hd__fill_1
X_11245_ net257 net293 _03921_ _03922_ VGND VGND VPWR VPWR _03923_ sky130_fd_sc_hd__o22a_1
XFILLER_79_111 VGND VGND VPWR VPWR sky130_fd_sc_hd__fill_1
XPHY_EDGE_ROW_20_Right_20 VGND VGND VPWR VPWR sky130_fd_sc_hd__decap_3
X_11176_ _03845_ _03846_ VGND VGND VPWR VPWR _03848_ sky130_fd_sc_hd__xor2_1
X_10127_ _02609_ _02704_ VGND VGND VPWR VPWR _02705_ sky130_fd_sc_hd__nand2b_1
XFILLER_79_177 VGND VGND VPWR VPWR sky130_fd_sc_hd__fill_2
XFILLER_67_317 VGND VGND VPWR VPWR sky130_fd_sc_hd__decap_6
XTAP_TAPCELL_ROW_50_1030 VGND VPWR sky130_fd_sc_hd__tapvpwrvgnd_1
X_10058_ _02522_ _02555_ _02523_ VGND VGND VPWR VPWR _02631_ sky130_fd_sc_hd__a21oi_1
XFILLER_82_309 VGND VGND VPWR VPWR sky130_fd_sc_hd__decap_3
XFILLER_36_726 VPWR VGND VPWR VGND sky130_ef_sc_hd__decap_12
XTAP_TAPCELL_ROW_106_1830 VGND VPWR sky130_fd_sc_hd__tapvpwrvgnd_1
XFILLER_35_225 VGND VGND VPWR VPWR sky130_fd_sc_hd__decap_4
XTAP_TAPCELL_ROW_106_1841 VGND VPWR sky130_fd_sc_hd__tapvpwrvgnd_1
XFILLER_51_718 VGND VGND VPWR VPWR sky130_fd_sc_hd__fill_1
XFILLER_44_781 VPWR VGND VPWR VGND sky130_ef_sc_hd__decap_12
XFILLER_16_472 VGND VGND VPWR VPWR sky130_fd_sc_hd__decap_4
XFILLER_31_420 VGND VGND VPWR VPWR sky130_fd_sc_hd__decap_8
XFILLER_85_3 VPWR VGND VPWR VGND sky130_ef_sc_hd__decap_12
X_13679_ clknet_3_1__leaf_clk _00014_ net714 VGND VGND VPWR VPWR net198 sky130_fd_sc_hd__dfrtp_1
XFILLER_129_352 VGND VGND VPWR VPWR sky130_fd_sc_hd__fill_2
XTAP_TAPCELL_ROW_61_1181 VGND VPWR sky130_fd_sc_hd__tapvpwrvgnd_1
XTAP_TAPCELL_ROW_135_2259 VGND VPWR sky130_fd_sc_hd__tapvpwrvgnd_1
XFILLER_8_682 VGND VGND VPWR VPWR sky130_fd_sc_hd__decap_8
XFILLER_105_709 VPWR VGND VPWR VGND sky130_ef_sc_hd__decap_12
XFILLER_7_192 VPWR VGND VPWR VGND sky130_ef_sc_hd__decap_12
X_09910_ _02329_ _02334_ _02333_ VGND VGND VPWR VPWR _02469_ sky130_fd_sc_hd__a21bo_1
XTAP_TAPCELL_ROW_117_1992 VGND VPWR sky130_fd_sc_hd__tapvpwrvgnd_1
XFILLER_132_539 VGND VGND VPWR VPWR sky130_fd_sc_hd__decap_6
Xfanout606 net608 VGND VGND VPWR VPWR net606 sky130_fd_sc_hd__clkbuf_4
XFILLER_113_775 VGND VGND VPWR VPWR sky130_fd_sc_hd__decap_8
Xfanout617 net135 VGND VGND VPWR VPWR net617 sky130_fd_sc_hd__clkbuf_4
X_09841_ _02392_ _02393_ VGND VGND VPWR VPWR _02395_ sky130_fd_sc_hd__xor2_1
Xfanout639 net641 VGND VGND VPWR VPWR net639 sky130_fd_sc_hd__clkbuf_4
XFILLER_98_475 VGND VGND VPWR VPWR sky130_fd_sc_hd__fill_1
Xfanout628 net635 VGND VGND VPWR VPWR net628 sky130_fd_sc_hd__clkbuf_2
X_09772_ _02318_ _02319_ VGND VGND VPWR VPWR _00056_ sky130_fd_sc_hd__xnor2_1
XFILLER_113_797 VPWR VGND VPWR VGND sky130_ef_sc_hd__decap_12
XFILLER_112_285 VGND VGND VPWR VPWR sky130_fd_sc_hd__decap_8
XFILLER_85_125 VPWR VGND VPWR VGND sky130_ef_sc_hd__decap_12
X_06984_ net670 net451 net669 net459 VGND VGND VPWR VPWR _03161_ sky130_fd_sc_hd__a22o_1
XFILLER_58_317 VGND VGND VPWR VPWR sky130_fd_sc_hd__decap_3
X_08723_ net471 net333 _01188_ _01189_ VGND VGND VPWR VPWR _01190_ sky130_fd_sc_hd__nand4_1
XFILLER_100_458 VGND VGND VPWR VPWR sky130_fd_sc_hd__fill_2
XFILLER_94_681 VPWR VGND VPWR VGND sky130_ef_sc_hd__decap_12
XFILLER_82_810 VGND VGND VPWR VPWR sky130_fd_sc_hd__fill_2
XTAP_TAPCELL_ROW_1_313 VGND VPWR sky130_fd_sc_hd__tapvpwrvgnd_1
X_08654_ _01067_ _01114_ VGND VGND VPWR VPWR _01121_ sky130_fd_sc_hd__xor2_1
XFILLER_27_737 VGND VGND VPWR VPWR sky130_fd_sc_hd__fill_2
XFILLER_27_759 VPWR VGND VPWR VGND sky130_ef_sc_hd__decap_12
X_08585_ net524 net349 VGND VGND VPWR VPWR _01053_ sky130_fd_sc_hd__nand2_1
X_07605_ _00069_ _00083_ _00084_ VGND VGND VPWR VPWR _00085_ sky130_fd_sc_hd__and3_1
XFILLER_54_589 VPWR VGND VPWR VGND sky130_ef_sc_hd__decap_12
XFILLER_26_247 VGND VGND VPWR VPWR sky130_fd_sc_hd__decap_4
XFILLER_53_39 VPWR VGND VPWR VGND sky130_ef_sc_hd__decap_12
X_07536_ _06761_ _06762_ net571 net113 VGND VGND VPWR VPWR _06765_ sky130_fd_sc_hd__and4b_1
X_09206_ net266 net364 _01522_ VGND VGND VPWR VPWR _01701_ sky130_fd_sc_hd__o21a_1
X_07467_ _06694_ _06695_ VGND VGND VPWR VPWR _06697_ sky130_fd_sc_hd__xor2_1
X_07398_ _06039_ _06627_ VGND VGND VPWR VPWR _06628_ sky130_fd_sc_hd__xnor2_1
XFILLER_10_659 VPWR VGND VPWR VGND sky130_ef_sc_hd__decap_12
X_09137_ _01622_ _01623_ _01624_ VGND VGND VPWR VPWR _01626_ sky130_fd_sc_hd__a21oi_1
XTAP_TAPCELL_ROW_79_1442 VGND VPWR sky130_fd_sc_hd__tapvpwrvgnd_1
X_09068_ net498 net490 net349 net348 VGND VGND VPWR VPWR _01552_ sky130_fd_sc_hd__and4_1
XFILLER_5_129 VGND VGND VPWR VPWR sky130_fd_sc_hd__fill_1
XFILLER_118_65 VPWR VGND VPWR VGND sky130_ef_sc_hd__decap_12
X_08019_ _00493_ _00494_ VGND VGND VPWR VPWR _00496_ sky130_fd_sc_hd__xor2_1
XTAP_TAPCELL_ROW_9_424 VGND VPWR sky130_fd_sc_hd__tapvpwrvgnd_1
XFILLER_135_399 VGND VGND VPWR VPWR sky130_fd_sc_hd__fill_1
XTAP_TAPCELL_ROW_92_1631 VGND VPWR sky130_fd_sc_hd__tapvpwrvgnd_1
XTAP_TAPCELL_ROW_9_435 VGND VPWR sky130_fd_sc_hd__tapvpwrvgnd_1
X_11030_ _03685_ _03687_ _03505_ _03507_ VGND VGND VPWR VPWR _03689_ sky130_fd_sc_hd__a211oi_2
XFILLER_134_53 VPWR VGND VPWR VGND sky130_ef_sc_hd__decap_12
XFILLER_134_97 VPWR VGND VPWR VGND sky130_ef_sc_hd__decap_12
X_12981_ _05666_ _05673_ _05672_ VGND VGND VPWR VPWR _05814_ sky130_fd_sc_hd__o21ai_1
XFILLER_73_821 VGND VGND VPWR VPWR sky130_fd_sc_hd__decap_3
XFILLER_45_501 VGND VGND VPWR VPWR sky130_fd_sc_hd__decap_3
XFILLER_84_180 VGND VGND VPWR VPWR sky130_fd_sc_hd__fill_2
X_11932_ _04666_ _04667_ _04668_ VGND VGND VPWR VPWR _04670_ sky130_fd_sc_hd__o21ai_1
XFILLER_27_51 VGND VGND VPWR VPWR sky130_fd_sc_hd__decap_4
XTAP_TAPCELL_ROW_28_710 VGND VPWR sky130_fd_sc_hd__tapvpwrvgnd_1
X_11863_ _04595_ _04596_ VGND VGND VPWR VPWR _04597_ sky130_fd_sc_hd__nor2_1
X_13602_ _06489_ _06490_ VGND VGND VPWR VPWR _06491_ sky130_fd_sc_hd__xor2_1
X_10814_ _03415_ _03451_ VGND VGND VPWR VPWR _03452_ sky130_fd_sc_hd__xnor2_1
XFILLER_32_239 VGND VGND VPWR VPWR sky130_fd_sc_hd__fill_2
X_11794_ _04519_ _04520_ _04505_ VGND VGND VPWR VPWR _04522_ sky130_fd_sc_hd__o21ai_1
XTAP_TAPCELL_ROW_101_1760 VGND VPWR sky130_fd_sc_hd__tapvpwrvgnd_1
X_13533_ _06306_ _06307_ _06311_ VGND VGND VPWR VPWR _06416_ sky130_fd_sc_hd__a21o_1
X_10745_ _03209_ _03375_ VGND VGND VPWR VPWR _03376_ sky130_fd_sc_hd__xnor2_1
X_13464_ _06335_ _06339_ VGND VGND VPWR VPWR _06341_ sky130_fd_sc_hd__xnor2_1
X_10676_ _03298_ _03299_ _03152_ VGND VGND VPWR VPWR _03301_ sky130_fd_sc_hd__a21oi_1
X_13395_ _06261_ _06265_ VGND VGND VPWR VPWR _06266_ sky130_fd_sc_hd__xor2_1
X_12415_ _05193_ _05194_ _05038_ _05040_ VGND VGND VPWR VPWR _05196_ sky130_fd_sc_hd__o211ai_2
XFILLER_138_193 VGND VGND VPWR VPWR sky130_fd_sc_hd__decap_3
X_12346_ net516 net399 net401 net507 VGND VGND VPWR VPWR _05120_ sky130_fd_sc_hd__a22o_1
XFILLER_5_641 VGND VGND VPWR VPWR sky130_fd_sc_hd__decap_3
Xoutput209 net209 VGND VGND VPWR VPWR y2[6] sky130_fd_sc_hd__buf_2
XFILLER_126_399 VGND VGND VPWR VPWR sky130_fd_sc_hd__decap_3
X_12277_ _05015_ _05043_ _05044_ VGND VGND VPWR VPWR _05045_ sky130_fd_sc_hd__nor3_4
XTAP_TAPCELL_ROW_130_2189 VGND VPWR sky130_fd_sc_hd__tapvpwrvgnd_1
XTAP_TAPCELL_ROW_130_2178 VGND VPWR sky130_fd_sc_hd__tapvpwrvgnd_1
XFILLER_4_195 VGND VGND VPWR VPWR sky130_fd_sc_hd__fill_1
XFILLER_4_77 VGND VGND VPWR VPWR sky130_fd_sc_hd__decap_6
X_11228_ _03745_ _03902_ VGND VGND VPWR VPWR _03905_ sky130_fd_sc_hd__xor2_1
XFILLER_110_712 VGND VGND VPWR VPWR sky130_fd_sc_hd__fill_1
XFILLER_68_615 VGND VGND VPWR VPWR sky130_fd_sc_hd__decap_8
X_11159_ _03820_ _03829_ VGND VGND VPWR VPWR _03830_ sky130_fd_sc_hd__xor2_1
XFILLER_67_169 VGND VGND VPWR VPWR sky130_fd_sc_hd__decap_3
XFILLER_91_695 VGND VGND VPWR VPWR sky130_fd_sc_hd__fill_2
XTAP_TAPCELL_ROW_63_1210 VGND VPWR sky130_fd_sc_hd__tapvpwrvgnd_1
XFILLER_51_537 VGND VGND VPWR VPWR sky130_fd_sc_hd__fill_1
X_08370_ _00843_ _00822_ VGND VGND VPWR VPWR _00844_ sky130_fd_sc_hd__and2b_1
XFILLER_36_589 VGND VGND VPWR VPWR sky130_fd_sc_hd__decap_3
X_07321_ _06519_ _06550_ _06551_ VGND VGND VPWR VPWR _06552_ sky130_fd_sc_hd__nand3_1
XFILLER_51_559 VGND VGND VPWR VPWR sky130_fd_sc_hd__fill_1
XFILLER_32_740 VPWR VGND VPWR VGND sky130_ef_sc_hd__decap_12
X_07252_ _06050_ _06061_ _06029_ VGND VGND VPWR VPWR _06083_ sky130_fd_sc_hd__a21bo_1
Xclkbuf_3_2__f_clk clknet_0_clk VGND VGND VPWR VPWR clknet_3_2__leaf_clk sky130_fd_sc_hd__clkbuf_16
X_07183_ _04816_ _05308_ _05319_ VGND VGND VPWR VPWR _05330_ sky130_fd_sc_hd__nor3_1
XFILLER_132_303 VGND VGND VPWR VPWR sky130_fd_sc_hd__decap_4
XFILLER_132_347 VGND VGND VPWR VPWR sky130_fd_sc_hd__decap_3
Xfanout403 net20 VGND VGND VPWR VPWR net403 sky130_fd_sc_hd__dlymetal6s2s_1
XTAP_TAPCELL_ROW_74_1372 VGND VPWR sky130_fd_sc_hd__tapvpwrvgnd_1
Xfanout414 net161 VGND VGND VPWR VPWR net414 sky130_fd_sc_hd__buf_2
XFILLER_59_604 VPWR VGND VPWR VGND sky130_ef_sc_hd__decap_12
X_09824_ _01768_ _02375_ VGND VGND VPWR VPWR _02376_ sky130_fd_sc_hd__xnor2_1
XFILLER_113_561 VPWR VGND VPWR VGND sky130_ef_sc_hd__decap_12
Xfanout447 net448 VGND VGND VPWR VPWR net447 sky130_fd_sc_hd__clkbuf_2
XFILLER_98_283 VGND VGND VPWR VPWR sky130_fd_sc_hd__decap_8
Xfanout436 net441 VGND VGND VPWR VPWR net436 sky130_fd_sc_hd__buf_1
Xfanout425 net427 VGND VGND VPWR VPWR net425 sky130_fd_sc_hd__clkbuf_2
XFILLER_101_767 VPWR VGND VPWR VGND sky130_ef_sc_hd__decap_12
XFILLER_100_211 VGND VGND VPWR VPWR sky130_fd_sc_hd__decap_3
Xfanout458 net460 VGND VGND VPWR VPWR net458 sky130_fd_sc_hd__buf_2
Xfanout469 net473 VGND VGND VPWR VPWR net469 sky130_fd_sc_hd__clkbuf_4
X_09755_ _02298_ _02299_ VGND VGND VPWR VPWR _02301_ sky130_fd_sc_hd__xnor2_2
XFILLER_58_169 VGND VGND VPWR VPWR sky130_fd_sc_hd__fill_1
X_06967_ _02445_ _02964_ VGND VGND VPWR VPWR _02975_ sky130_fd_sc_hd__and2_1
X_09686_ _02109_ _02126_ _02125_ VGND VGND VPWR VPWR _02225_ sky130_fd_sc_hd__a21oi_1
X_08706_ net647 net36 net373 net657 VGND VGND VPWR VPWR _01173_ sky130_fd_sc_hd__a22o_1
XFILLER_73_128 VGND VGND VPWR VPWR sky130_fd_sc_hd__decap_4
XFILLER_64_27 VGND VGND VPWR VPWR sky130_fd_sc_hd__fill_1
X_06898_ _02118_ _02216_ VGND VGND VPWR VPWR _02227_ sky130_fd_sc_hd__xor2_1
X_08637_ _01101_ _01103_ VGND VGND VPWR VPWR _01104_ sky130_fd_sc_hd__and2b_1
XFILLER_70_813 VGND VGND VPWR VPWR sky130_fd_sc_hd__fill_2
XFILLER_54_353 VGND VGND VPWR VPWR sky130_fd_sc_hd__fill_1
XFILLER_54_331 VGND VGND VPWR VPWR sky130_fd_sc_hd__fill_2
X_08568_ _01006_ _01035_ VGND VGND VPWR VPWR _01036_ sky130_fd_sc_hd__and2_1
XFILLER_120_77 VGND VGND VPWR VPWR sky130_fd_sc_hd__decap_6
X_08499_ _00940_ _00943_ VGND VGND VPWR VPWR _00971_ sky130_fd_sc_hd__nor2_1
XFILLER_22_250 VGND VGND VPWR VPWR sky130_fd_sc_hd__fill_2
X_07519_ _06746_ _06747_ VGND VGND VPWR VPWR _06748_ sky130_fd_sc_hd__xnor2_1
X_10530_ _03138_ _03140_ _03137_ VGND VGND VPWR VPWR _03142_ sky130_fd_sc_hd__o21ai_1
XFILLER_6_427 VGND VGND VPWR VPWR sky130_fd_sc_hd__fill_1
XFILLER_6_416 VGND VGND VPWR VPWR sky130_fd_sc_hd__fill_1
X_10461_ _03066_ VGND VGND VPWR VPWR _03067_ sky130_fd_sc_hd__inv_2
XFILLER_108_322 VGND VGND VPWR VPWR sky130_fd_sc_hd__decap_4
X_12200_ _04812_ _04960_ VGND VGND VPWR VPWR _04961_ sky130_fd_sc_hd__xor2_1
XFILLER_108_355 VGND VGND VPWR VPWR sky130_fd_sc_hd__fill_1
X_13180_ _05929_ _05932_ _06030_ VGND VGND VPWR VPWR _06031_ sky130_fd_sc_hd__o21ba_1
XFILLER_89_57 VPWR VGND VPWR VGND sky130_ef_sc_hd__decap_12
X_10392_ _02988_ _02989_ _02987_ VGND VGND VPWR VPWR _02991_ sky130_fd_sc_hd__a21o_1
X_12131_ _04883_ _04884_ _04881_ VGND VGND VPWR VPWR _04886_ sky130_fd_sc_hd__a21bo_1
XFILLER_96_209 VPWR VGND VPWR VGND sky130_ef_sc_hd__decap_12
X_12062_ net403 _04755_ _04809_ VGND VGND VPWR VPWR _04810_ sky130_fd_sc_hd__a21bo_1
XFILLER_1_143 VGND VGND VPWR VPWR sky130_fd_sc_hd__fill_1
XFILLER_89_250 VPWR VGND VPWR VGND sky130_ef_sc_hd__decap_12
XFILLER_2_688 VPWR VGND VPWR VGND sky130_ef_sc_hd__decap_12
XFILLER_1_154 VGND VGND VPWR VPWR sky130_fd_sc_hd__decap_8
X_11013_ net636 net72 VGND VGND VPWR VPWR _03670_ sky130_fd_sc_hd__nand2_1
X_12964_ _05785_ _05794_ VGND VGND VPWR VPWR _05795_ sky130_fd_sc_hd__xnor2_1
XFILLER_38_83 VGND VGND VPWR VPWR sky130_fd_sc_hd__fill_1
X_11915_ _04635_ _04652_ VGND VGND VPWR VPWR _04653_ sky130_fd_sc_hd__xnor2_1
XFILLER_18_578 VGND VGND VPWR VPWR sky130_fd_sc_hd__decap_4
X_12895_ _05719_ _05718_ VGND VGND VPWR VPWR _05720_ sky130_fd_sc_hd__and2b_1
XFILLER_72_150 VPWR VGND VPWR VGND sky130_ef_sc_hd__decap_12
XFILLER_45_364 VGND VGND VPWR VPWR sky130_fd_sc_hd__fill_1
XFILLER_18_589 VGND VGND VPWR VPWR sky130_fd_sc_hd__decap_6
X_11846_ _04180_ _04498_ _04312_ VGND VGND VPWR VPWR _04578_ sky130_fd_sc_hd__or3b_1
X_11777_ _04313_ _04500_ _04501_ VGND VGND VPWR VPWR _04503_ sky130_fd_sc_hd__and3_1
XTAP_TAPCELL_ROW_119_2029 VGND VPWR sky130_fd_sc_hd__tapvpwrvgnd_1
XTAP_TAPCELL_ROW_119_2018 VGND VPWR sky130_fd_sc_hd__tapvpwrvgnd_1
X_13516_ _06178_ _06287_ _06286_ VGND VGND VPWR VPWR _06398_ sky130_fd_sc_hd__a21oi_1
XFILLER_9_221 VGND VGND VPWR VPWR sky130_fd_sc_hd__decap_3
X_10728_ _03070_ _03076_ _03202_ _03203_ _03357_ VGND VGND VPWR VPWR _03359_ sky130_fd_sc_hd__a41o_1
XTAP_TAPCELL_ROW_31_749 VGND VPWR sky130_fd_sc_hd__tapvpwrvgnd_1
XFILLER_118_119 VPWR VGND VPWR VGND sky130_ef_sc_hd__decap_12
XFILLER_118_108 VGND VGND VPWR VPWR sky130_fd_sc_hd__decap_4
XTAP_TAPCELL_ROW_132_2218 VGND VPWR sky130_fd_sc_hd__tapvpwrvgnd_1
XTAP_TAPCELL_ROW_132_2207 VGND VPWR sky130_fd_sc_hd__tapvpwrvgnd_1
X_13447_ _06318_ _06321_ VGND VGND VPWR VPWR _06322_ sky130_fd_sc_hd__and2b_1
XTAP_TAPCELL_ROW_11_462 VGND VPWR sky130_fd_sc_hd__tapvpwrvgnd_1
X_10659_ net416 net283 VGND VGND VPWR VPWR _03283_ sky130_fd_sc_hd__nand2_1
XFILLER_126_141 VGND VGND VPWR VPWR sky130_fd_sc_hd__fill_2
XFILLER_126_130 VGND VGND VPWR VPWR sky130_fd_sc_hd__fill_2
X_13378_ _06244_ _06245_ VGND VGND VPWR VPWR _06248_ sky130_fd_sc_hd__xnor2_1
X_12329_ _04959_ _05101_ VGND VGND VPWR VPWR _05102_ sky130_fd_sc_hd__xnor2_1
XTAP_TAPCELL_ROW_114_1951 VGND VPWR sky130_fd_sc_hd__tapvpwrvgnd_1
XFILLER_102_509 VGND VGND VPWR VPWR sky130_fd_sc_hd__fill_2
XFILLER_48_3 VPWR VGND VPWR VGND sky130_ef_sc_hd__decap_12
XFILLER_68_456 VPWR VGND VPWR VGND sky130_ef_sc_hd__decap_12
X_07870_ _00345_ _00346_ VGND VGND VPWR VPWR _00348_ sky130_fd_sc_hd__xor2_1
XFILLER_83_415 VPWR VGND VPWR VGND sky130_ef_sc_hd__decap_12
XFILLER_49_670 VGND VGND VPWR VPWR sky130_fd_sc_hd__fill_2
XFILLER_28_309 VGND VGND VPWR VPWR sky130_fd_sc_hd__fill_1
X_06821_ net410 VGND VGND VPWR VPWR _01387_ sky130_fd_sc_hd__inv_2
X_09540_ _01888_ _01899_ _01898_ VGND VGND VPWR VPWR _02066_ sky130_fd_sc_hd__a21oi_1
XFILLER_37_821 VGND VGND VPWR VPWR sky130_fd_sc_hd__decap_3
X_09471_ net367 _00259_ VGND VGND VPWR VPWR _01991_ sky130_fd_sc_hd__and2_1
XFILLER_52_813 VGND VGND VPWR VPWR sky130_fd_sc_hd__decap_6
XTAP_TAPCELL_ROW_19_573 VGND VPWR sky130_fd_sc_hd__tapvpwrvgnd_1
XFILLER_24_504 VGND VGND VPWR VPWR sky130_fd_sc_hd__decap_4
X_08422_ _00894_ _00895_ VGND VGND VPWR VPWR _00045_ sky130_fd_sc_hd__and2_1
XFILLER_24_548 VGND VGND VPWR VPWR sky130_fd_sc_hd__fill_2
XFILLER_36_397 VPWR VGND VPWR VGND sky130_ef_sc_hd__decap_12
X_08353_ net256 net661 _06633_ VGND VGND VPWR VPWR _00827_ sky130_fd_sc_hd__o21a_1
X_07304_ net638 net102 VGND VGND VPWR VPWR _06535_ sky130_fd_sc_hd__nand2_1
X_08284_ net253 _00758_ _00598_ VGND VGND VPWR VPWR _00759_ sky130_fd_sc_hd__o21a_1
XFILLER_137_417 VGND VGND VPWR VPWR sky130_fd_sc_hd__fill_1
XFILLER_109_119 VPWR VGND VPWR VGND sky130_ef_sc_hd__decap_12
XFILLER_50_29 VPWR VGND VPWR VGND sky130_ef_sc_hd__decap_12
X_07235_ _05886_ _05865_ VGND VGND VPWR VPWR _05897_ sky130_fd_sc_hd__and2b_1
XFILLER_117_141 VGND VGND VPWR VPWR sky130_fd_sc_hd__fill_1
XTAP_TAPCELL_ROW_76_1401 VGND VPWR sky130_fd_sc_hd__tapvpwrvgnd_1
X_07166_ _05111_ _05122_ _05133_ VGND VGND VPWR VPWR _05144_ sky130_fd_sc_hd__nand3_1
XFILLER_117_174 VGND VGND VPWR VPWR sky130_fd_sc_hd__fill_1
X_07097_ net571 net698 VGND VGND VPWR VPWR _04395_ sky130_fd_sc_hd__nand2_1
XFILLER_133_667 VGND VGND VPWR VPWR sky130_fd_sc_hd__decap_4
XFILLER_132_133 VGND VGND VPWR VPWR sky130_fd_sc_hd__decap_6
Xfanout255 _01582_ VGND VGND VPWR VPWR net255 sky130_fd_sc_hd__buf_4
XFILLER_115_55 VGND VGND VPWR VPWR sky130_fd_sc_hd__fill_1
XFILLER_113_380 VGND VGND VPWR VPWR sky130_fd_sc_hd__decap_4
X_09807_ _02356_ _02324_ VGND VGND VPWR VPWR _02357_ sky130_fd_sc_hd__and2b_1
Xfanout266 _01355_ VGND VGND VPWR VPWR net266 sky130_fd_sc_hd__buf_2
XFILLER_86_264 VPWR VGND VPWR VGND sky130_ef_sc_hd__decap_12
XFILLER_86_253 VGND VGND VPWR VPWR sky130_fd_sc_hd__decap_3
XFILLER_59_478 VGND VGND VPWR VPWR sky130_fd_sc_hd__fill_2
X_07999_ _00474_ _00475_ VGND VGND VPWR VPWR _00476_ sky130_fd_sc_hd__and2b_1
Xfanout299 net81 VGND VGND VPWR VPWR net299 sky130_fd_sc_hd__clkbuf_4
Xfanout288 net88 VGND VGND VPWR VPWR net288 sky130_fd_sc_hd__clkbuf_4
Xfanout277 net94 VGND VGND VPWR VPWR net277 sky130_fd_sc_hd__clkbuf_2
X_09738_ _02131_ _02132_ _02134_ VGND VGND VPWR VPWR _02283_ sky130_fd_sc_hd__o21bai_2
XFILLER_46_117 VGND VGND VPWR VPWR sky130_fd_sc_hd__fill_2
XFILLER_28_821 VGND VGND VPWR VPWR sky130_fd_sc_hd__decap_3
XTAP_TAPCELL_ROW_87_1563 VGND VPWR sky130_fd_sc_hd__tapvpwrvgnd_1
X_09669_ _02081_ _02087_ _02086_ VGND VGND VPWR VPWR _02207_ sky130_fd_sc_hd__a21o_1
XFILLER_70_621 VGND VGND VPWR VPWR sky130_fd_sc_hd__decap_8
XFILLER_70_610 VGND VGND VPWR VPWR sky130_fd_sc_hd__fill_1
XFILLER_15_515 VGND VGND VPWR VPWR sky130_fd_sc_hd__decap_6
X_12680_ _05485_ _05453_ VGND VGND VPWR VPWR _05486_ sky130_fd_sc_hd__and2b_1
X_11700_ _04170_ _04287_ _04285_ VGND VGND VPWR VPWR _04420_ sky130_fd_sc_hd__a21oi_1
XFILLER_91_69 VPWR VGND VPWR VGND sky130_ef_sc_hd__decap_12
X_11631_ _04310_ _04342_ VGND VGND VPWR VPWR _04344_ sky130_fd_sc_hd__xnor2_1
XFILLER_24_41 VPWR VGND VPWR VGND sky130_ef_sc_hd__decap_12
XFILLER_11_732 VPWR VGND VPWR VGND sky130_ef_sc_hd__decap_12
X_11562_ _04105_ _04268_ VGND VGND VPWR VPWR _04269_ sky130_fd_sc_hd__xor2_1
XFILLER_128_417 VGND VGND VPWR VPWR sky130_fd_sc_hd__decap_3
X_13301_ _06161_ _06162_ VGND VGND VPWR VPWR _06164_ sky130_fd_sc_hd__xnor2_2
XFILLER_7_725 VGND VGND VPWR VPWR sky130_fd_sc_hd__decap_3
X_10513_ _03120_ _03122_ VGND VGND VPWR VPWR _03123_ sky130_fd_sc_hd__nor2_1
XFILLER_6_235 VGND VGND VPWR VPWR sky130_fd_sc_hd__fill_2
XFILLER_10_264 VGND VGND VPWR VPWR sky130_fd_sc_hd__fill_1
X_11493_ net248 _04193_ VGND VGND VPWR VPWR _04194_ sky130_fd_sc_hd__or2_1
XFILLER_124_601 VPWR VGND VPWR VGND sky130_ef_sc_hd__decap_12
XFILLER_108_141 VGND VGND VPWR VPWR sky130_fd_sc_hd__fill_1
X_13232_ _05285_ _06087_ VGND VGND VPWR VPWR _06088_ sky130_fd_sc_hd__and2_1
XFILLER_6_268 VGND VGND VPWR VPWR sky130_fd_sc_hd__fill_1
X_10444_ _03043_ net237 _03038_ _03039_ VGND VGND VPWR VPWR _03048_ sky130_fd_sc_hd__o211ai_4
XFILLER_123_111 VGND VGND VPWR VPWR sky130_fd_sc_hd__fill_1
XFILLER_108_174 VGND VGND VPWR VPWR sky130_fd_sc_hd__fill_2
X_13163_ _05968_ _06012_ VGND VGND VPWR VPWR _06013_ sky130_fd_sc_hd__xnor2_2
X_10375_ net443 net90 _02970_ _02968_ VGND VGND VPWR VPWR _02972_ sky130_fd_sc_hd__a31o_1
XFILLER_124_656 VPWR VGND VPWR VGND sky130_ef_sc_hd__decap_12
X_12114_ net640 net405 _04705_ _04704_ VGND VGND VPWR VPWR _04867_ sky130_fd_sc_hd__a31o_1
XFILLER_97_518 VGND VGND VPWR VPWR sky130_fd_sc_hd__decap_3
X_13094_ net478 net397 net396 net487 VGND VGND VPWR VPWR _05937_ sky130_fd_sc_hd__a22oi_1
X_12045_ _04787_ _04789_ VGND VGND VPWR VPWR _04791_ sky130_fd_sc_hd__nor2_1
XFILLER_93_702 VGND VGND VPWR VPWR sky130_fd_sc_hd__decap_4
XFILLER_49_93 VGND VGND VPWR VPWR sky130_fd_sc_hd__decap_4
XFILLER_19_821 VGND VGND VPWR VPWR sky130_fd_sc_hd__decap_3
X_12947_ _05738_ _05775_ VGND VGND VPWR VPWR _05776_ sky130_fd_sc_hd__nand2b_1
XFILLER_34_813 VGND VGND VPWR VPWR sky130_fd_sc_hd__decap_8
XTAP_TAPCELL_ROW_36_819 VGND VPWR sky130_fd_sc_hd__tapvpwrvgnd_1
X_12878_ _05699_ _05700_ VGND VGND VPWR VPWR _05702_ sky130_fd_sc_hd__nor2_1
XFILLER_61_643 VGND VGND VPWR VPWR sky130_fd_sc_hd__fill_2
XFILLER_60_120 VGND VGND VPWR VPWR sky130_fd_sc_hd__decap_3
XTAP_TAPCELL_ROW_16_532 VGND VPWR sky130_fd_sc_hd__tapvpwrvgnd_1
X_11829_ _04448_ _04458_ _04450_ VGND VGND VPWR VPWR _04560_ sky130_fd_sc_hd__a21oi_1
XFILLER_60_197 VGND VGND VPWR VPWR sky130_fd_sc_hd__decap_4
XFILLER_119_428 VGND VGND VPWR VPWR sky130_fd_sc_hd__fill_2
XPHY_EDGE_ROW_112_Right_112 VGND VGND VPWR VPWR sky130_fd_sc_hd__decap_3
X_07020_ _03445_ _03467_ _03456_ VGND VGND VPWR VPWR _03554_ sky130_fd_sc_hd__a21o_1
XTAP_TAPCELL_ROW_58_1142 VGND VPWR sky130_fd_sc_hd__tapvpwrvgnd_1
XPHY_EDGE_ROW_49_Right_49 VGND VGND VPWR VPWR sky130_fd_sc_hd__decap_3
XFILLER_114_133 VGND VGND VPWR VPWR sky130_fd_sc_hd__fill_1
X_08971_ net447 net61 VGND VGND VPWR VPWR _01446_ sky130_fd_sc_hd__nand2_1
XFILLER_69_721 VGND VGND VPWR VPWR sky130_fd_sc_hd__decap_6
XTAP_TAPCELL_ROW_71_1331 VGND VPWR sky130_fd_sc_hd__tapvpwrvgnd_1
X_07922_ _00257_ _00262_ _00258_ VGND VGND VPWR VPWR _00400_ sky130_fd_sc_hd__a21oi_1
XFILLER_69_765 VPWR VGND VPWR VGND sky130_ef_sc_hd__decap_12
XFILLER_68_253 VGND VGND VPWR VPWR sky130_fd_sc_hd__decap_8
X_07853_ _00298_ _00330_ VGND VGND VPWR VPWR _00331_ sky130_fd_sc_hd__nand2b_1
XFILLER_83_201 VPWR VGND VPWR VGND sky130_ef_sc_hd__decap_12
XFILLER_56_437 VGND VGND VPWR VPWR sky130_fd_sc_hd__decap_3
XFILLER_84_779 VPWR VGND VPWR VGND sky130_ef_sc_hd__decap_12
X_07784_ _00257_ _00262_ VGND VGND VPWR VPWR _00263_ sky130_fd_sc_hd__xnor2_2
XPHY_EDGE_ROW_58_Right_58 VGND VGND VPWR VPWR sky130_fd_sc_hd__decap_3
X_09523_ _02044_ _02045_ _02043_ VGND VGND VPWR VPWR _02047_ sky130_fd_sc_hd__o21ba_1
XFILLER_36_161 VGND VGND VPWR VPWR sky130_fd_sc_hd__fill_2
XFILLER_37_673 VGND VGND VPWR VPWR sky130_fd_sc_hd__fill_2
XFILLER_37_695 VGND VGND VPWR VPWR sky130_fd_sc_hd__decap_8
X_09454_ _01618_ _01807_ _01809_ VGND VGND VPWR VPWR _01972_ sky130_fd_sc_hd__o21bai_1
XTAP_TAPCELL_ROW_69_1293 VGND VPWR sky130_fd_sc_hd__tapvpwrvgnd_1
X_09385_ _01891_ _01895_ VGND VGND VPWR VPWR _01897_ sky130_fd_sc_hd__xor2_1
XFILLER_101_57 VPWR VGND VPWR VGND sky130_ef_sc_hd__decap_12
X_08405_ _00851_ _00877_ VGND VGND VPWR VPWR _00879_ sky130_fd_sc_hd__xnor2_1
XFILLER_12_518 VGND VGND VPWR VPWR sky130_fd_sc_hd__fill_2
XTAP_TAPCELL_ROW_82_1493 VGND VPWR sky130_fd_sc_hd__tapvpwrvgnd_1
XTAP_TAPCELL_ROW_82_1482 VGND VPWR sky130_fd_sc_hd__tapvpwrvgnd_1
X_08336_ _00723_ _00735_ _00809_ VGND VGND VPWR VPWR _00810_ sky130_fd_sc_hd__and3_1
XFILLER_12_529 VGND VGND VPWR VPWR sky130_fd_sc_hd__decap_3
XFILLER_24_389 VPWR VGND VPWR VGND sky130_ef_sc_hd__decap_12
XFILLER_20_540 VGND VGND VPWR VPWR sky130_fd_sc_hd__fill_2
X_08267_ _00648_ _00741_ VGND VGND VPWR VPWR _00742_ sky130_fd_sc_hd__nor2_2
XPHY_EDGE_ROW_67_Right_67 VGND VGND VPWR VPWR sky130_fd_sc_hd__decap_3
X_07218_ _04329_ _05701_ VGND VGND VPWR VPWR _05712_ sky130_fd_sc_hd__nor2_1
X_08198_ _00294_ _00552_ _00551_ VGND VGND VPWR VPWR _00674_ sky130_fd_sc_hd__a21oi_2
XFILLER_118_494 VPWR VGND VPWR VGND sky130_ef_sc_hd__decap_12
X_07149_ _04849_ _04947_ VGND VGND VPWR VPWR _04958_ sky130_fd_sc_hd__xnor2_1
XFILLER_106_645 VGND VGND VPWR VPWR sky130_fd_sc_hd__decap_3
XFILLER_105_133 VPWR VGND VPWR VGND sky130_ef_sc_hd__decap_12
X_10160_ _02738_ _02740_ VGND VGND VPWR VPWR _02742_ sky130_fd_sc_hd__xnor2_1
XFILLER_10_65 VGND VGND VPWR VPWR sky130_fd_sc_hd__decap_6
X_10091_ _02633_ _02666_ VGND VGND VPWR VPWR _02667_ sky130_fd_sc_hd__xnor2_1
XFILLER_126_65 VPWR VGND VPWR VGND sky130_ef_sc_hd__decap_12
XFILLER_75_713 VGND VGND VPWR VPWR sky130_fd_sc_hd__fill_2
XPHY_EDGE_ROW_76_Right_76 VGND VGND VPWR VPWR sky130_fd_sc_hd__decap_3
XFILLER_59_275 VGND VGND VPWR VPWR sky130_fd_sc_hd__decap_4
XFILLER_47_437 VGND VGND VPWR VPWR sky130_fd_sc_hd__fill_1
XFILLER_19_63 VGND VGND VPWR VPWR sky130_fd_sc_hd__fill_1
XFILLER_19_139 VPWR VGND VPWR VGND sky130_ef_sc_hd__decap_12
X_12801_ _05577_ _05615_ VGND VGND VPWR VPWR _05617_ sky130_fd_sc_hd__xnor2_1
XFILLER_74_289 VPWR VGND VPWR VGND sky130_ef_sc_hd__decap_12
XFILLER_16_813 VGND VGND VPWR VPWR sky130_fd_sc_hd__decap_6
X_10993_ _03645_ _03646_ _03637_ VGND VGND VPWR VPWR _03648_ sky130_fd_sc_hd__a21o_1
X_12732_ _05540_ _05541_ _05359_ _05361_ VGND VGND VPWR VPWR _05543_ sky130_fd_sc_hd__a211o_1
XFILLER_43_632 VGND VGND VPWR VPWR sky130_fd_sc_hd__decap_6
XFILLER_35_51 VGND VGND VPWR VPWR sky130_fd_sc_hd__decap_4
XFILLER_42_153 VGND VGND VPWR VPWR sky130_fd_sc_hd__decap_8
XFILLER_15_356 VGND VGND VPWR VPWR sky130_fd_sc_hd__fill_2
X_12663_ _05466_ _05465_ VGND VGND VPWR VPWR _05467_ sky130_fd_sc_hd__and2b_1
XFILLER_42_197 VPWR VGND VPWR VGND sky130_ef_sc_hd__decap_12
X_12594_ _05389_ _05390_ _05391_ VGND VGND VPWR VPWR _05392_ sky130_fd_sc_hd__o21ai_1
XFILLER_7_500 VGND VGND VPWR VPWR sky130_fd_sc_hd__decap_4
X_11614_ _04324_ net249 VGND VGND VPWR VPWR _04325_ sky130_fd_sc_hd__nand2b_1
XFILLER_129_748 VPWR VGND VPWR VGND sky130_ef_sc_hd__decap_12
XPHY_EDGE_ROW_85_Right_85 VGND VGND VPWR VPWR sky130_fd_sc_hd__decap_3
XTAP_TAPCELL_ROW_41_899 VGND VPWR sky130_fd_sc_hd__tapvpwrvgnd_1
XTAP_TAPCELL_ROW_41_888 VGND VPWR sky130_fd_sc_hd__tapvpwrvgnd_1
XFILLER_7_511 VPWR VGND VPWR VGND sky130_ef_sc_hd__decap_12
X_11545_ net317 net316 net602 net598 VGND VGND VPWR VPWR _04250_ sky130_fd_sc_hd__and4b_1
X_11476_ _04173_ _04174_ VGND VGND VPWR VPWR _04175_ sky130_fd_sc_hd__nor2_1
XFILLER_109_461 VGND VGND VPWR VPWR sky130_fd_sc_hd__decap_6
X_13215_ _06035_ _06068_ VGND VGND VPWR VPWR _06069_ sky130_fd_sc_hd__nor2_1
X_10427_ _02846_ _03020_ _03028_ VGND VGND VPWR VPWR _03029_ sky130_fd_sc_hd__nand3_2
XFILLER_98_805 VGND VGND VPWR VPWR sky130_fd_sc_hd__decap_6
XTAP_TAPCELL_ROW_111_1910 VGND VPWR sky130_fd_sc_hd__tapvpwrvgnd_1
XFILLER_97_315 VPWR VGND VPWR VGND sky130_ef_sc_hd__decap_12
X_13146_ net613 net320 _05846_ _05845_ VGND VGND VPWR VPWR _05994_ sky130_fd_sc_hd__a31o_1
X_10358_ _02894_ _02896_ VGND VGND VPWR VPWR _02954_ sky130_fd_sc_hd__nand2b_1
XFILLER_112_648 VGND VGND VPWR VPWR sky130_fd_sc_hd__fill_1
XFILLER_111_136 VGND VGND VPWR VPWR sky130_fd_sc_hd__fill_1
X_13077_ net246 _05916_ VGND VGND VPWR VPWR _05918_ sky130_fd_sc_hd__xnor2_1
XFILLER_3_783 VGND VGND VPWR VPWR sky130_fd_sc_hd__fill_1
X_10289_ _02876_ _02878_ VGND VGND VPWR VPWR _02879_ sky130_fd_sc_hd__nand2_1
XFILLER_111_169 VGND VGND VPWR VPWR sky130_fd_sc_hd__decap_4
X_12028_ net565 net556 net711 net696 VGND VGND VPWR VPWR _04773_ sky130_fd_sc_hd__and4_1
XPHY_EDGE_ROW_94_Right_94 VGND VGND VPWR VPWR sky130_fd_sc_hd__decap_3
XFILLER_78_551 VGND VGND VPWR VPWR sky130_fd_sc_hd__decap_4
XFILLER_66_713 VPWR VGND VPWR VGND sky130_ef_sc_hd__decap_12
XTAP_TAPCELL_ROW_53_1072 VGND VPWR sky130_fd_sc_hd__tapvpwrvgnd_1
XTAP_TAPCELL_ROW_53_1061 VGND VPWR sky130_fd_sc_hd__tapvpwrvgnd_1
XPHY_EDGE_ROW_29_Left_168 VGND VGND VPWR VPWR sky130_fd_sc_hd__decap_3
XTAP_TAPCELL_ROW_127_2139 VGND VPWR sky130_fd_sc_hd__tapvpwrvgnd_1
XFILLER_66_757 VPWR VGND VPWR VGND sky130_ef_sc_hd__decap_12
XTAP_TAPCELL_ROW_109_1883 VGND VPWR sky130_fd_sc_hd__tapvpwrvgnd_1
XFILLER_81_716 VPWR VGND VPWR VGND sky130_ef_sc_hd__decap_12
XFILLER_19_673 VGND VGND VPWR VPWR sky130_fd_sc_hd__decap_6
XFILLER_25_109 VGND VGND VPWR VPWR sky130_fd_sc_hd__decap_3
XFILLER_19_695 VPWR VGND VPWR VGND sky130_ef_sc_hd__decap_12
XPHY_EDGE_ROW_1_Left_140 VGND VGND VPWR VPWR sky130_fd_sc_hd__decap_3
XFILLER_34_698 VGND VGND VPWR VPWR sky130_fd_sc_hd__fill_2
XPHY_EDGE_ROW_38_Left_177 VGND VGND VPWR VPWR sky130_fd_sc_hd__decap_3
X_09170_ _01632_ _01661_ VGND VGND VPWR VPWR _01663_ sky130_fd_sc_hd__xnor2_1
X_08121_ _00502_ _00512_ _00511_ VGND VGND VPWR VPWR _00597_ sky130_fd_sc_hd__a21o_1
X_08052_ _06658_ _00528_ VGND VGND VPWR VPWR _00529_ sky130_fd_sc_hd__xnor2_1
XFILLER_135_729 VPWR VGND VPWR VGND sky130_ef_sc_hd__decap_12
XFILLER_128_781 VPWR VGND VPWR VGND sky130_ef_sc_hd__decap_12
X_07003_ net268 net632 net622 net269 VGND VGND VPWR VPWR _03368_ sky130_fd_sc_hd__a22oi_1
XFILLER_115_420 VGND VGND VPWR VPWR sky130_fd_sc_hd__fill_1
XFILLER_130_401 VGND VGND VPWR VPWR sky130_fd_sc_hd__decap_4
XFILLER_115_486 VPWR VGND VPWR VGND sky130_ef_sc_hd__decap_12
XFILLER_115_475 VGND VGND VPWR VPWR sky130_fd_sc_hd__decap_6
XFILLER_103_615 VGND VGND VPWR VPWR sky130_fd_sc_hd__fill_1
X_08954_ _01425_ _01426_ VGND VGND VPWR VPWR _01427_ sky130_fd_sc_hd__nor2_1
XPHY_EDGE_ROW_47_Left_186 VGND VGND VPWR VPWR sky130_fd_sc_hd__decap_3
Xinput109 w31[3] VGND VGND VPWR VPWR net109 sky130_fd_sc_hd__dlymetal6s2s_1
X_07905_ _00245_ _00246_ _00248_ VGND VGND VPWR VPWR _00383_ sky130_fd_sc_hd__o21bai_2
X_08885_ _01270_ _01271_ _01347_ _01349_ VGND VGND VPWR VPWR _01352_ sky130_fd_sc_hd__o22a_1
XFILLER_69_573 VPWR VGND VPWR VGND sky130_ef_sc_hd__decap_12
XFILLER_84_543 VPWR VGND VPWR VGND sky130_ef_sc_hd__decap_12
X_07836_ _00312_ _00313_ VGND VGND VPWR VPWR _00314_ sky130_fd_sc_hd__xnor2_1
XTAP_TAPCELL_ROW_84_1511 VGND VPWR sky130_fd_sc_hd__tapvpwrvgnd_1
X_07767_ net710 net599 VGND VGND VPWR VPWR _00246_ sky130_fd_sc_hd__nand2b_1
XFILLER_56_289 VGND VGND VPWR VPWR sky130_fd_sc_hd__decap_8
XFILLER_44_418 VGND VGND VPWR VPWR sky130_fd_sc_hd__fill_2
X_09506_ _01907_ _01909_ _02027_ VGND VGND VPWR VPWR _02028_ sky130_fd_sc_hd__a21oi_2
XTAP_TAPCELL_ROW_84_1522 VGND VPWR sky130_fd_sc_hd__tapvpwrvgnd_1
XFILLER_72_749 VGND VGND VPWR VPWR sky130_fd_sc_hd__decap_6
XFILLER_112_89 VGND VGND VPWR VPWR sky130_fd_sc_hd__fill_1
XFILLER_72_27 VGND VGND VPWR VPWR sky130_fd_sc_hd__fill_1
XPHY_EDGE_ROW_56_Left_195 VGND VGND VPWR VPWR sky130_fd_sc_hd__decap_3
X_07698_ _00171_ _00175_ VGND VGND VPWR VPWR _00177_ sky130_fd_sc_hd__xor2_1
X_09437_ net438 net428 net333 net331 VGND VGND VPWR VPWR _01953_ sky130_fd_sc_hd__and4_1
XFILLER_9_809 VPWR VGND VPWR VGND sky130_ef_sc_hd__decap_12
XFILLER_40_613 VPWR VGND VPWR VGND sky130_ef_sc_hd__decap_12
X_09368_ _01876_ _01877_ VGND VGND VPWR VPWR _01879_ sky130_fd_sc_hd__nor2_1
XFILLER_8_319 VPWR VGND VPWR VGND sky130_ef_sc_hd__decap_12
X_09299_ _01782_ _01803_ VGND VGND VPWR VPWR _01804_ sky130_fd_sc_hd__xnor2_1
X_08319_ _00670_ _00672_ _00792_ VGND VGND VPWR VPWR _00794_ sky130_fd_sc_hd__nand3_1
X_11330_ _03536_ _03866_ _03865_ VGND VGND VPWR VPWR _04017_ sky130_fd_sc_hd__a21oi_1
XFILLER_20_381 VPWR VGND VPWR VGND sky130_ef_sc_hd__decap_12
XFILLER_138_589 VGND VGND VPWR VPWR sky130_fd_sc_hd__fill_2
XFILLER_115_3 VPWR VGND VPWR VGND sky130_ef_sc_hd__decap_12
XFILLER_21_64 VGND VGND VPWR VPWR sky130_fd_sc_hd__fill_2
XFILLER_118_291 VPWR VGND VPWR VGND sky130_ef_sc_hd__decap_12
XFILLER_118_280 VGND VGND VPWR VPWR sky130_fd_sc_hd__decap_6
XTAP_TAPCELL_ROW_95_1673 VGND VPWR sky130_fd_sc_hd__tapvpwrvgnd_1
X_11261_ _03935_ _03940_ VGND VGND VPWR VPWR _03941_ sky130_fd_sc_hd__and2_1
XFILLER_106_464 VPWR VGND VPWR VGND sky130_ef_sc_hd__decap_12
X_13000_ net606 net338 VGND VGND VPWR VPWR _05835_ sky130_fd_sc_hd__nand2_1
X_11192_ _03863_ _03864_ VGND VGND VPWR VPWR _03866_ sky130_fd_sc_hd__xnor2_1
X_10212_ _02795_ VGND VGND VPWR VPWR _02796_ sky130_fd_sc_hd__inv_2
X_10143_ _02648_ _02722_ VGND VGND VPWR VPWR _02723_ sky130_fd_sc_hd__nand2_1
XFILLER_97_57 VPWR VGND VPWR VGND sky130_ef_sc_hd__decap_12
XFILLER_79_337 VPWR VGND VPWR VGND sky130_ef_sc_hd__decap_12
XFILLER_0_742 VGND VGND VPWR VPWR sky130_fd_sc_hd__decap_8
X_10074_ net250 _02528_ VGND VGND VPWR VPWR _02648_ sky130_fd_sc_hd__or2_1
XFILLER_48_713 VGND VGND VPWR VPWR sky130_fd_sc_hd__fill_1
XTAP_TAPCELL_ROW_7_396 VGND VPWR sky130_fd_sc_hd__tapvpwrvgnd_1
XFILLER_0_797 VPWR VGND VPWR VGND sky130_ef_sc_hd__decap_12
XFILLER_90_502 VPWR VGND VPWR VGND sky130_ef_sc_hd__decap_12
XFILLER_75_565 VGND VGND VPWR VPWR sky130_fd_sc_hd__fill_1
XFILLER_62_204 VPWR VGND VPWR VGND sky130_ef_sc_hd__decap_12
XFILLER_47_267 VGND VGND VPWR VPWR sky130_fd_sc_hd__fill_1
XFILLER_90_557 VGND VGND VPWR VPWR sky130_fd_sc_hd__decap_8
XFILLER_62_237 VGND VGND VPWR VPWR sky130_fd_sc_hd__fill_1
XFILLER_46_83 VGND VGND VPWR VPWR sky130_fd_sc_hd__fill_1
XFILLER_16_621 VGND VGND VPWR VPWR sky130_fd_sc_hd__fill_1
XFILLER_16_643 VGND VGND VPWR VPWR sky130_fd_sc_hd__fill_1
XTAP_TAPCELL_ROW_122_2069 VGND VPWR sky130_fd_sc_hd__tapvpwrvgnd_1
XTAP_TAPCELL_ROW_46_969 VGND VPWR sky130_fd_sc_hd__tapvpwrvgnd_1
X_10976_ _03593_ _03628_ VGND VGND VPWR VPWR _03629_ sky130_fd_sc_hd__xnor2_1
XFILLER_31_602 VGND VGND VPWR VPWR sky130_fd_sc_hd__decap_3
X_12715_ _05522_ _05523_ VGND VGND VPWR VPWR _05524_ sky130_fd_sc_hd__and2b_1
XFILLER_15_164 VGND VGND VPWR VPWR sky130_fd_sc_hd__decap_4
XTAP_TAPCELL_ROW_26_671 VGND VPWR sky130_fd_sc_hd__tapvpwrvgnd_1
XTAP_TAPCELL_ROW_26_682 VGND VPWR sky130_fd_sc_hd__tapvpwrvgnd_1
X_13695_ clknet_3_1__leaf_clk _00041_ net713 VGND VGND VPWR VPWR net214 sky130_fd_sc_hd__dfrtp_1
X_12646_ _05399_ _05447_ VGND VGND VPWR VPWR _05448_ sky130_fd_sc_hd__and2b_1
XFILLER_87_7 VPWR VGND VPWR VGND sky130_ef_sc_hd__decap_12
XFILLER_70_292 VGND VGND VPWR VPWR sky130_fd_sc_hd__fill_1
XFILLER_30_123 VGND VGND VPWR VPWR sky130_fd_sc_hd__fill_1
XFILLER_31_657 VGND VGND VPWR VPWR sky130_fd_sc_hd__decap_6
XFILLER_129_578 VGND VGND VPWR VPWR sky130_fd_sc_hd__decap_4
X_12577_ _05312_ _05371_ VGND VGND VPWR VPWR _05373_ sky130_fd_sc_hd__xnor2_1
XFILLER_7_55 VGND VGND VPWR VPWR sky130_fd_sc_hd__fill_1
XFILLER_11_370 VGND VGND VPWR VPWR sky130_fd_sc_hd__decap_8
XTAP_TAPCELL_ROW_137_2290 VGND VPWR sky130_fd_sc_hd__tapvpwrvgnd_1
XFILLER_129_589 VGND VGND VPWR VPWR sky130_fd_sc_hd__fill_1
XFILLER_117_729 VGND VGND VPWR VPWR sky130_fd_sc_hd__fill_1
X_11528_ _04230_ _04231_ VGND VGND VPWR VPWR _04233_ sky130_fd_sc_hd__nor2_1
X_11459_ _04155_ _04157_ VGND VGND VPWR VPWR _04158_ sky130_fd_sc_hd__nor2_1
XFILLER_125_762 VGND VGND VPWR VPWR sky130_fd_sc_hd__fill_1
XFILLER_112_401 VPWR VGND VPWR VGND sky130_ef_sc_hd__decap_12
XFILLER_98_613 VGND VGND VPWR VPWR sky130_fd_sc_hd__fill_2
XTAP_TAPCELL_ROW_55_1101 VGND VPWR sky130_fd_sc_hd__tapvpwrvgnd_1
XFILLER_124_294 VGND VGND VPWR VPWR sky130_fd_sc_hd__fill_1
X_13129_ net418 net383 VGND VGND VPWR VPWR _05976_ sky130_fd_sc_hd__nand2_1
XFILLER_97_167 VGND VGND VPWR VPWR sky130_fd_sc_hd__fill_1
XFILLER_86_819 VGND VGND VPWR VPWR sky130_fd_sc_hd__fill_1
XFILLER_30_3 VPWR VGND VPWR VGND sky130_ef_sc_hd__decap_12
XFILLER_39_702 VGND VGND VPWR VPWR sky130_fd_sc_hd__fill_1
XFILLER_66_521 VGND VGND VPWR VPWR sky130_fd_sc_hd__fill_1
XFILLER_38_212 VGND VGND VPWR VPWR sky130_fd_sc_hd__decap_3
X_08670_ _01135_ _01136_ VGND VGND VPWR VPWR _01137_ sky130_fd_sc_hd__xor2_1
XFILLER_81_502 VGND VGND VPWR VPWR sky130_fd_sc_hd__fill_2
X_07621_ net709 net612 VGND VGND VPWR VPWR _00101_ sky130_fd_sc_hd__nand2_1
XFILLER_54_716 VGND VGND VPWR VPWR sky130_fd_sc_hd__fill_2
XFILLER_81_557 VGND VGND VPWR VPWR sky130_fd_sc_hd__decap_3
X_07552_ _06734_ _06780_ VGND VGND VPWR VPWR _06781_ sky130_fd_sc_hd__xor2_1
XTAP_TAPCELL_ROW_66_1263 VGND VPWR sky130_fd_sc_hd__tapvpwrvgnd_1
XTAP_TAPCELL_ROW_66_1252 VGND VPWR sky130_fd_sc_hd__tapvpwrvgnd_1
X_07483_ _06656_ _06711_ VGND VGND VPWR VPWR _06713_ sky130_fd_sc_hd__xnor2_1
X_09222_ _01408_ _01554_ _01555_ _01549_ VGND VGND VPWR VPWR _01719_ sky130_fd_sc_hd__a22oi_2
X_09153_ net652 net414 net41 VGND VGND VPWR VPWR _01644_ sky130_fd_sc_hd__and3_1
X_08104_ net252 _00472_ _00476_ VGND VGND VPWR VPWR _00580_ sky130_fd_sc_hd__or3_1
X_09084_ _01520_ _01567_ VGND VGND VPWR VPWR _01569_ sky130_fd_sc_hd__xnor2_1
XFILLER_108_729 VPWR VGND VPWR VGND sky130_ef_sc_hd__decap_12
X_08035_ _00503_ _00510_ VGND VGND VPWR VPWR _00512_ sky130_fd_sc_hd__xnor2_1
Xinput80 w21[6] VGND VGND VPWR VPWR net80 sky130_fd_sc_hd__buf_1
Xinput91 w23[1] VGND VGND VPWR VPWR net91 sky130_fd_sc_hd__buf_1
XFILLER_131_710 VGND VGND VPWR VPWR sky130_fd_sc_hd__decap_8
XFILLER_116_773 VGND VGND VPWR VPWR sky130_fd_sc_hd__fill_1
XFILLER_115_261 VGND VGND VPWR VPWR sky130_fd_sc_hd__decap_6
XFILLER_89_624 VGND VGND VPWR VPWR sky130_fd_sc_hd__fill_2
X_09986_ _02527_ _02551_ VGND VGND VPWR VPWR _02552_ sky130_fd_sc_hd__and2b_1
X_08937_ net490 net480 net352 net351 VGND VGND VPWR VPWR _01408_ sky130_fd_sc_hd__and4_1
XFILLER_57_510 VPWR VGND VPWR VGND sky130_ef_sc_hd__decap_12
XFILLER_130_297 VGND VGND VPWR VPWR sky130_fd_sc_hd__decap_8
X_08868_ _01331_ _01314_ _01333_ VGND VGND VPWR VPWR _01334_ sky130_fd_sc_hd__or3_4
XTAP_TAPCELL_ROW_4_355 VGND VPWR sky130_fd_sc_hd__tapvpwrvgnd_1
XFILLER_123_55 VGND VGND VPWR VPWR sky130_fd_sc_hd__fill_1
XFILLER_84_362 VGND VGND VPWR VPWR sky130_fd_sc_hd__fill_2
XFILLER_83_15 VPWR VGND VPWR VGND sky130_ef_sc_hd__decap_12
X_07819_ _00168_ _00183_ _00182_ VGND VGND VPWR VPWR _00297_ sky130_fd_sc_hd__o21a_1
XFILLER_29_267 VPWR VGND VPWR VGND sky130_ef_sc_hd__decap_12
X_08799_ _01263_ _01264_ VGND VGND VPWR VPWR _01265_ sky130_fd_sc_hd__xnor2_1
XPHY_EDGE_ROW_64_Left_203 VGND VGND VPWR VPWR sky130_fd_sc_hd__decap_3
XFILLER_17_429 VGND VGND VPWR VPWR sky130_fd_sc_hd__decap_3
XTAP_TAPCELL_ROW_43_917 VGND VPWR sky130_fd_sc_hd__tapvpwrvgnd_1
XFILLER_16_53 VPWR VGND VPWR VGND sky130_ef_sc_hd__decap_12
X_10830_ _03288_ _03291_ _03290_ VGND VGND VPWR VPWR _03470_ sky130_fd_sc_hd__o21bai_1
XFILLER_52_270 VGND VGND VPWR VPWR sky130_fd_sc_hd__decap_6
XTAP_TAPCELL_ROW_43_928 VGND VPWR sky130_fd_sc_hd__tapvpwrvgnd_1
X_10761_ net485 net295 net294 net494 VGND VGND VPWR VPWR _03394_ sky130_fd_sc_hd__a22oi_1
XFILLER_16_75 VGND VGND VPWR VPWR sky130_fd_sc_hd__decap_3
X_13480_ _06191_ _06206_ _06205_ VGND VGND VPWR VPWR _06359_ sky130_fd_sc_hd__o21bai_1
X_12500_ _05119_ _05121_ VGND VGND VPWR VPWR _05289_ sky130_fd_sc_hd__nand2_1
XFILLER_52_292 VPWR VGND VPWR VGND sky130_ef_sc_hd__decap_12
XFILLER_9_617 VGND VGND VPWR VPWR sky130_fd_sc_hd__decap_8
XTAP_TAPCELL_ROW_23_630 VGND VPWR sky130_fd_sc_hd__tapvpwrvgnd_1
X_10692_ net644 net318 net72 net651 VGND VGND VPWR VPWR _03319_ sky130_fd_sc_hd__a22oi_2
XFILLER_40_421 VPWR VGND VPWR VGND sky130_ef_sc_hd__decap_12
X_12431_ _05212_ _05211_ _05060_ _05062_ VGND VGND VPWR VPWR _05214_ sky130_fd_sc_hd__a211o_1
XFILLER_8_116 VGND VGND VPWR VPWR sky130_fd_sc_hd__decap_4
XTAP_TAPCELL_ROW_97_1702 VGND VPWR sky130_fd_sc_hd__tapvpwrvgnd_1
XFILLER_32_41 VPWR VGND VPWR VGND sky130_ef_sc_hd__decap_12
XFILLER_126_504 VGND VGND VPWR VPWR sky130_fd_sc_hd__fill_2
X_12362_ _05012_ _05137_ VGND VGND VPWR VPWR _05138_ sky130_fd_sc_hd__and2b_1
XPHY_EDGE_ROW_73_Left_212 VGND VGND VPWR VPWR sky130_fd_sc_hd__decap_3
XFILLER_4_300 VGND VGND VPWR VPWR sky130_fd_sc_hd__decap_8
XFILLER_32_85 VPWR VGND VPWR VGND sky130_ef_sc_hd__decap_12
X_12293_ _05060_ _05061_ _04941_ VGND VGND VPWR VPWR _05063_ sky130_fd_sc_hd__o21a_1
XFILLER_4_333 VPWR VGND VPWR VGND sky130_ef_sc_hd__decap_12
X_11313_ _03819_ _03848_ _03847_ VGND VGND VPWR VPWR _03998_ sky130_fd_sc_hd__a21o_1
X_11244_ net474 net291 net290 net483 VGND VGND VPWR VPWR _03922_ sky130_fd_sc_hd__a22oi_1
XFILLER_68_819 VGND VGND VPWR VPWR sky130_fd_sc_hd__fill_1
X_11175_ _03845_ _03846_ VGND VGND VPWR VPWR _03847_ sky130_fd_sc_hd__and2_1
X_10126_ _02702_ _02703_ VGND VGND VPWR VPWR _02704_ sky130_fd_sc_hd__or2_1
XFILLER_79_167 VGND VGND VPWR VPWR sky130_fd_sc_hd__fill_1
XTAP_TAPCELL_ROW_50_1020 VGND VPWR sky130_fd_sc_hd__tapvpwrvgnd_1
XFILLER_0_561 VGND VGND VPWR VPWR sky130_fd_sc_hd__fill_2
X_10057_ _02605_ _02628_ VGND VGND VPWR VPWR _02629_ sky130_fd_sc_hd__xor2_1
XFILLER_94_159 VGND VGND VPWR VPWR sky130_fd_sc_hd__decap_8
XTAP_TAPCELL_ROW_50_1031 VGND VPWR sky130_fd_sc_hd__tapvpwrvgnd_1
XFILLER_48_521 VGND VGND VPWR VPWR sky130_fd_sc_hd__fill_1
XPHY_EDGE_ROW_82_Left_221 VGND VGND VPWR VPWR sky130_fd_sc_hd__decap_3
XFILLER_63_513 VPWR VGND VPWR VGND sky130_ef_sc_hd__decap_12
XFILLER_36_716 VGND VGND VPWR VPWR sky130_fd_sc_hd__decap_6
XTAP_TAPCELL_ROW_106_1831 VGND VPWR sky130_fd_sc_hd__tapvpwrvgnd_1
XFILLER_63_546 VGND VGND VPWR VPWR sky130_fd_sc_hd__fill_1
XFILLER_36_738 VPWR VGND VPWR VGND sky130_ef_sc_hd__decap_12
XTAP_TAPCELL_ROW_106_1842 VGND VPWR sky130_fd_sc_hd__tapvpwrvgnd_1
XFILLER_90_365 VGND VGND VPWR VPWR sky130_fd_sc_hd__decap_6
XFILLER_44_793 VPWR VGND VPWR VGND sky130_ef_sc_hd__decap_12
X_10959_ _03600_ _03610_ VGND VGND VPWR VPWR _03611_ sky130_fd_sc_hd__xnor2_1
X_13678_ clknet_3_2__leaf_clk _00013_ net714 VGND VGND VPWR VPWR net197 sky130_fd_sc_hd__dfrtp_1
X_12629_ _05429_ net409 _06762_ VGND VGND VPWR VPWR _05430_ sky130_fd_sc_hd__and3b_1
XPHY_EDGE_ROW_91_Left_230 VGND VGND VPWR VPWR sky130_fd_sc_hd__decap_3
XFILLER_78_3 VPWR VGND VPWR VGND sky130_ef_sc_hd__decap_12
XTAP_TAPCELL_ROW_61_1182 VGND VPWR sky130_fd_sc_hd__tapvpwrvgnd_1
XTAP_TAPCELL_ROW_117_1993 VGND VPWR sky130_fd_sc_hd__tapvpwrvgnd_1
XFILLER_113_710 VGND VGND VPWR VPWR sky130_fd_sc_hd__decap_8
XFILLER_98_421 VPWR VGND VPWR VGND sky130_ef_sc_hd__decap_12
XFILLER_112_242 VGND VGND VPWR VPWR sky130_fd_sc_hd__decap_3
X_09840_ _02392_ _02393_ VGND VGND VPWR VPWR _02394_ sky130_fd_sc_hd__and2_1
Xfanout607 net608 VGND VGND VPWR VPWR net607 sky130_fd_sc_hd__clkbuf_4
Xfanout629 net635 VGND VGND VPWR VPWR net629 sky130_fd_sc_hd__buf_2
Xfanout618 net626 VGND VGND VPWR VPWR net618 sky130_fd_sc_hd__buf_2
X_09771_ _02172_ _02174_ _02178_ VGND VGND VPWR VPWR _02319_ sky130_fd_sc_hd__o21a_1
XFILLER_112_253 VPWR VGND VPWR VGND sky130_ef_sc_hd__decap_12
X_06983_ net459 net670 net451 net669 VGND VGND VPWR VPWR _03150_ sky130_fd_sc_hd__and4_1
X_08722_ _01178_ _01179_ _01186_ VGND VGND VPWR VPWR _01189_ sky130_fd_sc_hd__a21o_1
XFILLER_85_137 VPWR VGND VPWR VGND sky130_ef_sc_hd__decap_12
XTAP_TAPCELL_ROW_1_314 VGND VPWR sky130_fd_sc_hd__tapvpwrvgnd_1
X_08653_ _01091_ _01119_ VGND VGND VPWR VPWR _01120_ sky130_fd_sc_hd__xor2_1
XFILLER_94_693 VGND VGND VPWR VPWR sky130_fd_sc_hd__fill_1
XFILLER_93_181 VPWR VGND VPWR VGND sky130_ef_sc_hd__decap_12
X_08584_ net524 net351 _01000_ VGND VGND VPWR VPWR _01052_ sky130_fd_sc_hd__and3_1
X_07604_ _00081_ _00082_ _00074_ VGND VGND VPWR VPWR _00084_ sky130_fd_sc_hd__a21o_1
XFILLER_35_760 VPWR VGND VPWR VGND sky130_ef_sc_hd__decap_12
X_07535_ net571 net690 VGND VGND VPWR VPWR _06764_ sky130_fd_sc_hd__nand2_1
X_07466_ _06694_ _06695_ VGND VGND VPWR VPWR _06696_ sky130_fd_sc_hd__and2_1
XFILLER_34_281 VPWR VGND VPWR VGND sky130_ef_sc_hd__decap_12
X_09205_ net266 net364 _01522_ VGND VGND VPWR VPWR _01700_ sky130_fd_sc_hd__or3_1
X_07397_ _06625_ _06626_ VGND VGND VPWR VPWR _06627_ sky130_fd_sc_hd__and2b_1
XFILLER_136_813 VGND VGND VPWR VPWR sky130_fd_sc_hd__decap_8
X_09136_ _01622_ _01623_ _01624_ VGND VGND VPWR VPWR _01625_ sky130_fd_sc_hd__and3_1
XTAP_TAPCELL_ROW_79_1443 VGND VPWR sky130_fd_sc_hd__tapvpwrvgnd_1
X_09067_ net481 net351 _01273_ VGND VGND VPWR VPWR _01550_ sky130_fd_sc_hd__and3_1
XFILLER_78_15 VPWR VGND VPWR VGND sky130_ef_sc_hd__decap_12
X_08018_ _00493_ _00494_ VGND VGND VPWR VPWR _00495_ sky130_fd_sc_hd__nor2_1
XTAP_TAPCELL_ROW_9_425 VGND VPWR sky130_fd_sc_hd__tapvpwrvgnd_1
XFILLER_118_77 VGND VGND VPWR VPWR sky130_fd_sc_hd__decap_6
XTAP_TAPCELL_ROW_92_1632 VGND VPWR sky130_fd_sc_hd__tapvpwrvgnd_1
XTAP_TAPCELL_ROW_9_436 VGND VPWR sky130_fd_sc_hd__tapvpwrvgnd_1
XFILLER_103_231 VGND VGND VPWR VPWR sky130_fd_sc_hd__decap_6
XFILLER_89_465 VGND VGND VPWR VPWR sky130_fd_sc_hd__fill_1
X_09969_ _02363_ _02533_ VGND VGND VPWR VPWR _02534_ sky130_fd_sc_hd__and2b_1
XFILLER_103_275 VGND VGND VPWR VPWR sky130_fd_sc_hd__decap_4
XFILLER_134_65 VPWR VGND VPWR VGND sky130_ef_sc_hd__decap_12
XFILLER_85_671 VGND VGND VPWR VPWR sky130_fd_sc_hd__fill_1
X_12980_ _05779_ _05812_ VGND VGND VPWR VPWR _05813_ sky130_fd_sc_hd__xor2_1
XTAP_TAPCELL_ROW_28_700 VGND VPWR sky130_fd_sc_hd__tapvpwrvgnd_1
X_11931_ _04666_ _04667_ _04668_ VGND VGND VPWR VPWR _04669_ sky130_fd_sc_hd__or3_1
XFILLER_17_204 VGND VGND VPWR VPWR sky130_fd_sc_hd__decap_8
XTAP_TAPCELL_ROW_28_711 VGND VPWR sky130_fd_sc_hd__tapvpwrvgnd_1
X_11862_ _04486_ _04489_ _04594_ VGND VGND VPWR VPWR _04596_ sky130_fd_sc_hd__nor3_1
XFILLER_17_248 VGND VGND VPWR VPWR sky130_fd_sc_hd__decap_3
XFILLER_33_719 VGND VGND VPWR VPWR sky130_fd_sc_hd__fill_2
X_13601_ _06307_ _06333_ VGND VGND VPWR VPWR _06490_ sky130_fd_sc_hd__xnor2_1
XFILLER_13_410 VGND VGND VPWR VPWR sky130_fd_sc_hd__fill_2
X_10813_ _03416_ _03449_ VGND VGND VPWR VPWR _03451_ sky130_fd_sc_hd__xnor2_1
X_13532_ _06413_ _06414_ VGND VGND VPWR VPWR _06415_ sky130_fd_sc_hd__nand2_1
X_11793_ _04505_ _04519_ _04520_ VGND VGND VPWR VPWR _04521_ sky130_fd_sc_hd__or3_1
XFILLER_25_281 VGND VGND VPWR VPWR sky130_fd_sc_hd__decap_4
XTAP_TAPCELL_ROW_101_1761 VGND VPWR sky130_fd_sc_hd__tapvpwrvgnd_1
XFILLER_43_51 VGND VGND VPWR VPWR sky130_fd_sc_hd__decap_4
XFILLER_41_785 VPWR VGND VPWR VGND sky130_ef_sc_hd__decap_12
XFILLER_9_425 VGND VGND VPWR VPWR sky130_fd_sc_hd__decap_8
X_10744_ _03373_ _03374_ VGND VGND VPWR VPWR _03375_ sky130_fd_sc_hd__and2b_1
XFILLER_40_251 VGND VGND VPWR VPWR sky130_fd_sc_hd__fill_1
X_13463_ _06335_ _06339_ VGND VGND VPWR VPWR _06340_ sky130_fd_sc_hd__nand2b_1
XFILLER_9_447 VGND VGND VPWR VPWR sky130_fd_sc_hd__fill_1
X_10675_ _03152_ _03298_ _03299_ VGND VGND VPWR VPWR _03300_ sky130_fd_sc_hd__and3_1
XFILLER_126_301 VGND VGND VPWR VPWR sky130_fd_sc_hd__decap_6
X_13394_ _05476_ _06264_ VGND VGND VPWR VPWR _06265_ sky130_fd_sc_hd__xor2_1
X_12414_ _05038_ _05040_ _05193_ _05194_ VGND VGND VPWR VPWR _05195_ sky130_fd_sc_hd__a211o_1
XFILLER_126_345 VGND VGND VPWR VPWR sky130_fd_sc_hd__decap_8
X_12345_ net516 net507 net399 net401 VGND VGND VPWR VPWR _05119_ sky130_fd_sc_hd__nand4_1
XFILLER_114_507 VPWR VGND VPWR VGND sky130_ef_sc_hd__decap_12
XFILLER_4_141 VPWR VGND VPWR VGND sky130_ef_sc_hd__decap_12
XFILLER_99_229 VGND VGND VPWR VPWR sky130_fd_sc_hd__fill_1
X_12276_ _05040_ _05041_ _05042_ VGND VGND VPWR VPWR _05044_ sky130_fd_sc_hd__a21oi_2
XTAP_TAPCELL_ROW_130_2179 VGND VPWR sky130_fd_sc_hd__tapvpwrvgnd_1
X_11227_ _03902_ _03745_ VGND VGND VPWR VPWR _03903_ sky130_fd_sc_hd__nand2b_1
X_11158_ _03821_ _03826_ VGND VGND VPWR VPWR _03829_ sky130_fd_sc_hd__xor2_1
XFILLER_122_595 VGND VGND VPWR VPWR sky130_fd_sc_hd__decap_8
X_10109_ _02492_ _02590_ _02683_ VGND VGND VPWR VPWR _02686_ sky130_fd_sc_hd__a21o_1
XFILLER_110_757 VPWR VGND VPWR VGND sky130_ef_sc_hd__decap_12
XFILLER_110_735 VPWR VGND VPWR VGND sky130_ef_sc_hd__decap_12
XFILLER_95_446 VGND VGND VPWR VPWR sky130_fd_sc_hd__fill_2
XFILLER_0_391 VGND VGND VPWR VPWR sky130_fd_sc_hd__fill_1
X_11089_ _03567_ _03582_ _03581_ VGND VGND VPWR VPWR _03753_ sky130_fd_sc_hd__o21ai_2
XFILLER_82_118 VGND VGND VPWR VPWR sky130_fd_sc_hd__fill_1
XFILLER_76_682 VGND VGND VPWR VPWR sky130_fd_sc_hd__fill_2
XFILLER_91_641 VPWR VGND VPWR VGND sky130_ef_sc_hd__decap_12
XFILLER_51_505 VGND VGND VPWR VPWR sky130_fd_sc_hd__fill_1
XTAP_TAPCELL_ROW_63_1211 VGND VPWR sky130_fd_sc_hd__tapvpwrvgnd_1
X_07320_ _06548_ _06549_ _05210_ _05242_ VGND VGND VPWR VPWR _06551_ sky130_fd_sc_hd__o211ai_2
XFILLER_32_752 VGND VGND VPWR VPWR sky130_fd_sc_hd__decap_4
XFILLER_31_262 VGND VGND VPWR VPWR sky130_fd_sc_hd__fill_1
X_07251_ _06029_ _06050_ _06061_ VGND VGND VPWR VPWR _06072_ sky130_fd_sc_hd__nand3b_1
XFILLER_136_109 VPWR VGND VPWR VGND sky130_ef_sc_hd__decap_12
XFILLER_118_813 VGND VGND VPWR VPWR sky130_fd_sc_hd__decap_8
X_07182_ net240 _05297_ _03729_ _03762_ VGND VGND VPWR VPWR _05319_ sky130_fd_sc_hd__o211a_1
XFILLER_117_334 VGND VGND VPWR VPWR sky130_fd_sc_hd__fill_2
XFILLER_117_378 VGND VGND VPWR VPWR sky130_fd_sc_hd__fill_1
XFILLER_117_356 VPWR VGND VPWR VGND sky130_ef_sc_hd__decap_12
XFILLER_132_359 VGND VGND VPWR VPWR sky130_fd_sc_hd__decap_4
XTAP_TAPCELL_ROW_74_1373 VGND VPWR sky130_fd_sc_hd__tapvpwrvgnd_1
Xfanout404 net2 VGND VGND VPWR VPWR net404 sky130_fd_sc_hd__clkbuf_4
X_09823_ net255 _02373_ VGND VGND VPWR VPWR _02375_ sky130_fd_sc_hd__xnor2_1
XFILLER_113_573 VPWR VGND VPWR VGND sky130_ef_sc_hd__decap_12
XFILLER_99_785 VPWR VGND VPWR VGND sky130_ef_sc_hd__decap_12
Xfanout437 net440 VGND VGND VPWR VPWR net437 sky130_fd_sc_hd__buf_2
Xfanout426 net427 VGND VGND VPWR VPWR net426 sky130_fd_sc_hd__buf_2
XFILLER_58_104 VGND VGND VPWR VPWR sky130_fd_sc_hd__fill_2
Xfanout415 net417 VGND VGND VPWR VPWR net415 sky130_fd_sc_hd__clkbuf_4
XFILLER_48_29 VPWR VGND VPWR VGND sky130_ef_sc_hd__decap_12
Xfanout448 net157 VGND VGND VPWR VPWR net448 sky130_fd_sc_hd__clkbuf_8
XFILLER_86_446 VGND VGND VPWR VPWR sky130_fd_sc_hd__fill_1
Xfanout459 net460 VGND VGND VPWR VPWR net459 sky130_fd_sc_hd__buf_2
X_09754_ _02298_ _02299_ VGND VGND VPWR VPWR _02300_ sky130_fd_sc_hd__nand2b_1
XFILLER_101_779 VGND VGND VPWR VPWR sky130_fd_sc_hd__decap_4
XFILLER_86_468 VGND VGND VPWR VPWR sky130_fd_sc_hd__decap_8
XFILLER_67_671 VGND VGND VPWR VPWR sky130_fd_sc_hd__fill_1
X_06966_ _02920_ _02953_ VGND VGND VPWR VPWR _02964_ sky130_fd_sc_hd__xnor2_1
X_09685_ _02089_ _02102_ _02101_ VGND VGND VPWR VPWR _02224_ sky130_fd_sc_hd__o21ai_2
X_08705_ net639 net376 VGND VGND VPWR VPWR _01172_ sky130_fd_sc_hd__and2_1
X_06897_ _02194_ _02205_ VGND VGND VPWR VPWR _02216_ sky130_fd_sc_hd__and2_1
X_08636_ net586 net44 net362 net596 VGND VGND VPWR VPWR _01103_ sky130_fd_sc_hd__a22o_1
XPHY_EDGE_ROW_126_Right_126 VGND VGND VPWR VPWR sky130_fd_sc_hd__decap_3
XFILLER_15_708 VPWR VGND VPWR VGND sky130_ef_sc_hd__decap_12
XFILLER_27_568 VGND VGND VPWR VPWR sky130_fd_sc_hd__fill_2
XFILLER_82_685 VGND VGND VPWR VPWR sky130_fd_sc_hd__decap_3
X_08567_ _01031_ _01034_ VGND VGND VPWR VPWR _01035_ sky130_fd_sc_hd__xnor2_1
XFILLER_54_398 VGND VGND VPWR VPWR sky130_fd_sc_hd__decap_3
XFILLER_80_27 VGND VGND VPWR VPWR sky130_fd_sc_hd__fill_1
X_08498_ _00968_ _00969_ VGND VGND VPWR VPWR _00970_ sky130_fd_sc_hd__xnor2_1
XFILLER_23_785 VPWR VGND VPWR VGND sky130_ef_sc_hd__decap_12
X_07518_ net697 net546 VGND VGND VPWR VPWR _06747_ sky130_fd_sc_hd__nand2_1
X_07449_ net638 net102 net631 net707 VGND VGND VPWR VPWR _06679_ sky130_fd_sc_hd__nand4_1
XFILLER_50_593 VPWR VGND VPWR VGND sky130_ef_sc_hd__decap_12
XTAP_TAPCELL_ROW_33_780 VGND VPWR sky130_fd_sc_hd__tapvpwrvgnd_1
X_10460_ _02868_ _02880_ VGND VGND VPWR VPWR _03066_ sky130_fd_sc_hd__nor2_1
X_09119_ _01570_ _01606_ VGND VGND VPWR VPWR _01607_ sky130_fd_sc_hd__xnor2_1
X_10391_ _02987_ _02988_ _02989_ VGND VGND VPWR VPWR _02990_ sky130_fd_sc_hd__nand3_1
XFILLER_123_337 VGND VGND VPWR VPWR sky130_fd_sc_hd__fill_1
XFILLER_89_69 VPWR VGND VPWR VGND sky130_ef_sc_hd__decap_12
X_12130_ _04881_ _04883_ _04884_ VGND VGND VPWR VPWR _04885_ sky130_fd_sc_hd__nand3_1
XFILLER_123_359 VGND VGND VPWR VPWR sky130_fd_sc_hd__fill_1
X_12061_ net507 net19 net402 net516 VGND VGND VPWR VPWR _04809_ sky130_fd_sc_hd__a22o_1
XFILLER_8_3 VPWR VGND VPWR VGND sky130_ef_sc_hd__decap_12
XFILLER_2_656 VGND VGND VPWR VPWR sky130_fd_sc_hd__fill_1
XFILLER_1_111 VGND VGND VPWR VPWR sky130_fd_sc_hd__fill_1
XFILLER_89_262 VGND VGND VPWR VPWR sky130_fd_sc_hd__fill_2
XFILLER_49_104 VGND VGND VPWR VPWR sky130_fd_sc_hd__decap_8
X_11012_ net650 net644 net315 VGND VGND VPWR VPWR _03669_ sky130_fd_sc_hd__and3_1
XFILLER_131_381 VGND VGND VPWR VPWR sky130_fd_sc_hd__fill_2
XFILLER_49_126 VPWR VGND VPWR VGND sky130_ef_sc_hd__decap_12
XFILLER_46_811 VGND VGND VPWR VPWR sky130_fd_sc_hd__fill_1
XFILLER_18_502 VGND VGND VPWR VPWR sky130_fd_sc_hd__fill_1
X_12963_ _05791_ _05792_ VGND VGND VPWR VPWR _05794_ sky130_fd_sc_hd__xnor2_1
XFILLER_18_513 VPWR VGND VPWR VGND sky130_ef_sc_hd__decap_12
XFILLER_57_181 VPWR VGND VPWR VGND sky130_ef_sc_hd__decap_12
X_11914_ _04649_ _04651_ VGND VGND VPWR VPWR _04652_ sky130_fd_sc_hd__xnor2_1
X_12894_ _05451_ _05551_ _05550_ VGND VGND VPWR VPWR _05719_ sky130_fd_sc_hd__o21ba_1
XFILLER_72_162 VPWR VGND VPWR VGND sky130_ef_sc_hd__decap_12
XFILLER_72_195 VGND VGND VPWR VPWR sky130_fd_sc_hd__fill_1
XFILLER_72_184 VGND VGND VPWR VPWR sky130_fd_sc_hd__decap_3
X_11845_ _04180_ _04498_ VGND VGND VPWR VPWR _04577_ sky130_fd_sc_hd__nand2_1
XFILLER_33_549 VGND VGND VPWR VPWR sky130_fd_sc_hd__decap_3
X_11776_ _04500_ _04501_ _04313_ VGND VGND VPWR VPWR _04502_ sky130_fd_sc_hd__a21oi_1
XTAP_TAPCELL_ROW_119_2019 VGND VPWR sky130_fd_sc_hd__tapvpwrvgnd_1
X_13515_ _06303_ _06396_ VGND VGND VPWR VPWR _06397_ sky130_fd_sc_hd__xnor2_1
XFILLER_41_571 VGND VGND VPWR VPWR sky130_fd_sc_hd__decap_6
X_10727_ _03062_ _03068_ _03198_ _03199_ VGND VGND VPWR VPWR _03357_ sky130_fd_sc_hd__and4b_1
X_13446_ _06319_ _06320_ VGND VGND VPWR VPWR _06321_ sky130_fd_sc_hd__and2b_1
XFILLER_9_255 VPWR VGND VPWR VGND sky130_ef_sc_hd__decap_12
XTAP_TAPCELL_ROW_132_2219 VGND VPWR sky130_fd_sc_hd__tapvpwrvgnd_1
XTAP_TAPCELL_ROW_132_2208 VGND VPWR sky130_fd_sc_hd__tapvpwrvgnd_1
XTAP_TAPCELL_ROW_11_452 VGND VPWR sky130_fd_sc_hd__tapvpwrvgnd_1
XTAP_TAPCELL_ROW_11_463 VGND VPWR sky130_fd_sc_hd__tapvpwrvgnd_1
X_10658_ _03136_ _03146_ _03144_ VGND VGND VPWR VPWR _03282_ sky130_fd_sc_hd__a21o_1
X_13377_ _06245_ _06244_ VGND VGND VPWR VPWR _06246_ sky130_fd_sc_hd__and2b_1
X_10589_ _03204_ _03206_ VGND VGND VPWR VPWR _00021_ sky130_fd_sc_hd__and2b_1
X_12328_ _05090_ _05099_ VGND VGND VPWR VPWR _05101_ sky130_fd_sc_hd__xor2_1
XFILLER_126_197 VGND VGND VPWR VPWR sky130_fd_sc_hd__decap_4
XTAP_TAPCELL_ROW_114_1952 VGND VPWR sky130_fd_sc_hd__tapvpwrvgnd_1
X_12259_ net645 net656 net338 net320 VGND VGND VPWR VPWR _05026_ sky130_fd_sc_hd__and4_1
XPHY_EDGE_ROW_10_Left_149 VGND VGND VPWR VPWR sky130_fd_sc_hd__decap_3
X_06820_ net153 VGND VGND VPWR VPWR _01376_ sky130_fd_sc_hd__inv_2
XFILLER_110_565 VGND VGND VPWR VPWR sky130_fd_sc_hd__decap_3
XFILLER_68_468 VGND VGND VPWR VPWR sky130_fd_sc_hd__decap_8
XFILLER_110_587 VGND VGND VPWR VPWR sky130_fd_sc_hd__fill_1
XFILLER_95_276 VGND VGND VPWR VPWR sky130_fd_sc_hd__decap_4
XFILLER_83_449 VGND VGND VPWR VPWR sky130_fd_sc_hd__decap_4
XFILLER_83_427 VGND VGND VPWR VPWR sky130_fd_sc_hd__fill_1
X_09470_ net637 _01820_ VGND VGND VPWR VPWR _01990_ sky130_fd_sc_hd__nand2_1
XFILLER_64_652 VGND VGND VPWR VPWR sky130_fd_sc_hd__decap_8
XTAP_TAPCELL_ROW_19_574 VGND VPWR sky130_fd_sc_hd__tapvpwrvgnd_1
XFILLER_36_365 VPWR VGND VPWR VGND sky130_ef_sc_hd__decap_12
X_08421_ _00892_ _00893_ VGND VGND VPWR VPWR _00895_ sky130_fd_sc_hd__or2_1
X_08352_ _00644_ _00648_ VGND VGND VPWR VPWR _00826_ sky130_fd_sc_hd__nor2_1
X_07303_ _06530_ _06533_ VGND VGND VPWR VPWR _06534_ sky130_fd_sc_hd__xnor2_1
X_08283_ net677 net257 _00755_ _00756_ VGND VGND VPWR VPWR _00758_ sky130_fd_sc_hd__o22a_1
XFILLER_20_733 VGND VGND VPWR VPWR sky130_fd_sc_hd__decap_6
XFILLER_20_755 VGND VGND VPWR VPWR sky130_fd_sc_hd__fill_1
X_07234_ _02975_ _04449_ _05876_ VGND VGND VPWR VPWR _05886_ sky130_fd_sc_hd__a21oi_1
XFILLER_118_632 VPWR VGND VPWR VGND sky130_ef_sc_hd__decap_12
XFILLER_133_602 VGND VGND VPWR VPWR sky130_fd_sc_hd__decap_8
XFILLER_106_805 VGND VGND VPWR VPWR sky130_fd_sc_hd__decap_6
XTAP_TAPCELL_ROW_76_1402 VGND VPWR sky130_fd_sc_hd__tapvpwrvgnd_1
X_07165_ _03390_ _03412_ _03401_ VGND VGND VPWR VPWR _05133_ sky130_fd_sc_hd__a21bo_1
XFILLER_117_186 VPWR VGND VPWR VGND sky130_ef_sc_hd__decap_12
X_07096_ _04362_ _04373_ VGND VGND VPWR VPWR _04384_ sky130_fd_sc_hd__and2b_1
XFILLER_86_221 VPWR VGND VPWR VGND sky130_ef_sc_hd__decap_12
Xfanout256 _01387_ VGND VGND VPWR VPWR net256 sky130_fd_sc_hd__clkbuf_4
X_09806_ _02326_ _02354_ VGND VGND VPWR VPWR _02356_ sky130_fd_sc_hd__xnor2_1
XFILLER_101_576 VPWR VGND VPWR VGND sky130_ef_sc_hd__decap_12
Xfanout267 net99 VGND VGND VPWR VPWR net267 sky130_fd_sc_hd__buf_2
X_07998_ net682 net258 VGND VGND VPWR VPWR _00475_ sky130_fd_sc_hd__nor2_1
Xfanout289 net88 VGND VGND VPWR VPWR net289 sky130_fd_sc_hd__dlymetal6s2s_1
Xfanout278 net93 VGND VGND VPWR VPWR net278 sky130_fd_sc_hd__clkbuf_4
X_09737_ _02278_ _02279_ VGND VGND VPWR VPWR _02281_ sky130_fd_sc_hd__xor2_2
XFILLER_86_276 VPWR VGND VPWR VGND sky130_ef_sc_hd__decap_12
XFILLER_28_811 VGND VGND VPWR VPWR sky130_fd_sc_hd__fill_1
X_06949_ _02684_ _02771_ VGND VGND VPWR VPWR _02782_ sky130_fd_sc_hd__and2b_1
XFILLER_55_641 VGND VGND VPWR VPWR sky130_fd_sc_hd__decap_4
XTAP_TAPCELL_ROW_38_850 VGND VPWR sky130_fd_sc_hd__tapvpwrvgnd_1
XFILLER_39_181 VGND VGND VPWR VPWR sky130_fd_sc_hd__decap_4
XFILLER_131_55 VGND VGND VPWR VPWR sky130_fd_sc_hd__fill_1
X_09668_ _02056_ _02060_ _02059_ VGND VGND VPWR VPWR _02206_ sky130_fd_sc_hd__o21ai_1
XFILLER_91_15 VPWR VGND VPWR VGND sky130_ef_sc_hd__decap_12
XTAP_TAPCELL_ROW_87_1564 VGND VPWR sky130_fd_sc_hd__tapvpwrvgnd_1
XFILLER_15_527 VGND VGND VPWR VPWR sky130_fd_sc_hd__decap_4
XFILLER_27_376 VPWR VGND VPWR VGND sky130_ef_sc_hd__decap_12
X_08619_ net50 net349 _01017_ VGND VGND VPWR VPWR _01086_ sky130_fd_sc_hd__o21ai_1
X_09599_ net606 net372 VGND VGND VPWR VPWR _02131_ sky130_fd_sc_hd__nand2_1
XFILLER_54_184 VPWR VGND VPWR VGND sky130_ef_sc_hd__decap_12
X_11630_ _04342_ _04310_ VGND VGND VPWR VPWR _04343_ sky130_fd_sc_hd__and2b_1
XFILLER_70_699 VGND VGND VPWR VPWR sky130_fd_sc_hd__fill_1
XFILLER_24_53 VGND VGND VPWR VPWR sky130_fd_sc_hd__decap_6
XFILLER_24_75 VGND VGND VPWR VPWR sky130_fd_sc_hd__decap_8
X_11561_ _04266_ _04267_ VGND VGND VPWR VPWR _04268_ sky130_fd_sc_hd__xor2_1
X_13300_ _06161_ _06162_ VGND VGND VPWR VPWR _06163_ sky130_fd_sc_hd__nor2_1
XFILLER_50_390 VGND VGND VPWR VPWR sky130_fd_sc_hd__decap_3
XFILLER_7_704 VGND VGND VPWR VPWR sky130_fd_sc_hd__fill_1
XFILLER_11_744 VPWR VGND VPWR VGND sky130_ef_sc_hd__decap_12
X_10512_ net528 net292 _03121_ VGND VGND VPWR VPWR _03122_ sky130_fd_sc_hd__and3_1
X_11492_ _04191_ _04192_ VGND VGND VPWR VPWR _04193_ sky130_fd_sc_hd__nand2_1
XFILLER_109_654 VPWR VGND VPWR VGND sky130_ef_sc_hd__decap_12
X_13231_ net383 net412 VGND VGND VPWR VPWR _06087_ sky130_fd_sc_hd__and2b_1
X_10443_ _03043_ _03046_ _03045_ VGND VGND VPWR VPWR _03047_ sky130_fd_sc_hd__nor3b_1
XFILLER_40_41 VPWR VGND VPWR VGND sky130_ef_sc_hd__decap_12
XFILLER_136_484 VGND VGND VPWR VPWR sky130_fd_sc_hd__fill_2
XFILLER_124_613 VGND VGND VPWR VPWR sky130_fd_sc_hd__decap_4
XFILLER_109_698 VGND VGND VPWR VPWR sky130_fd_sc_hd__decap_6
X_13162_ _06009_ _06010_ VGND VGND VPWR VPWR _06012_ sky130_fd_sc_hd__xor2_2
X_10374_ _02968_ _02970_ VGND VGND VPWR VPWR _02971_ sky130_fd_sc_hd__and2b_1
XFILLER_40_85 VPWR VGND VPWR VGND sky130_ef_sc_hd__decap_12
XFILLER_124_668 VGND VGND VPWR VPWR sky130_fd_sc_hd__decap_8
XFILLER_123_145 VPWR VGND VPWR VGND sky130_ef_sc_hd__decap_12
XFILLER_108_197 VGND VGND VPWR VPWR sky130_fd_sc_hd__decap_8
X_12113_ _04863_ _04864_ _04851_ VGND VGND VPWR VPWR _04866_ sky130_fd_sc_hd__a21o_1
XFILLER_123_167 VGND VGND VPWR VPWR sky130_fd_sc_hd__fill_1
X_13093_ net487 net478 net397 net396 VGND VGND VPWR VPWR _05936_ sky130_fd_sc_hd__and4_1
X_12044_ _04787_ _04789_ VGND VGND VPWR VPWR _04790_ sky130_fd_sc_hd__and2_1
XFILLER_77_232 VGND VGND VPWR VPWR sky130_fd_sc_hd__fill_2
XFILLER_93_714 VGND VGND VPWR VPWR sky130_fd_sc_hd__decap_3
XTAP_TAPCELL_ROW_129_2170 VGND VPWR sky130_fd_sc_hd__tapvpwrvgnd_1
XFILLER_92_224 VGND VGND VPWR VPWR sky130_fd_sc_hd__decap_6
XFILLER_92_257 VGND VGND VPWR VPWR sky130_fd_sc_hd__fill_1
XFILLER_65_449 VPWR VGND VPWR VGND sky130_ef_sc_hd__decap_12
XFILLER_46_652 VGND VGND VPWR VPWR sky130_fd_sc_hd__decap_6
XFILLER_1_57 VPWR VGND VPWR VGND sky130_ef_sc_hd__decap_12
X_12946_ _05739_ _05773_ VGND VGND VPWR VPWR _05775_ sky130_fd_sc_hd__xnor2_1
XFILLER_18_365 VPWR VGND VPWR VGND sky130_ef_sc_hd__decap_12
X_12877_ _05526_ _05533_ _05532_ VGND VGND VPWR VPWR _05700_ sky130_fd_sc_hd__a21boi_1
XFILLER_46_696 VGND VGND VPWR VPWR sky130_fd_sc_hd__decap_4
XFILLER_45_184 VPWR VGND VPWR VGND sky130_ef_sc_hd__decap_12
XTAP_TAPCELL_ROW_16_533 VGND VPWR sky130_fd_sc_hd__tapvpwrvgnd_1
XFILLER_33_313 VPWR VGND VPWR VGND sky130_ef_sc_hd__decap_12
XFILLER_61_677 VGND VGND VPWR VPWR sky130_fd_sc_hd__fill_1
XFILLER_61_666 VGND VGND VPWR VPWR sky130_fd_sc_hd__fill_1
X_11828_ _04556_ _04557_ VGND VGND VPWR VPWR _04559_ sky130_fd_sc_hd__or2_1
X_11759_ _04467_ _04483_ VGND VGND VPWR VPWR _04484_ sky130_fd_sc_hd__or2_1
X_13429_ _06300_ _06302_ VGND VGND VPWR VPWR _06303_ sky130_fd_sc_hd__and2_1
XTAP_TAPCELL_ROW_58_1143 VGND VPWR sky130_fd_sc_hd__tapvpwrvgnd_1
XFILLER_6_781 VPWR VGND VPWR VGND sky130_ef_sc_hd__decap_12
XFILLER_130_605 VGND VGND VPWR VPWR sky130_fd_sc_hd__decap_6
X_08970_ _01440_ _01444_ VGND VGND VPWR VPWR _01445_ sky130_fd_sc_hd__xnor2_1
XTAP_TAPCELL_ROW_71_1332 VGND VPWR sky130_fd_sc_hd__tapvpwrvgnd_1
XFILLER_68_221 VPWR VGND VPWR VGND sky130_ef_sc_hd__decap_12
X_07921_ _00393_ _00398_ VGND VGND VPWR VPWR _00399_ sky130_fd_sc_hd__xnor2_2
XFILLER_69_777 VGND VGND VPWR VPWR sky130_fd_sc_hd__decap_6
X_07852_ _00316_ _00329_ VGND VGND VPWR VPWR _00330_ sky130_fd_sc_hd__xor2_2
XFILLER_83_213 VGND VGND VPWR VPWR sky130_fd_sc_hd__decap_8
Xinput1 rst_n VGND VGND VPWR VPWR net1 sky130_fd_sc_hd__buf_2
X_09522_ _02044_ _02045_ _02043_ VGND VGND VPWR VPWR _02046_ sky130_fd_sc_hd__nor3b_1
XFILLER_110_395 VPWR VGND VPWR VGND sky130_ef_sc_hd__decap_12
X_07783_ _00260_ _00261_ _00107_ VGND VGND VPWR VPWR _00262_ sky130_fd_sc_hd__a21bo_1
XFILLER_71_408 VPWR VGND VPWR VGND sky130_ef_sc_hd__decap_12
X_09453_ _01951_ _01970_ VGND VGND VPWR VPWR _01971_ sky130_fd_sc_hd__xor2_1
XTAP_TAPCELL_ROW_69_1294 VGND VPWR sky130_fd_sc_hd__tapvpwrvgnd_1
XFILLER_51_110 VGND VGND VPWR VPWR sky130_fd_sc_hd__fill_2
X_09384_ _01891_ _01895_ VGND VGND VPWR VPWR _01896_ sky130_fd_sc_hd__and2b_1
XFILLER_52_666 VGND VGND VPWR VPWR sky130_fd_sc_hd__decap_6
X_08404_ _00877_ _00851_ VGND VGND VPWR VPWR _00878_ sky130_fd_sc_hd__nand2b_1
XFILLER_101_69 VPWR VGND VPWR VGND sky130_ef_sc_hd__decap_12
XTAP_TAPCELL_ROW_82_1483 VGND VPWR sky130_fd_sc_hd__tapvpwrvgnd_1
X_08335_ _00724_ _00808_ VGND VGND VPWR VPWR _00809_ sky130_fd_sc_hd__xnor2_1
XFILLER_61_18 VPWR VGND VPWR VGND sky130_ef_sc_hd__decap_12
XFILLER_51_198 VGND VGND VPWR VPWR sky130_fd_sc_hd__decap_3
XFILLER_138_727 VGND VGND VPWR VPWR sky130_fd_sc_hd__fill_1
XTAP_TAPCELL_ROW_82_1494 VGND VPWR sky130_fd_sc_hd__tapvpwrvgnd_1
X_08266_ net417 net661 _00646_ VGND VGND VPWR VPWR _00741_ sky130_fd_sc_hd__a21oi_1
XFILLER_20_563 VPWR VGND VPWR VGND sky130_ef_sc_hd__decap_12
XFILLER_137_248 VGND VGND VPWR VPWR sky130_fd_sc_hd__fill_2
X_07217_ _05679_ _05690_ VGND VGND VPWR VPWR _05701_ sky130_fd_sc_hd__nand2_1
X_08197_ _00431_ _00671_ VGND VGND VPWR VPWR _00673_ sky130_fd_sc_hd__xnor2_2
X_07148_ _04926_ _04937_ VGND VGND VPWR VPWR _04947_ sky130_fd_sc_hd__nor2_1
XFILLER_133_432 VPWR VGND VPWR VGND sky130_ef_sc_hd__decap_12
XFILLER_105_145 VGND VGND VPWR VPWR sky130_fd_sc_hd__fill_2
X_07079_ _02380_ _04156_ _04188_ VGND VGND VPWR VPWR _04199_ sky130_fd_sc_hd__and3_1
X_10090_ _02634_ _02665_ VGND VGND VPWR VPWR _02666_ sky130_fd_sc_hd__xor2_1
XFILLER_126_77 VGND VGND VPWR VPWR sky130_fd_sc_hd__decap_6
XFILLER_99_390 VGND VGND VPWR VPWR sky130_fd_sc_hd__fill_2
XFILLER_47_416 VGND VGND VPWR VPWR sky130_fd_sc_hd__fill_2
XFILLER_19_129 VGND VGND VPWR VPWR sky130_fd_sc_hd__decap_3
X_12800_ _05577_ _05615_ VGND VGND VPWR VPWR _05616_ sky130_fd_sc_hd__nand2_1
XFILLER_90_706 VGND VGND VPWR VPWR sky130_fd_sc_hd__decap_8
XFILLER_74_246 VGND VGND VPWR VPWR sky130_fd_sc_hd__decap_6
XFILLER_47_449 VGND VGND VPWR VPWR sky130_fd_sc_hd__decap_3
XFILLER_90_739 VGND VGND VPWR VPWR sky130_fd_sc_hd__fill_1
XFILLER_55_471 VGND VGND VPWR VPWR sky130_fd_sc_hd__decap_4
XFILLER_43_611 VGND VGND VPWR VPWR sky130_fd_sc_hd__fill_1
XFILLER_15_302 VGND VGND VPWR VPWR sky130_fd_sc_hd__decap_8
X_10992_ _03637_ _03645_ _03646_ VGND VGND VPWR VPWR _03647_ sky130_fd_sc_hd__nand3_1
XFILLER_27_140 VPWR VGND VPWR VGND sky130_ef_sc_hd__decap_12
XFILLER_28_663 VGND VGND VPWR VPWR sky130_fd_sc_hd__fill_1
X_12731_ _05359_ _05361_ _05540_ _05541_ VGND VGND VPWR VPWR _05542_ sky130_fd_sc_hd__o211ai_2
XFILLER_42_121 VGND VGND VPWR VPWR sky130_fd_sc_hd__decap_4
XFILLER_15_335 VGND VGND VPWR VPWR sky130_fd_sc_hd__fill_1
X_12662_ _05284_ _05285_ _05283_ VGND VGND VPWR VPWR _05466_ sky130_fd_sc_hd__a21oi_1
XFILLER_42_176 VPWR VGND VPWR VGND sky130_ef_sc_hd__decap_12
X_11613_ _04214_ _04216_ _04213_ VGND VGND VPWR VPWR _04324_ sky130_fd_sc_hd__a21oi_1
XFILLER_15_379 VPWR VGND VPWR VGND sky130_ef_sc_hd__decap_12
XFILLER_129_716 VPWR VGND VPWR VGND sky130_ef_sc_hd__decap_12
X_12593_ _05216_ _05219_ _05215_ VGND VGND VPWR VPWR _05391_ sky130_fd_sc_hd__a21oi_2
XFILLER_23_390 VGND VGND VPWR VPWR sky130_fd_sc_hd__fill_2
XTAP_TAPCELL_ROW_41_889 VGND VPWR sky130_fd_sc_hd__tapvpwrvgnd_1
XFILLER_7_523 VGND VGND VPWR VPWR sky130_fd_sc_hd__decap_6
XFILLER_11_552 VGND VGND VPWR VPWR sky130_fd_sc_hd__decap_3
X_11544_ net602 net316 net317 net261 VGND VGND VPWR VPWR _04249_ sky130_fd_sc_hd__o2bb2a_1
XFILLER_51_95 VGND VGND VPWR VPWR sky130_fd_sc_hd__fill_1
X_11475_ net535 net301 net304 net263 VGND VGND VPWR VPWR _04174_ sky130_fd_sc_hd__o2bb2a_1
X_13214_ _06051_ _06067_ VGND VGND VPWR VPWR _06068_ sky130_fd_sc_hd__xnor2_1
X_10426_ _03016_ _03018_ _03017_ VGND VGND VPWR VPWR _03028_ sky130_fd_sc_hd__a21o_1
XFILLER_124_421 VPWR VGND VPWR VGND sky130_ef_sc_hd__decap_12
XTAP_TAPCELL_ROW_111_1911 VGND VPWR sky130_fd_sc_hd__tapvpwrvgnd_1
XFILLER_97_305 VGND VGND VPWR VPWR sky130_fd_sc_hd__fill_2
X_13145_ _05835_ _05836_ _05838_ VGND VGND VPWR VPWR _05993_ sky130_fd_sc_hd__o21bai_2
X_10357_ _02893_ _02950_ _02951_ VGND VGND VPWR VPWR _02952_ sky130_fd_sc_hd__a21o_1
XFILLER_97_327 VGND VGND VPWR VPWR sky130_fd_sc_hd__decap_3
X_13076_ net246 _05916_ VGND VGND VPWR VPWR _05917_ sky130_fd_sc_hd__nand2b_1
X_10288_ _02829_ _02875_ VGND VGND VPWR VPWR _02878_ sky130_fd_sc_hd__or2_1
X_12027_ _04770_ VGND VGND VPWR VPWR _04771_ sky130_fd_sc_hd__inv_2
XTAP_TAPCELL_ROW_53_1073 VGND VPWR sky130_fd_sc_hd__tapvpwrvgnd_1
XTAP_TAPCELL_ROW_53_1062 VGND VPWR sky130_fd_sc_hd__tapvpwrvgnd_1
XFILLER_120_671 VPWR VGND VPWR VGND sky130_ef_sc_hd__decap_12
XFILLER_93_500 VGND VGND VPWR VPWR sky130_fd_sc_hd__fill_1
XFILLER_66_725 VPWR VGND VPWR VGND sky130_ef_sc_hd__decap_12
XFILLER_38_405 VGND VGND VPWR VPWR sky130_fd_sc_hd__decap_8
XFILLER_38_427 VGND VGND VPWR VPWR sky130_fd_sc_hd__decap_3
XFILLER_66_769 VGND VGND VPWR VPWR sky130_fd_sc_hd__fill_1
XTAP_TAPCELL_ROW_109_1873 VGND VPWR sky130_fd_sc_hd__tapvpwrvgnd_1
XFILLER_65_279 VGND VGND VPWR VPWR sky130_fd_sc_hd__fill_1
XTAP_TAPCELL_ROW_109_1884 VGND VPWR sky130_fd_sc_hd__tapvpwrvgnd_1
X_12929_ _05753_ _05754_ VGND VGND VPWR VPWR _05757_ sky130_fd_sc_hd__xnor2_1
XFILLER_74_791 VGND VGND VPWR VPWR sky130_fd_sc_hd__decap_3
XFILLER_18_195 VGND VGND VPWR VPWR sky130_fd_sc_hd__fill_1
XFILLER_33_165 VGND VGND VPWR VPWR sky130_fd_sc_hd__decap_3
X_08120_ _00485_ _00496_ _00495_ VGND VGND VPWR VPWR _00596_ sky130_fd_sc_hd__a21o_1
X_08051_ _00525_ _00526_ VGND VGND VPWR VPWR _00528_ sky130_fd_sc_hd__xnor2_1
XFILLER_134_229 VGND VGND VPWR VPWR sky130_fd_sc_hd__fill_2
XFILLER_128_793 VPWR VGND VPWR VGND sky130_ef_sc_hd__decap_12
X_07002_ net268 net269 net632 net622 VGND VGND VPWR VPWR _03358_ sky130_fd_sc_hd__and4_1
XFILLER_127_281 VGND VGND VPWR VPWR sky130_fd_sc_hd__fill_2
XFILLER_0_209 VGND VGND VPWR VPWR sky130_fd_sc_hd__decap_4
X_08953_ _01423_ _01424_ _01297_ VGND VGND VPWR VPWR _01426_ sky130_fd_sc_hd__a21oi_1
XFILLER_115_498 VGND VGND VPWR VPWR sky130_fd_sc_hd__decap_6
XPHY_EDGE_ROW_102_Left_241 VGND VGND VPWR VPWR sky130_fd_sc_hd__decap_3
XFILLER_102_137 VGND VGND VPWR VPWR sky130_fd_sc_hd__decap_3
X_07904_ _00365_ _00381_ VGND VGND VPWR VPWR _00382_ sky130_fd_sc_hd__xor2_2
X_08884_ _01270_ _01347_ _01271_ _01349_ VGND VGND VPWR VPWR _01351_ sky130_fd_sc_hd__or4_4
XFILLER_69_585 VPWR VGND VPWR VGND sky130_ef_sc_hd__decap_12
XFILLER_56_29 VPWR VGND VPWR VGND sky130_ef_sc_hd__decap_12
XFILLER_29_405 VGND VGND VPWR VPWR sky130_fd_sc_hd__fill_1
XFILLER_84_555 VGND VGND VPWR VPWR sky130_fd_sc_hd__decap_6
X_07835_ _00159_ _00162_ _00158_ VGND VGND VPWR VPWR _00313_ sky130_fd_sc_hd__a21oi_1
X_07766_ net709 net605 VGND VGND VPWR VPWR _00245_ sky130_fd_sc_hd__nand2_1
X_09505_ _01700_ _01886_ _01885_ VGND VGND VPWR VPWR _02027_ sky130_fd_sc_hd__o21a_1
XTAP_TAPCELL_ROW_84_1523 VGND VPWR sky130_fd_sc_hd__tapvpwrvgnd_1
XTAP_TAPCELL_ROW_84_1512 VGND VPWR sky130_fd_sc_hd__tapvpwrvgnd_1
X_09436_ _01805_ _01812_ _01811_ VGND VGND VPWR VPWR _01952_ sky130_fd_sc_hd__a21oi_1
X_07697_ _00171_ _00175_ VGND VGND VPWR VPWR _00176_ sky130_fd_sc_hd__and2b_1
XPHY_EDGE_ROW_111_Left_250 VGND VGND VPWR VPWR sky130_fd_sc_hd__decap_3
XFILLER_12_305 VGND VGND VPWR VPWR sky130_fd_sc_hd__decap_3
XFILLER_24_176 VGND VGND VPWR VPWR sky130_fd_sc_hd__decap_3
XFILLER_40_625 VGND VGND VPWR VPWR sky130_fd_sc_hd__fill_2
X_09367_ _01874_ _01875_ VGND VGND VPWR VPWR _01877_ sky130_fd_sc_hd__nor2_1
X_09298_ _01800_ _01801_ VGND VGND VPWR VPWR _01803_ sky130_fd_sc_hd__nor2_1
XFILLER_20_360 VGND VGND VPWR VPWR sky130_fd_sc_hd__decap_4
X_08318_ _00670_ _00672_ _00792_ VGND VGND VPWR VPWR _00793_ sky130_fd_sc_hd__a21oi_1
X_08249_ _00722_ _00723_ VGND VGND VPWR VPWR _00724_ sky130_fd_sc_hd__nand2_2
XFILLER_20_393 VGND VGND VPWR VPWR sky130_fd_sc_hd__fill_1
XFILLER_119_782 VGND VGND VPWR VPWR sky130_fd_sc_hd__fill_2
XFILLER_108_3 VPWR VGND VPWR VGND sky130_ef_sc_hd__decap_12
XFILLER_106_421 VPWR VGND VPWR VGND sky130_ef_sc_hd__decap_12
XTAP_TAPCELL_ROW_95_1674 VGND VPWR sky130_fd_sc_hd__tapvpwrvgnd_1
X_11260_ _03617_ _03939_ VGND VGND VPWR VPWR _03940_ sky130_fd_sc_hd__xnor2_1
XFILLER_79_305 VGND VGND VPWR VPWR sky130_fd_sc_hd__decap_8
X_11191_ _03863_ _03864_ VGND VGND VPWR VPWR _03865_ sky130_fd_sc_hd__and2b_1
X_10211_ net655 net327 net283 net468 VGND VGND VPWR VPWR _02795_ sky130_fd_sc_hd__a22o_1
X_10142_ net250 _02528_ VGND VGND VPWR VPWR _02722_ sky130_fd_sc_hd__nand2_1
XFILLER_121_435 VGND VGND VPWR VPWR sky130_fd_sc_hd__decap_3
XFILLER_121_413 VGND VGND VPWR VPWR sky130_fd_sc_hd__decap_8
XFILLER_97_69 VPWR VGND VPWR VGND sky130_ef_sc_hd__decap_12
XFILLER_79_327 VGND VGND VPWR VPWR sky130_fd_sc_hd__decap_8
XFILLER_0_721 VGND VGND VPWR VPWR sky130_fd_sc_hd__decap_3
Xoutput190 net190 VGND VGND VPWR VPWR y1[4] sky130_fd_sc_hd__buf_2
X_10073_ _02056_ _02478_ _02476_ VGND VGND VPWR VPWR _02647_ sky130_fd_sc_hd__o21ai_1
XFILLER_75_511 VGND VGND VPWR VPWR sky130_fd_sc_hd__decap_8
XFILLER_75_500 VGND VGND VPWR VPWR sky130_fd_sc_hd__decap_4
XFILLER_47_213 VGND VGND VPWR VPWR sky130_fd_sc_hd__decap_3
XTAP_TAPCELL_ROW_7_397 VGND VPWR sky130_fd_sc_hd__tapvpwrvgnd_1
XFILLER_101_181 VPWR VGND VPWR VGND sky130_ef_sc_hd__decap_12
XFILLER_75_544 VPWR VGND VPWR VGND sky130_ef_sc_hd__decap_12
XFILLER_90_514 VGND VGND VPWR VPWR sky130_fd_sc_hd__fill_2
XFILLER_47_279 VGND VGND VPWR VPWR sky130_fd_sc_hd__fill_1
XFILLER_35_408 VGND VGND VPWR VPWR sky130_fd_sc_hd__decap_8
XFILLER_62_216 VGND VGND VPWR VPWR sky130_fd_sc_hd__decap_8
XTAP_TAPCELL_ROW_46_959 VGND VPWR sky130_fd_sc_hd__tapvpwrvgnd_1
XFILLER_16_611 VGND VGND VPWR VPWR sky130_fd_sc_hd__fill_1
XFILLER_28_471 VGND VGND VPWR VPWR sky130_fd_sc_hd__decap_4
XFILLER_90_569 VPWR VGND VPWR VGND sky130_ef_sc_hd__decap_12
X_12714_ net621 net338 net320 net630 VGND VGND VPWR VPWR _05523_ sky130_fd_sc_hd__a22o_1
X_10975_ _03594_ _03626_ VGND VGND VPWR VPWR _03628_ sky130_fd_sc_hd__xnor2_1
XFILLER_71_783 VGND VGND VPWR VPWR sky130_fd_sc_hd__fill_1
X_13694_ clknet_3_1__leaf_clk _00053_ net713 VGND VGND VPWR VPWR net229 sky130_fd_sc_hd__dfrtp_1
XFILLER_43_474 VPWR VGND VPWR VGND sky130_ef_sc_hd__decap_12
XTAP_TAPCELL_ROW_26_672 VGND VPWR sky130_fd_sc_hd__tapvpwrvgnd_1
XTAP_TAPCELL_ROW_26_683 VGND VPWR sky130_fd_sc_hd__tapvpwrvgnd_1
XFILLER_31_614 VGND VGND VPWR VPWR sky130_fd_sc_hd__fill_2
XFILLER_129_502 VGND VGND VPWR VPWR sky130_fd_sc_hd__fill_2
X_12645_ _05424_ _05445_ VGND VGND VPWR VPWR _05447_ sky130_fd_sc_hd__xnor2_1
X_12576_ _05312_ _05371_ VGND VGND VPWR VPWR _05372_ sky130_fd_sc_hd__or2_1
XFILLER_62_83 VGND VGND VPWR VPWR sky130_fd_sc_hd__fill_1
XFILLER_8_821 VGND VGND VPWR VPWR sky130_fd_sc_hd__decap_3
XTAP_TAPCELL_ROW_137_2280 VGND VPWR sky130_fd_sc_hd__tapvpwrvgnd_1
XFILLER_11_393 VPWR VGND VPWR VGND sky130_ef_sc_hd__decap_12
X_11527_ _04084_ _04092_ _04091_ VGND VGND VPWR VPWR _04231_ sky130_fd_sc_hd__a21oi_1
XTAP_TAPCELL_ROW_137_2291 VGND VPWR sky130_fd_sc_hd__tapvpwrvgnd_1
XFILLER_109_281 VPWR VGND VPWR VGND sky130_ef_sc_hd__decap_12
X_11458_ _03877_ _04009_ _04008_ VGND VGND VPWR VPWR _04157_ sky130_fd_sc_hd__a21boi_1
XFILLER_125_785 VPWR VGND VPWR VGND sky130_ef_sc_hd__decap_12
XFILLER_124_251 VGND VGND VPWR VPWR sky130_fd_sc_hd__fill_1
XTAP_TAPCELL_ROW_55_1102 VGND VPWR sky130_fd_sc_hd__tapvpwrvgnd_1
X_11389_ net492 net288 _03927_ _04077_ _03770_ VGND VGND VPWR VPWR _04081_ sky130_fd_sc_hd__a311oi_1
X_10409_ _03000_ _03001_ _03009_ VGND VGND VPWR VPWR _03010_ sky130_fd_sc_hd__and3_1
XFILLER_112_413 VGND VGND VPWR VPWR sky130_fd_sc_hd__decap_3
XFILLER_97_113 VPWR VGND VPWR VGND sky130_ef_sc_hd__decap_12
X_13128_ _05972_ _05973_ VGND VGND VPWR VPWR _05975_ sky130_fd_sc_hd__nor2_1
XFILLER_3_581 VGND VGND VPWR VPWR sky130_fd_sc_hd__fill_1
XFILLER_98_669 VPWR VGND VPWR VGND sky130_ef_sc_hd__decap_12
X_13059_ _05741_ _05745_ _05896_ VGND VGND VPWR VPWR _05899_ sky130_fd_sc_hd__or3_1
XFILLER_66_511 VGND VGND VPWR VPWR sky130_fd_sc_hd__decap_3
XFILLER_23_3 VPWR VGND VPWR VGND sky130_ef_sc_hd__decap_12
XFILLER_66_566 VGND VGND VPWR VPWR sky130_fd_sc_hd__decap_4
X_07620_ _00098_ _00099_ VGND VGND VPWR VPWR _00100_ sky130_fd_sc_hd__and2b_1
XFILLER_26_419 VGND VGND VPWR VPWR sky130_fd_sc_hd__fill_1
X_07551_ _06735_ _06778_ VGND VGND VPWR VPWR _06780_ sky130_fd_sc_hd__xnor2_1
XTAP_TAPCELL_ROW_66_1253 VGND VPWR sky130_fd_sc_hd__tapvpwrvgnd_1
X_07482_ _06656_ _06711_ VGND VGND VPWR VPWR _06712_ sky130_fd_sc_hd__nor2_1
XFILLER_22_603 VPWR VGND VPWR VGND sky130_ef_sc_hd__decap_12
X_09221_ _01698_ _01717_ VGND VGND VPWR VPWR _01718_ sky130_fd_sc_hd__xor2_1
XFILLER_21_113 VGND VGND VPWR VPWR sky130_fd_sc_hd__decap_4
XFILLER_34_496 VGND VGND VPWR VPWR sky130_fd_sc_hd__fill_2
X_09152_ net652 net41 net413 VGND VGND VPWR VPWR _01643_ sky130_fd_sc_hd__a21oi_1
X_08103_ _00472_ _00476_ net252 VGND VGND VPWR VPWR _00579_ sky130_fd_sc_hd__o21ai_1
XFILLER_135_505 VPWR VGND VPWR VGND sky130_ef_sc_hd__decap_12
X_09083_ _01520_ _01567_ VGND VGND VPWR VPWR _01568_ sky130_fd_sc_hd__nand2_1
X_08034_ _00510_ _00503_ VGND VGND VPWR VPWR _00511_ sky130_fd_sc_hd__and2b_1
Xinput81 w21[7] VGND VGND VPWR VPWR net81 sky130_fd_sc_hd__buf_1
Xinput70 w20[4] VGND VGND VPWR VPWR net70 sky130_fd_sc_hd__clkbuf_4
Xinput92 w23[2] VGND VGND VPWR VPWR net92 sky130_fd_sc_hd__dlymetal6s2s_1
XFILLER_107_57 VPWR VGND VPWR VGND sky130_ef_sc_hd__decap_12
XFILLER_1_518 VGND VGND VPWR VPWR sky130_fd_sc_hd__decap_4
X_09985_ _02549_ _02550_ VGND VGND VPWR VPWR _02551_ sky130_fd_sc_hd__nor2_1
XFILLER_103_435 VGND VGND VPWR VPWR sky130_fd_sc_hd__decap_3
XFILLER_130_276 VGND VGND VPWR VPWR sky130_fd_sc_hd__fill_2
X_08936_ _01051_ _01082_ _01135_ _01287_ _01290_ VGND VGND VPWR VPWR _01407_ sky130_fd_sc_hd__o41a_1
XFILLER_97_680 VGND VGND VPWR VPWR sky130_fd_sc_hd__decap_8
X_08867_ _01328_ net721 _01330_ VGND VGND VPWR VPWR _01333_ sky130_fd_sc_hd__a21oi_1
XFILLER_57_522 VPWR VGND VPWR VGND sky130_ef_sc_hd__decap_12
XTAP_TAPCELL_ROW_4_356 VGND VPWR sky130_fd_sc_hd__tapvpwrvgnd_1
X_07818_ _00294_ _00295_ VGND VGND VPWR VPWR _00296_ sky130_fd_sc_hd__nor2_1
XFILLER_17_419 VGND VGND VPWR VPWR sky130_fd_sc_hd__decap_4
XFILLER_29_279 VGND VGND VPWR VPWR sky130_fd_sc_hd__fill_1
X_08798_ _01106_ _01110_ VGND VGND VPWR VPWR _01264_ sky130_fd_sc_hd__nor2_1
XFILLER_84_385 VGND VGND VPWR VPWR sky130_fd_sc_hd__fill_2
XFILLER_83_27 VPWR VGND VPWR VGND sky130_ef_sc_hd__decap_12
XFILLER_38_791 VPWR VGND VPWR VGND sky130_ef_sc_hd__decap_12
XFILLER_72_569 VGND VGND VPWR VPWR sky130_fd_sc_hd__fill_1
X_07749_ net669 net415 _00226_ _00227_ VGND VGND VPWR VPWR _00228_ sky130_fd_sc_hd__o2bb2a_1
XTAP_TAPCELL_ROW_43_918 VGND VPWR sky130_fd_sc_hd__tapvpwrvgnd_1
XFILLER_53_783 VGND VGND VPWR VPWR sky130_fd_sc_hd__fill_1
XTAP_TAPCELL_ROW_43_929 VGND VPWR sky130_fd_sc_hd__tapvpwrvgnd_1
X_10760_ net568 net306 _03229_ _03228_ VGND VGND VPWR VPWR _03393_ sky130_fd_sc_hd__a31oi_2
XFILLER_13_614 VGND VGND VPWR VPWR sky130_fd_sc_hd__fill_2
X_09419_ net421 net336 _01785_ _01784_ VGND VGND VPWR VPWR _01934_ sky130_fd_sc_hd__a31o_1
XTAP_TAPCELL_ROW_23_631 VGND VPWR sky130_fd_sc_hd__tapvpwrvgnd_1
X_10691_ net651 net644 net318 net316 VGND VGND VPWR VPWR _03318_ sky130_fd_sc_hd__and4_1
XFILLER_40_433 VGND VGND VPWR VPWR sky130_fd_sc_hd__fill_1
X_12430_ _05060_ _05062_ _05211_ _05212_ VGND VGND VPWR VPWR _05213_ sky130_fd_sc_hd__o211ai_2
XFILLER_40_477 VGND VGND VPWR VPWR sky130_fd_sc_hd__decap_4
XTAP_TAPCELL_ROW_97_1703 VGND VPWR sky130_fd_sc_hd__tapvpwrvgnd_1
XFILLER_8_128 VPWR VGND VPWR VGND sky130_ef_sc_hd__decap_12
XFILLER_32_53 VPWR VGND VPWR VGND sky130_ef_sc_hd__decap_12
XFILLER_138_365 VGND VGND VPWR VPWR sky130_fd_sc_hd__fill_2
X_12361_ _05127_ _05135_ VGND VGND VPWR VPWR _05137_ sky130_fd_sc_hd__xor2_1
XFILLER_32_97 VPWR VGND VPWR VGND sky130_ef_sc_hd__decap_12
XFILLER_107_741 VPWR VGND VPWR VGND sky130_ef_sc_hd__decap_12
X_12292_ _04941_ _05060_ _05061_ VGND VGND VPWR VPWR _05062_ sky130_fd_sc_hd__nor3_2
X_11312_ _03969_ _03996_ VGND VGND VPWR VPWR _03997_ sky130_fd_sc_hd__xnor2_1
XFILLER_106_251 VGND VGND VPWR VPWR sky130_fd_sc_hd__fill_1
XFILLER_4_345 VPWR VGND VPWR VGND sky130_ef_sc_hd__decap_12
X_11243_ net483 net474 net291 net290 VGND VGND VPWR VPWR _03921_ sky130_fd_sc_hd__and4_1
XFILLER_107_785 VPWR VGND VPWR VGND sky130_ef_sc_hd__decap_12
XFILLER_79_135 VGND VGND VPWR VPWR sky130_fd_sc_hd__decap_8
X_11174_ _03662_ _03680_ _03679_ VGND VGND VPWR VPWR _03846_ sky130_fd_sc_hd__a21bo_1
X_10125_ _02616_ _02701_ _02615_ VGND VGND VPWR VPWR _02703_ sky130_fd_sc_hd__and3b_1
XTAP_TAPCELL_ROW_50_1021 VGND VPWR sky130_fd_sc_hd__tapvpwrvgnd_1
X_10056_ _02626_ _02627_ VGND VGND VPWR VPWR _02628_ sky130_fd_sc_hd__or2_1
XFILLER_0_584 VGND VGND VPWR VPWR sky130_fd_sc_hd__decap_4
XFILLER_0_595 VPWR VGND VPWR VGND sky130_ef_sc_hd__decap_12
XFILLER_63_503 VGND VGND VPWR VPWR sky130_fd_sc_hd__fill_1
XFILLER_57_83 VPWR VGND VPWR VGND sky130_ef_sc_hd__decap_12
XFILLER_63_536 VGND VGND VPWR VPWR sky130_fd_sc_hd__fill_1
XFILLER_35_205 VPWR VGND VPWR VGND sky130_ef_sc_hd__decap_12
XTAP_TAPCELL_ROW_106_1843 VGND VPWR sky130_fd_sc_hd__tapvpwrvgnd_1
XTAP_TAPCELL_ROW_106_1832 VGND VPWR sky130_fd_sc_hd__tapvpwrvgnd_1
X_10958_ _03606_ _03607_ VGND VGND VPWR VPWR _03610_ sky130_fd_sc_hd__xnor2_1
XFILLER_43_271 VGND VGND VPWR VPWR sky130_fd_sc_hd__fill_1
X_13677_ clknet_3_2__leaf_clk _00025_ net712 VGND VGND VPWR VPWR net212 sky130_fd_sc_hd__dfrtp_1
XFILLER_129_310 VGND VGND VPWR VPWR sky130_fd_sc_hd__fill_2
X_12628_ net593 net583 net409 VGND VGND VPWR VPWR _05429_ sky130_fd_sc_hd__and3_1
X_10889_ _03530_ _03532_ _03534_ VGND VGND VPWR VPWR _00023_ sky130_fd_sc_hd__o21a_1
XTAP_TAPCELL_ROW_61_1183 VGND VPWR sky130_fd_sc_hd__tapvpwrvgnd_1
X_12559_ _05179_ _05181_ _05180_ VGND VGND VPWR VPWR _05354_ sky130_fd_sc_hd__o21bai_1
XPHY_EDGE_ROW_9_Right_9 VGND VGND VPWR VPWR sky130_fd_sc_hd__decap_3
XTAP_TAPCELL_ROW_117_1994 VGND VPWR sky130_fd_sc_hd__tapvpwrvgnd_1
Xfanout608 net136 VGND VGND VPWR VPWR net608 sky130_fd_sc_hd__buf_2
XFILLER_98_433 VGND VGND VPWR VPWR sky130_fd_sc_hd__decap_4
Xfanout619 net626 VGND VGND VPWR VPWR net619 sky130_fd_sc_hd__clkbuf_2
X_09770_ _02180_ _02317_ VGND VGND VPWR VPWR _02318_ sky130_fd_sc_hd__xor2_1
XFILLER_112_265 VGND VGND VPWR VPWR sky130_fd_sc_hd__fill_1
XPHY_EDGE_ROW_107_Right_107 VGND VGND VPWR VPWR sky130_fd_sc_hd__decap_3
XFILLER_98_499 VPWR VGND VPWR VGND sky130_ef_sc_hd__decap_12
XFILLER_98_477 VGND VGND VPWR VPWR sky130_fd_sc_hd__fill_2
X_06982_ net673 net443 VGND VGND VPWR VPWR _03139_ sky130_fd_sc_hd__nand2_1
X_08721_ _01178_ _01179_ _01186_ VGND VGND VPWR VPWR _01188_ sky130_fd_sc_hd__nand3_1
XFILLER_85_149 VPWR VGND VPWR VGND sky130_ef_sc_hd__decap_12
X_08652_ _01095_ _01117_ VGND VGND VPWR VPWR _01119_ sky130_fd_sc_hd__xor2_1
XTAP_TAPCELL_ROW_1_315 VGND VPWR sky130_fd_sc_hd__tapvpwrvgnd_1
XFILLER_66_385 VGND VGND VPWR VPWR sky130_fd_sc_hd__fill_2
X_07603_ _00074_ _00081_ _00082_ VGND VGND VPWR VPWR _00083_ sky130_fd_sc_hd__nand3_1
XFILLER_26_227 VPWR VGND VPWR VGND sky130_ef_sc_hd__decap_12
X_08583_ net530 net349 VGND VGND VPWR VPWR _01051_ sky130_fd_sc_hd__nand2_2
XFILLER_93_193 VPWR VGND VPWR VGND sky130_ef_sc_hd__decap_12
XFILLER_81_344 VGND VGND VPWR VPWR sky130_fd_sc_hd__fill_2
XFILLER_42_709 VGND VGND VPWR VPWR sky130_fd_sc_hd__fill_1
XFILLER_81_388 VGND VGND VPWR VPWR sky130_fd_sc_hd__decap_4
XFILLER_81_366 VGND VGND VPWR VPWR sky130_fd_sc_hd__fill_1
X_07534_ _06761_ _06762_ net113 VGND VGND VPWR VPWR _06763_ sky130_fd_sc_hd__and3b_1
XFILLER_35_772 VPWR VGND VPWR VGND sky130_ef_sc_hd__decap_12
X_07465_ _06535_ _06537_ _06536_ VGND VGND VPWR VPWR _06695_ sky130_fd_sc_hd__o21bai_1
XFILLER_34_293 VGND VGND VPWR VPWR sky130_fd_sc_hd__decap_4
X_09204_ net265 net364 _01522_ VGND VGND VPWR VPWR _01699_ sky130_fd_sc_hd__nor3_1
XFILLER_22_455 VGND VGND VPWR VPWR sky130_fd_sc_hd__decap_8
X_07396_ net510 net119 net678 net519 VGND VGND VPWR VPWR _06626_ sky130_fd_sc_hd__a22o_1
XFILLER_10_628 VPWR VGND VPWR VGND sky130_ef_sc_hd__decap_12
X_09135_ _01446_ _01449_ _01448_ VGND VGND VPWR VPWR _01624_ sky130_fd_sc_hd__o21bai_1
XTAP_TAPCELL_ROW_79_1444 VGND VPWR sky130_fd_sc_hd__tapvpwrvgnd_1
XFILLER_135_335 VGND VGND VPWR VPWR sky130_fd_sc_hd__fill_1
X_09066_ net574 net359 _01388_ _01386_ VGND VGND VPWR VPWR _01549_ sky130_fd_sc_hd__a31o_1
XFILLER_108_538 VGND VGND VPWR VPWR sky130_fd_sc_hd__fill_2
XFILLER_135_357 VPWR VGND VPWR VGND sky130_ef_sc_hd__decap_12
X_08017_ _00350_ _00356_ _00355_ VGND VGND VPWR VPWR _00494_ sky130_fd_sc_hd__a21oi_1
XFILLER_2_805 VGND VGND VPWR VPWR sky130_fd_sc_hd__decap_6
XTAP_TAPCELL_ROW_92_1633 VGND VPWR sky130_fd_sc_hd__tapvpwrvgnd_1
XFILLER_78_27 VGND VGND VPWR VPWR sky130_fd_sc_hd__fill_1
XTAP_TAPCELL_ROW_9_426 VGND VPWR sky130_fd_sc_hd__tapvpwrvgnd_1
XFILLER_104_755 VGND VGND VPWR VPWR sky130_fd_sc_hd__fill_1
XFILLER_89_444 VGND VGND VPWR VPWR sky130_fd_sc_hd__decap_4
XFILLER_1_337 VGND VGND VPWR VPWR sky130_fd_sc_hd__decap_4
X_09968_ _02530_ _02531_ VGND VGND VPWR VPWR _02533_ sky130_fd_sc_hd__xor2_1
XFILLER_89_488 VPWR VGND VPWR VGND sky130_ef_sc_hd__decap_12
XFILLER_77_617 VPWR VGND VPWR VGND sky130_ef_sc_hd__decap_12
XFILLER_76_116 VGND VGND VPWR VPWR sky130_fd_sc_hd__decap_8
XFILLER_49_308 VPWR VGND VPWR VGND sky130_ef_sc_hd__decap_12
XFILLER_134_77 VGND VGND VPWR VPWR sky130_fd_sc_hd__decap_6
X_08919_ _01386_ _01388_ VGND VGND VPWR VPWR _01389_ sky130_fd_sc_hd__and2b_1
XFILLER_94_15 VPWR VGND VPWR VGND sky130_ef_sc_hd__decap_12
XFILLER_76_138 VGND VGND VPWR VPWR sky130_fd_sc_hd__fill_2
X_09899_ _02196_ _02339_ _02337_ VGND VGND VPWR VPWR _02457_ sky130_fd_sc_hd__o21a_1
XFILLER_91_108 VGND VGND VPWR VPWR sky130_fd_sc_hd__decap_4
X_11930_ net593 net10 VGND VGND VPWR VPWR _04668_ sky130_fd_sc_hd__nand2_1
XFILLER_57_330 VGND VGND VPWR VPWR sky130_fd_sc_hd__decap_6
XFILLER_18_728 VGND VGND VPWR VPWR sky130_fd_sc_hd__decap_8
XTAP_TAPCELL_ROW_28_701 VGND VPWR sky130_fd_sc_hd__tapvpwrvgnd_1
XTAP_TAPCELL_ROW_28_712 VGND VPWR sky130_fd_sc_hd__tapvpwrvgnd_1
XFILLER_72_333 VGND VGND VPWR VPWR sky130_fd_sc_hd__decap_3
X_11861_ _04486_ _04489_ _04594_ VGND VGND VPWR VPWR _04595_ sky130_fd_sc_hd__o21a_1
XFILLER_27_86 VGND VGND VPWR VPWR sky130_fd_sc_hd__fill_1
X_13600_ _05826_ _05971_ _06238_ _06488_ VGND VGND VPWR VPWR _06489_ sky130_fd_sc_hd__a31o_1
X_11792_ _04330_ _04333_ _04518_ VGND VGND VPWR VPWR _04520_ sky130_fd_sc_hd__nor3_1
X_10812_ _03449_ _03416_ VGND VGND VPWR VPWR _03450_ sky130_fd_sc_hd__and2b_1
XFILLER_32_208 VGND VGND VPWR VPWR sky130_fd_sc_hd__decap_8
X_13531_ _06215_ _06314_ _06412_ VGND VGND VPWR VPWR _06414_ sky130_fd_sc_hd__or3_1
X_10743_ net561 net307 net305 net568 VGND VGND VPWR VPWR _03374_ sky130_fd_sc_hd__a22o_1
XTAP_TAPCELL_ROW_101_1762 VGND VPWR sky130_fd_sc_hd__tapvpwrvgnd_1
X_13462_ _05476_ _06338_ VGND VGND VPWR VPWR _06339_ sky130_fd_sc_hd__xor2_1
XFILLER_41_797 VGND VGND VPWR VPWR sky130_fd_sc_hd__decap_6
XFILLER_13_499 VGND VGND VPWR VPWR sky130_fd_sc_hd__decap_4
X_10674_ _03296_ _03297_ _03287_ VGND VGND VPWR VPWR _03299_ sky130_fd_sc_hd__a21o_1
X_13393_ _06262_ _06263_ VGND VGND VPWR VPWR _06264_ sky130_fd_sc_hd__nor2_1
X_12413_ _05191_ _05192_ _05172_ VGND VGND VPWR VPWR _05194_ sky130_fd_sc_hd__a21oi_1
XFILLER_126_313 VGND VGND VPWR VPWR sky130_fd_sc_hd__decap_8
X_12344_ net507 net399 VGND VGND VPWR VPWR _05118_ sky130_fd_sc_hd__nand2_1
XFILLER_114_519 VGND VGND VPWR VPWR sky130_fd_sc_hd__decap_4
X_12275_ _05040_ _05041_ _05042_ VGND VGND VPWR VPWR _05043_ sky130_fd_sc_hd__and3_4
XFILLER_5_698 VPWR VGND VPWR VGND sky130_ef_sc_hd__decap_12
XFILLER_4_153 VPWR VGND VPWR VGND sky130_ef_sc_hd__decap_12
X_11226_ _03766_ _03768_ _03765_ VGND VGND VPWR VPWR _03902_ sky130_fd_sc_hd__a21oi_1
X_11157_ _03821_ _03826_ VGND VGND VPWR VPWR _03827_ sky130_fd_sc_hd__and2_1
X_10108_ _02492_ _02590_ _02683_ VGND VGND VPWR VPWR _02685_ sky130_fd_sc_hd__and3_1
XFILLER_110_747 VGND VGND VPWR VPWR sky130_fd_sc_hd__decap_8
XFILLER_110_769 VPWR VGND VPWR VGND sky130_ef_sc_hd__decap_12
XFILLER_76_661 VGND VGND VPWR VPWR sky130_fd_sc_hd__decap_8
XFILLER_48_341 VGND VGND VPWR VPWR sky130_fd_sc_hd__fill_1
X_11088_ _03739_ _03750_ VGND VGND VPWR VPWR _03752_ sky130_fd_sc_hd__xor2_1
X_10039_ net419 _02416_ _02414_ VGND VGND VPWR VPWR _02610_ sky130_fd_sc_hd__a21oi_1
XFILLER_36_525 VGND VGND VPWR VPWR sky130_fd_sc_hd__fill_1
XFILLER_91_653 VGND VGND VPWR VPWR sky130_fd_sc_hd__decap_8
XFILLER_90_141 VGND VGND VPWR VPWR sky130_fd_sc_hd__decap_8
XFILLER_63_344 VGND VGND VPWR VPWR sky130_fd_sc_hd__fill_2
XFILLER_63_333 VGND VGND VPWR VPWR sky130_fd_sc_hd__decap_3
XFILLER_36_558 VGND VGND VPWR VPWR sky130_fd_sc_hd__decap_3
XTAP_TAPCELL_ROW_63_1212 VGND VPWR sky130_fd_sc_hd__tapvpwrvgnd_1
XFILLER_16_282 VPWR VGND VPWR VGND sky130_ef_sc_hd__decap_12
XFILLER_90_3 VPWR VGND VPWR VGND sky130_ef_sc_hd__decap_12
X_07250_ net512 net683 net685 net504 VGND VGND VPWR VPWR _06061_ sky130_fd_sc_hd__a22o_1
XFILLER_129_151 VPWR VGND VPWR VGND sky130_ef_sc_hd__decap_12
X_07181_ _03729_ _03762_ net240 _05297_ VGND VGND VPWR VPWR _05308_ sky130_fd_sc_hd__a211oi_2
XFILLER_117_368 VGND VGND VPWR VPWR sky130_fd_sc_hd__decap_4
XFILLER_132_327 VGND VGND VPWR VPWR sky130_fd_sc_hd__fill_1
XFILLER_99_720 VGND VGND VPWR VPWR sky130_fd_sc_hd__decap_8
XTAP_TAPCELL_ROW_74_1374 VGND VPWR sky130_fd_sc_hd__tapvpwrvgnd_1
Xfanout405 net2 VGND VGND VPWR VPWR net405 sky130_fd_sc_hd__buf_1
X_09822_ net331 net255 VGND VGND VPWR VPWR _02374_ sky130_fd_sc_hd__nor2_1
Xfanout438 net440 VGND VGND VPWR VPWR net438 sky130_fd_sc_hd__buf_2
XFILLER_101_703 VGND VGND VPWR VPWR sky130_fd_sc_hd__fill_1
XFILLER_99_797 VPWR VGND VPWR VGND sky130_ef_sc_hd__decap_12
Xfanout427 net432 VGND VGND VPWR VPWR net427 sky130_fd_sc_hd__clkbuf_4
Xfanout416 net417 VGND VGND VPWR VPWR net416 sky130_fd_sc_hd__clkbuf_4
XFILLER_113_585 VPWR VGND VPWR VGND sky130_ef_sc_hd__decap_12
X_09753_ _02127_ _02154_ _02153_ VGND VGND VPWR VPWR _02299_ sky130_fd_sc_hd__a21o_1
Xfanout449 net452 VGND VGND VPWR VPWR net449 sky130_fd_sc_hd__clkbuf_4
X_08704_ net657 net647 net36 net373 VGND VGND VPWR VPWR _01171_ sky130_fd_sc_hd__nand4_1
X_06965_ _02931_ _02942_ VGND VGND VPWR VPWR _02953_ sky130_fd_sc_hd__nor2_1
X_09684_ _02186_ _02221_ VGND VGND VPWR VPWR _02223_ sky130_fd_sc_hd__xnor2_2
X_06896_ _02173_ _02183_ VGND VGND VPWR VPWR _02205_ sky130_fd_sc_hd__nand2_1
X_08635_ net575 net365 VGND VGND VPWR VPWR _01102_ sky130_fd_sc_hd__nand2_1
XFILLER_82_631 VPWR VGND VPWR VGND sky130_ef_sc_hd__decap_12
XFILLER_64_29 VPWR VGND VPWR VGND sky130_ef_sc_hd__decap_12
X_08566_ _01032_ _01033_ VGND VGND VPWR VPWR _01034_ sky130_fd_sc_hd__and2b_1
X_07517_ _06744_ _06745_ VGND VGND VPWR VPWR _06746_ sky130_fd_sc_hd__and2b_1
X_08497_ _00925_ _00926_ _00937_ _00936_ VGND VGND VPWR VPWR _00969_ sky130_fd_sc_hd__a31o_1
X_07448_ net267 net612 _06532_ _06531_ VGND VGND VPWR VPWR _06678_ sky130_fd_sc_hd__a31o_1
XFILLER_10_403 VPWR VGND VPWR VGND sky130_ef_sc_hd__decap_12
XFILLER_23_797 VGND VGND VPWR VPWR sky130_fd_sc_hd__decap_6
XTAP_TAPCELL_ROW_33_781 VGND VPWR sky130_fd_sc_hd__tapvpwrvgnd_1
X_07379_ _06603_ _06608_ VGND VGND VPWR VPWR _06609_ sky130_fd_sc_hd__xor2_1
XFILLER_10_436 VGND VGND VPWR VPWR sky130_fd_sc_hd__decap_4
XFILLER_13_55 VGND VGND VPWR VPWR sky130_fd_sc_hd__fill_1
XFILLER_22_296 VGND VGND VPWR VPWR sky130_fd_sc_hd__fill_1
XFILLER_129_55 VGND VGND VPWR VPWR sky130_fd_sc_hd__fill_1
X_09118_ _01571_ _01604_ VGND VGND VPWR VPWR _01606_ sky130_fd_sc_hd__xnor2_1
XFILLER_108_302 VGND VGND VPWR VPWR sky130_fd_sc_hd__decap_6
XFILLER_13_77 VGND VGND VPWR VPWR sky130_fd_sc_hd__decap_3
XFILLER_124_806 VGND VGND VPWR VPWR sky130_fd_sc_hd__decap_6
XFILLER_108_368 VPWR VGND VPWR VGND sky130_ef_sc_hd__decap_12
X_10390_ net654 net319 net322 net643 VGND VGND VPWR VPWR _02989_ sky130_fd_sc_hd__a22o_1
X_09049_ net567 net360 net358 net574 VGND VGND VPWR VPWR _01531_ sky130_fd_sc_hd__a22o_1
X_12060_ net497 net18 VGND VGND VPWR VPWR _04808_ sky130_fd_sc_hd__nand2_1
XFILLER_131_360 VPWR VGND VPWR VGND sky130_ef_sc_hd__decap_12
XFILLER_1_167 VGND VGND VPWR VPWR sky130_fd_sc_hd__fill_1
X_11011_ _03666_ _03667_ VGND VGND VPWR VPWR _03668_ sky130_fd_sc_hd__xnor2_1
XFILLER_131_393 VPWR VGND VPWR VGND sky130_ef_sc_hd__decap_12
XFILLER_49_138 VGND VGND VPWR VPWR sky130_fd_sc_hd__decap_4
XFILLER_38_41 VPWR VGND VPWR VGND sky130_ef_sc_hd__decap_12
X_12962_ _05789_ _05790_ _05792_ VGND VGND VPWR VPWR _05793_ sky130_fd_sc_hd__or3_1
XFILLER_58_672 VGND VGND VPWR VPWR sky130_fd_sc_hd__decap_4
XFILLER_18_525 VGND VGND VPWR VPWR sky130_fd_sc_hd__decap_6
XFILLER_38_85 VPWR VGND VPWR VGND sky130_ef_sc_hd__decap_12
X_12893_ _05619_ _05717_ VGND VGND VPWR VPWR _05718_ sky130_fd_sc_hd__xor2_1
XFILLER_57_193 VGND VGND VPWR VPWR sky130_fd_sc_hd__decap_6
X_11913_ _04644_ _04650_ VGND VGND VPWR VPWR _04651_ sky130_fd_sc_hd__xnor2_1
XFILLER_73_697 VGND VGND VPWR VPWR sky130_fd_sc_hd__decap_6
XFILLER_72_141 VGND VGND VPWR VPWR sky130_fd_sc_hd__fill_2
X_11844_ _04519_ _04521_ VGND VGND VPWR VPWR _04576_ sky130_fd_sc_hd__and2b_1
XFILLER_72_174 VGND VGND VPWR VPWR sky130_fd_sc_hd__decap_6
XFILLER_14_731 VGND VGND VPWR VPWR sky130_fd_sc_hd__fill_2
X_11775_ _04181_ _04315_ _04499_ VGND VGND VPWR VPWR _04501_ sky130_fd_sc_hd__nand3_1
X_13514_ _06394_ _06395_ VGND VGND VPWR VPWR _06396_ sky130_fd_sc_hd__and2b_1
X_10726_ _03354_ _03355_ VGND VGND VPWR VPWR _03356_ sky130_fd_sc_hd__nand2b_1
X_13445_ _06226_ _06228_ _06239_ VGND VGND VPWR VPWR _06320_ sky130_fd_sc_hd__or3_1
XFILLER_13_296 VGND VGND VPWR VPWR sky130_fd_sc_hd__fill_1
X_10657_ _03278_ _03279_ VGND VGND VPWR VPWR _03280_ sky130_fd_sc_hd__nor2_1
XTAP_TAPCELL_ROW_132_2209 VGND VPWR sky130_fd_sc_hd__tapvpwrvgnd_1
XFILLER_70_83 VGND VGND VPWR VPWR sky130_fd_sc_hd__fill_1
XFILLER_9_278 VGND VGND VPWR VPWR sky130_fd_sc_hd__fill_2
XTAP_TAPCELL_ROW_11_453 VGND VPWR sky130_fd_sc_hd__tapvpwrvgnd_1
XTAP_TAPCELL_ROW_11_464 VGND VPWR sky130_fd_sc_hd__tapvpwrvgnd_1
XFILLER_127_644 VGND VGND VPWR VPWR sky130_fd_sc_hd__fill_1
X_13376_ _06123_ _06124_ _06140_ VGND VGND VPWR VPWR _06245_ sky130_fd_sc_hd__o21ba_1
XFILLER_62_7 VPWR VGND VPWR VGND sky130_ef_sc_hd__decap_12
X_10588_ _03070_ _03076_ _03202_ _03203_ VGND VGND VPWR VPWR _03206_ sky130_fd_sc_hd__a22o_1
XFILLER_126_176 VGND VGND VPWR VPWR sky130_fd_sc_hd__fill_1
XFILLER_114_327 VPWR VGND VPWR VGND sky130_ef_sc_hd__decap_12
XFILLER_114_305 VGND VGND VPWR VPWR sky130_fd_sc_hd__decap_3
X_12327_ _05096_ _05097_ VGND VGND VPWR VPWR _05099_ sky130_fd_sc_hd__xor2_1
XTAP_TAPCELL_ROW_114_1953 VGND VPWR sky130_fd_sc_hd__tapvpwrvgnd_1
X_12258_ net640 net353 VGND VGND VPWR VPWR _05025_ sky130_fd_sc_hd__nand2_1
X_11209_ _03881_ _03883_ VGND VGND VPWR VPWR _03884_ sky130_fd_sc_hd__nor2_1
XFILLER_110_533 VPWR VGND VPWR VGND sky130_ef_sc_hd__decap_12
X_12189_ _04773_ _04946_ VGND VGND VPWR VPWR _04949_ sky130_fd_sc_hd__or2_1
XFILLER_95_222 VGND VGND VPWR VPWR sky130_fd_sc_hd__fill_2
XFILLER_68_436 VGND VGND VPWR VPWR sky130_fd_sc_hd__fill_1
XFILLER_83_439 VGND VGND VPWR VPWR sky130_fd_sc_hd__decap_8
XFILLER_64_620 VPWR VGND VPWR VGND sky130_ef_sc_hd__decap_12
XFILLER_36_300 VGND VGND VPWR VPWR sky130_fd_sc_hd__fill_1
XFILLER_91_472 VPWR VGND VPWR VGND sky130_ef_sc_hd__decap_12
XFILLER_63_152 VGND VGND VPWR VPWR sky130_fd_sc_hd__decap_8
XTAP_TAPCELL_ROW_19_575 VGND VPWR sky130_fd_sc_hd__tapvpwrvgnd_1
XFILLER_24_517 VGND VGND VPWR VPWR sky130_fd_sc_hd__decap_6
X_08420_ _00675_ _00685_ _00793_ _00794_ _00892_ VGND VGND VPWR VPWR _00894_ sky130_fd_sc_hd__o311ai_2
XFILLER_51_358 VGND VGND VPWR VPWR sky130_fd_sc_hd__decap_3
X_08351_ _00598_ _00824_ VGND VGND VPWR VPWR _00825_ sky130_fd_sc_hd__xnor2_2
X_07302_ _06531_ _06532_ VGND VGND VPWR VPWR _06533_ sky130_fd_sc_hd__and2b_1
X_08282_ net677 net257 _00755_ _00756_ VGND VGND VPWR VPWR _00757_ sky130_fd_sc_hd__nor4_1
XTAP_TAPCELL_ROW_30_740 VGND VPWR sky130_fd_sc_hd__tapvpwrvgnd_1
X_07233_ _02975_ _04449_ _02760_ VGND VGND VPWR VPWR _05876_ sky130_fd_sc_hd__o21a_1
XFILLER_117_121 VGND VGND VPWR VPWR sky130_fd_sc_hd__decap_8
XTAP_TAPCELL_ROW_76_1403 VGND VPWR sky130_fd_sc_hd__tapvpwrvgnd_1
X_07164_ _05089_ _05100_ _05078_ VGND VGND VPWR VPWR _05122_ sky130_fd_sc_hd__o21ai_1
XFILLER_118_699 VGND VGND VPWR VPWR sky130_fd_sc_hd__fill_1
XFILLER_117_165 VGND VGND VPWR VPWR sky130_fd_sc_hd__decap_3
XFILLER_117_154 VGND VGND VPWR VPWR sky130_fd_sc_hd__decap_6
XFILLER_105_327 VGND VGND VPWR VPWR sky130_fd_sc_hd__decap_3
X_07095_ net582 net693 net691 net592 VGND VGND VPWR VPWR _04373_ sky130_fd_sc_hd__a22o_1
XFILLER_121_809 VGND VGND VPWR VPWR sky130_fd_sc_hd__decap_8
XFILLER_117_198 VGND VGND VPWR VPWR sky130_fd_sc_hd__decap_4
XFILLER_59_18 VPWR VGND VPWR VGND sky130_ef_sc_hd__decap_12
XFILLER_99_561 VGND VGND VPWR VPWR sky130_fd_sc_hd__decap_8
XFILLER_113_393 VPWR VGND VPWR VGND sky130_ef_sc_hd__decap_12
Xfanout246 _05761_ VGND VGND VPWR VPWR net246 sky130_fd_sc_hd__clkbuf_4
XFILLER_87_723 VGND VGND VPWR VPWR sky130_fd_sc_hd__decap_4
X_09805_ _02326_ _02354_ VGND VGND VPWR VPWR _02355_ sky130_fd_sc_hd__nor2_1
XFILLER_115_57 VPWR VGND VPWR VGND sky130_ef_sc_hd__decap_12
XFILLER_86_233 VPWR VGND VPWR VGND sky130_ef_sc_hd__decap_12
Xfanout268 net99 VGND VGND VPWR VPWR net268 sky130_fd_sc_hd__buf_1
X_07997_ _00472_ _00473_ VGND VGND VPWR VPWR _00474_ sky130_fd_sc_hd__or2_1
XFILLER_47_609 VGND VGND VPWR VPWR sky130_fd_sc_hd__fill_2
Xfanout257 _01376_ VGND VGND VPWR VPWR net257 sky130_fd_sc_hd__clkbuf_4
Xfanout279 net92 VGND VGND VPWR VPWR net279 sky130_fd_sc_hd__clkbuf_4
X_09736_ _02278_ _02279_ VGND VGND VPWR VPWR _02280_ sky130_fd_sc_hd__and2_1
XFILLER_101_588 VGND VGND VPWR VPWR sky130_fd_sc_hd__decap_4
XFILLER_86_288 VPWR VGND VPWR VGND sky130_ef_sc_hd__decap_12
X_06948_ _02739_ _02750_ VGND VGND VPWR VPWR _02771_ sky130_fd_sc_hd__xnor2_1
X_09667_ _02044_ _02203_ VGND VGND VPWR VPWR _02204_ sky130_fd_sc_hd__xnor2_1
XTAP_TAPCELL_ROW_87_1554 VGND VPWR sky130_fd_sc_hd__tapvpwrvgnd_1
XFILLER_27_344 VGND VGND VPWR VPWR sky130_fd_sc_hd__decap_8
X_08618_ net348 _01053_ net530 net51 VGND VGND VPWR VPWR _01085_ sky130_fd_sc_hd__or4bb_1
XTAP_TAPCELL_ROW_87_1565 VGND VPWR sky130_fd_sc_hd__tapvpwrvgnd_1
X_06879_ net467 net670 _01998_ VGND VGND VPWR VPWR _02020_ sky130_fd_sc_hd__and3_1
XFILLER_54_163 VGND VGND VPWR VPWR sky130_fd_sc_hd__decap_8
XFILLER_42_303 VGND VGND VPWR VPWR sky130_fd_sc_hd__decap_4
XTAP_TAPCELL_ROW_38_851 VGND VPWR sky130_fd_sc_hd__tapvpwrvgnd_1
X_09598_ _01983_ _01986_ VGND VGND VPWR VPWR _02130_ sky130_fd_sc_hd__nor2_1
XFILLER_91_27 VPWR VGND VPWR VGND sky130_ef_sc_hd__decap_12
XFILLER_70_645 VPWR VGND VPWR VGND sky130_ef_sc_hd__decap_12
XFILLER_27_388 VGND VGND VPWR VPWR sky130_fd_sc_hd__decap_4
X_08549_ net352 _01017_ VGND VGND VPWR VPWR _01018_ sky130_fd_sc_hd__nand2_1
XFILLER_23_561 VGND VGND VPWR VPWR sky130_fd_sc_hd__decap_8
X_11560_ net415 net272 VGND VGND VPWR VPWR _04267_ sky130_fd_sc_hd__nand2_1
XFILLER_138_3 VPWR VGND VPWR VGND sky130_ef_sc_hd__decap_12
XFILLER_11_756 VPWR VGND VPWR VGND sky130_ef_sc_hd__decap_12
X_10511_ net520 net290 VGND VGND VPWR VPWR _03121_ sky130_fd_sc_hd__and2_1
X_13230_ _05973_ _05976_ _05972_ VGND VGND VPWR VPWR _06086_ sky130_fd_sc_hd__o21ba_1
XFILLER_10_277 VPWR VGND VPWR VGND sky130_ef_sc_hd__decap_12
X_11491_ net249 _04070_ _04074_ VGND VGND VPWR VPWR _04192_ sky130_fd_sc_hd__or3_1
XFILLER_109_666 VGND VGND VPWR VPWR sky130_fd_sc_hd__fill_1
X_10442_ _03034_ _03042_ _03040_ VGND VGND VPWR VPWR _03046_ sky130_fd_sc_hd__a21oi_1
XFILLER_40_53 VPWR VGND VPWR VGND sky130_ef_sc_hd__decap_12
X_13161_ _06009_ _06010_ VGND VGND VPWR VPWR _06011_ sky130_fd_sc_hd__nor2_1
X_10373_ net450 net282 net280 net458 VGND VGND VPWR VPWR _02970_ sky130_fd_sc_hd__a22o_1
XFILLER_40_97 VPWR VGND VPWR VGND sky130_ef_sc_hd__decap_12
X_13092_ _05814_ _05830_ _05829_ VGND VGND VPWR VPWR _05935_ sky130_fd_sc_hd__a21oi_1
X_12112_ _04851_ _04863_ _04864_ VGND VGND VPWR VPWR _04865_ sky130_fd_sc_hd__nand3_1
XFILLER_2_421 VGND VGND VPWR VPWR sky130_fd_sc_hd__decap_8
X_12043_ _04736_ _04739_ _04788_ VGND VGND VPWR VPWR _04789_ sky130_fd_sc_hd__o21a_1
XFILLER_77_200 VGND VGND VPWR VPWR sky130_fd_sc_hd__decap_6
XFILLER_49_51 VGND VGND VPWR VPWR sky130_fd_sc_hd__decap_4
XTAP_TAPCELL_ROW_129_2171 VGND VPWR sky130_fd_sc_hd__tapvpwrvgnd_1
XFILLER_93_748 VGND VGND VPWR VPWR sky130_fd_sc_hd__fill_1
XFILLER_65_417 VGND VGND VPWR VPWR sky130_fd_sc_hd__fill_2
XFILLER_105_90 VGND VGND VPWR VPWR sky130_fd_sc_hd__fill_2
XFILLER_46_642 VGND VGND VPWR VPWR sky130_fd_sc_hd__fill_2
XFILLER_46_631 VGND VGND VPWR VPWR sky130_fd_sc_hd__fill_1
XFILLER_1_69 VPWR VGND VPWR VGND sky130_ef_sc_hd__decap_12
X_12945_ _05739_ _05773_ VGND VGND VPWR VPWR _05774_ sky130_fd_sc_hd__nand2b_1
XFILLER_18_377 VGND VGND VPWR VPWR sky130_fd_sc_hd__decap_8
X_12876_ _05694_ _05698_ VGND VGND VPWR VPWR _05699_ sky130_fd_sc_hd__xnor2_2
XFILLER_61_623 VGND VGND VPWR VPWR sky130_fd_sc_hd__fill_1
XFILLER_33_325 VGND VGND VPWR VPWR sky130_fd_sc_hd__decap_6
X_11827_ _04550_ _04555_ VGND VGND VPWR VPWR _04557_ sky130_fd_sc_hd__and2_1
XTAP_TAPCELL_ROW_16_534 VGND VPWR sky130_fd_sc_hd__tapvpwrvgnd_1
X_11758_ _04480_ _04481_ VGND VGND VPWR VPWR _04483_ sky130_fd_sc_hd__xnor2_1
XFILLER_119_408 VPWR VGND VPWR VGND sky130_ef_sc_hd__decap_12
XFILLER_41_391 VGND VGND VPWR VPWR sky130_fd_sc_hd__fill_1
X_10709_ _03179_ _03181_ _03335_ _03337_ VGND VGND VPWR VPWR _03338_ sky130_fd_sc_hd__o211ai_2
X_11689_ _04407_ _04380_ VGND VGND VPWR VPWR _04408_ sky130_fd_sc_hd__and2b_1
X_13428_ _06209_ _06212_ _06299_ VGND VGND VPWR VPWR _06302_ sky130_fd_sc_hd__or3b_1
X_13359_ _06220_ _06224_ VGND VGND VPWR VPWR _06227_ sky130_fd_sc_hd__xor2_1
XTAP_TAPCELL_ROW_58_1144 VGND VPWR sky130_fd_sc_hd__tapvpwrvgnd_1
XTAP_TAPCELL_ROW_58_1133 VGND VPWR sky130_fd_sc_hd__tapvpwrvgnd_1
XFILLER_53_3 VPWR VGND VPWR VGND sky130_ef_sc_hd__decap_12
XFILLER_103_809 VPWR VGND VPWR VGND sky130_ef_sc_hd__decap_12
XFILLER_6_793 VPWR VGND VPWR VGND sky130_ef_sc_hd__decap_12
XFILLER_5_281 VGND VGND VPWR VPWR sky130_fd_sc_hd__fill_1
X_07920_ _00396_ _00397_ VGND VGND VPWR VPWR _00398_ sky130_fd_sc_hd__nor2_1
XTAP_TAPCELL_ROW_71_1333 VGND VPWR sky130_fd_sc_hd__tapvpwrvgnd_1
XTAP_TAPCELL_ROW_71_1322 VGND VPWR sky130_fd_sc_hd__tapvpwrvgnd_1
XFILLER_110_341 VPWR VGND VPWR VGND sky130_ef_sc_hd__decap_12
XFILLER_68_233 VGND VGND VPWR VPWR sky130_fd_sc_hd__decap_8
X_07851_ _00326_ _00327_ VGND VGND VPWR VPWR _00329_ sky130_fd_sc_hd__xnor2_2
XFILLER_29_609 VGND VGND VPWR VPWR sky130_fd_sc_hd__decap_6
X_07782_ net652 net648 net636 VGND VGND VPWR VPWR _00261_ sky130_fd_sc_hd__o21ai_4
Xinput2 w00[0] VGND VGND VPWR VPWR net2 sky130_fd_sc_hd__buf_1
XFILLER_68_277 VPWR VGND VPWR VGND sky130_ef_sc_hd__decap_12
X_09521_ net540 net360 net361 net265 VGND VGND VPWR VPWR _02045_ sky130_fd_sc_hd__o2bb2a_1
XFILLER_83_225 VPWR VGND VPWR VGND sky130_ef_sc_hd__decap_12
XFILLER_64_450 VPWR VGND VPWR VGND sky130_ef_sc_hd__decap_12
XFILLER_36_141 VPWR VGND VPWR VGND sky130_ef_sc_hd__decap_12
X_09452_ _01952_ _01968_ VGND VGND VPWR VPWR _01970_ sky130_fd_sc_hd__xor2_1
XTAP_TAPCELL_ROW_69_1295 VGND VPWR sky130_fd_sc_hd__tapvpwrvgnd_1
XFILLER_52_645 VGND VGND VPWR VPWR sky130_fd_sc_hd__fill_1
XTAP_TAPCELL_ROW_35_810 VGND VPWR sky130_fd_sc_hd__tapvpwrvgnd_1
X_09383_ _01892_ net250 VGND VGND VPWR VPWR _01895_ sky130_fd_sc_hd__xor2_1
X_08403_ _00852_ _00875_ VGND VGND VPWR VPWR _00877_ sky130_fd_sc_hd__xnor2_1
XTAP_TAPCELL_ROW_82_1484 VGND VPWR sky130_fd_sc_hd__tapvpwrvgnd_1
X_08334_ _00801_ _00807_ VGND VGND VPWR VPWR _00808_ sky130_fd_sc_hd__xnor2_1
XFILLER_138_706 VGND VGND VPWR VPWR sky130_fd_sc_hd__decap_4
XTAP_TAPCELL_ROW_82_1495 VGND VPWR sky130_fd_sc_hd__tapvpwrvgnd_1
XFILLER_20_531 VGND VGND VPWR VPWR sky130_fd_sc_hd__fill_1
XFILLER_137_238 VGND VGND VPWR VPWR sky130_fd_sc_hd__decap_3
X_08265_ _00504_ _00647_ _00649_ _00377_ VGND VGND VPWR VPWR _00740_ sky130_fd_sc_hd__a31oi_2
XFILLER_20_575 VGND VGND VPWR VPWR sky130_fd_sc_hd__decap_6
X_08196_ _00431_ _00671_ VGND VGND VPWR VPWR _00672_ sky130_fd_sc_hd__nand2_1
XFILLER_20_586 VGND VGND VPWR VPWR sky130_fd_sc_hd__fill_2
X_07216_ net703 net537 _05668_ VGND VGND VPWR VPWR _05690_ sky130_fd_sc_hd__nand3_1
XFILLER_118_485 VGND VGND VPWR VPWR sky130_fd_sc_hd__fill_1
X_07147_ _04893_ _04904_ _04915_ VGND VGND VPWR VPWR _04937_ sky130_fd_sc_hd__a21oi_1
XFILLER_133_444 VGND VGND VPWR VPWR sky130_fd_sc_hd__decap_4
XFILLER_105_113 VGND VGND VPWR VPWR sky130_fd_sc_hd__fill_2
XFILLER_133_455 VGND VGND VPWR VPWR sky130_fd_sc_hd__fill_1
XFILLER_121_617 VGND VGND VPWR VPWR sky130_fd_sc_hd__decap_6
X_07078_ net236 _04145_ _02238_ _02347_ VGND VGND VPWR VPWR _04188_ sky130_fd_sc_hd__o211ai_1
XFILLER_105_179 VGND VGND VPWR VPWR sky130_fd_sc_hd__decap_6
XFILLER_86_27 VGND VGND VPWR VPWR sky130_fd_sc_hd__fill_1
XFILLER_101_352 VPWR VGND VPWR VGND sky130_ef_sc_hd__decap_12
XFILLER_87_575 VPWR VGND VPWR VGND sky130_ef_sc_hd__decap_12
XFILLER_59_288 VGND VGND VPWR VPWR sky130_fd_sc_hd__decap_6
X_09719_ _02122_ _02261_ VGND VGND VPWR VPWR _02262_ sky130_fd_sc_hd__nor2_4
XFILLER_27_152 VPWR VGND VPWR VGND sky130_ef_sc_hd__decap_12
X_10991_ _03641_ _03643_ _03644_ VGND VGND VPWR VPWR _03646_ sky130_fd_sc_hd__a21o_1
XFILLER_28_653 VGND VGND VPWR VPWR sky130_fd_sc_hd__decap_3
XTAP_TAPCELL_ROW_124_2090 VGND VPWR sky130_fd_sc_hd__tapvpwrvgnd_1
X_12730_ _05537_ _05539_ _05521_ VGND VGND VPWR VPWR _05541_ sky130_fd_sc_hd__a21o_1
X_12661_ _05463_ _05464_ VGND VGND VPWR VPWR _05465_ sky130_fd_sc_hd__xnor2_1
XFILLER_70_475 VGND VGND VPWR VPWR sky130_fd_sc_hd__fill_1
XFILLER_43_689 VGND VGND VPWR VPWR sky130_fd_sc_hd__fill_1
XFILLER_42_188 VGND VGND VPWR VPWR sky130_fd_sc_hd__decap_8
X_11612_ _04173_ _04322_ VGND VGND VPWR VPWR _04323_ sky130_fd_sc_hd__xnor2_1
XFILLER_30_317 VGND VGND VPWR VPWR sky130_fd_sc_hd__fill_2
X_12592_ _05213_ _05388_ VGND VGND VPWR VPWR _05390_ sky130_fd_sc_hd__nor2_1
XFILLER_11_531 VGND VGND VPWR VPWR sky130_fd_sc_hd__decap_3
X_11543_ _04118_ _04120_ _04117_ VGND VGND VPWR VPWR _04248_ sky130_fd_sc_hd__o21ba_1
X_11474_ net304 net301 net535 net532 VGND VGND VPWR VPWR _04173_ sky130_fd_sc_hd__and4b_1
XFILLER_11_597 VGND VGND VPWR VPWR sky130_fd_sc_hd__fill_1
XFILLER_137_783 VGND VGND VPWR VPWR sky130_fd_sc_hd__fill_1
XFILLER_109_474 VGND VGND VPWR VPWR sky130_fd_sc_hd__decap_3
X_13213_ _06064_ _06066_ VGND VGND VPWR VPWR _06067_ sky130_fd_sc_hd__or2_1
XFILLER_7_568 VGND VGND VPWR VPWR sky130_fd_sc_hd__decap_8
X_10425_ _03022_ _03024_ _02982_ VGND VGND VPWR VPWR _03027_ sky130_fd_sc_hd__o21a_1
XFILLER_124_433 VGND VGND VPWR VPWR sky130_fd_sc_hd__fill_2
X_13144_ _05989_ _05990_ VGND VGND VPWR VPWR _05992_ sky130_fd_sc_hd__xor2_2
XFILLER_124_477 VGND VGND VPWR VPWR sky130_fd_sc_hd__decap_6
XTAP_TAPCELL_ROW_111_1912 VGND VPWR sky130_fd_sc_hd__tapvpwrvgnd_1
XFILLER_3_741 VPWR VGND VPWR VGND sky130_ef_sc_hd__decap_12
X_10356_ net527 net520 net291 net293 VGND VGND VPWR VPWR _02951_ sky130_fd_sc_hd__and4_1
X_13075_ _05603_ _05914_ VGND VGND VPWR VPWR _05916_ sky130_fd_sc_hd__xnor2_1
XFILLER_3_785 VPWR VGND VPWR VGND sky130_ef_sc_hd__decap_12
X_10287_ _02829_ _02875_ VGND VGND VPWR VPWR _02876_ sky130_fd_sc_hd__nand2_1
XFILLER_111_149 VPWR VGND VPWR VGND sky130_ef_sc_hd__decap_12
X_12026_ net556 net711 net695 net565 VGND VGND VPWR VPWR _04770_ sky130_fd_sc_hd__a22o_1
XFILLER_78_564 VPWR VGND VPWR VGND sky130_ef_sc_hd__decap_12
XTAP_TAPCELL_ROW_53_1074 VGND VPWR sky130_fd_sc_hd__tapvpwrvgnd_1
XTAP_TAPCELL_ROW_53_1063 VGND VPWR sky130_fd_sc_hd__tapvpwrvgnd_1
XFILLER_120_683 VPWR VGND VPWR VGND sky130_ef_sc_hd__decap_12
XFILLER_93_512 VGND VGND VPWR VPWR sky130_fd_sc_hd__fill_2
XFILLER_66_737 VPWR VGND VPWR VGND sky130_ef_sc_hd__decap_12
XTAP_TAPCELL_ROW_109_1874 VGND VPWR sky130_fd_sc_hd__tapvpwrvgnd_1
XFILLER_81_729 VGND VGND VPWR VPWR sky130_fd_sc_hd__decap_6
XTAP_TAPCELL_ROW_109_1885 VGND VPWR sky130_fd_sc_hd__tapvpwrvgnd_1
X_12928_ _05754_ _05753_ VGND VGND VPWR VPWR _05756_ sky130_fd_sc_hd__and2b_1
XFILLER_46_494 VPWR VGND VPWR VGND sky130_ef_sc_hd__decap_12
XFILLER_61_453 VGND VGND VPWR VPWR sky130_fd_sc_hd__fill_1
XFILLER_61_431 VGND VGND VPWR VPWR sky130_fd_sc_hd__fill_1
X_12859_ net607 net353 VGND VGND VPWR VPWR _05681_ sky130_fd_sc_hd__nand2_1
XFILLER_21_328 VGND VGND VPWR VPWR sky130_fd_sc_hd__fill_1
XFILLER_14_391 VPWR VGND VPWR VGND sky130_ef_sc_hd__decap_12
X_08050_ _00525_ _00526_ VGND VGND VPWR VPWR _00527_ sky130_fd_sc_hd__nor2_1
XFILLER_134_208 VGND VGND VPWR VPWR sky130_fd_sc_hd__decap_8
XFILLER_115_400 VGND VGND VPWR VPWR sky130_fd_sc_hd__fill_1
X_07001_ net98 net632 VGND VGND VPWR VPWR _03347_ sky130_fd_sc_hd__nand2_1
XFILLER_103_617 VPWR VGND VPWR VGND sky130_ef_sc_hd__decap_12
XFILLER_88_306 VGND VGND VPWR VPWR sky130_fd_sc_hd__fill_2
X_08952_ _01297_ _01423_ _01424_ VGND VGND VPWR VPWR _01425_ sky130_fd_sc_hd__and3_1
XFILLER_88_328 VGND VGND VPWR VPWR sky130_fd_sc_hd__decap_3
XFILLER_88_317 VGND VGND VPWR VPWR sky130_fd_sc_hd__fill_2
X_08883_ _01270_ _01271_ _01347_ _01349_ VGND VGND VPWR VPWR _01350_ sky130_fd_sc_hd__nor4_1
XFILLER_69_553 VGND VGND VPWR VPWR sky130_fd_sc_hd__decap_6
X_07903_ _00366_ _00379_ VGND VGND VPWR VPWR _00381_ sky130_fd_sc_hd__xnor2_2
XFILLER_111_683 VGND VGND VPWR VPWR sky130_fd_sc_hd__decap_8
XFILLER_69_597 VGND VGND VPWR VPWR sky130_fd_sc_hd__decap_8
X_07834_ net245 _00311_ VGND VGND VPWR VPWR _00312_ sky130_fd_sc_hd__nor2_1
XFILLER_84_589 VPWR VGND VPWR VGND sky130_ef_sc_hd__decap_12
X_07765_ net709 net610 _00099_ _00098_ VGND VGND VPWR VPWR _00244_ sky130_fd_sc_hd__a31o_1
X_09504_ _01696_ _01865_ _01864_ VGND VGND VPWR VPWR _02026_ sky130_fd_sc_hd__a21o_1
XTAP_TAPCELL_ROW_84_1524 VGND VPWR sky130_fd_sc_hd__tapvpwrvgnd_1
XTAP_TAPCELL_ROW_84_1513 VGND VPWR sky130_fd_sc_hd__tapvpwrvgnd_1
XFILLER_71_217 VGND VGND VPWR VPWR sky130_fd_sc_hd__decap_6
X_07696_ _00172_ net252 VGND VGND VPWR VPWR _00175_ sky130_fd_sc_hd__xor2_1
XTAP_TAPCELL_ROW_48_990 VGND VPWR sky130_fd_sc_hd__tapvpwrvgnd_1
X_09435_ _01796_ _01798_ VGND VGND VPWR VPWR _01951_ sky130_fd_sc_hd__nand2_1
XFILLER_80_740 VGND VGND VPWR VPWR sky130_fd_sc_hd__decap_6
XFILLER_72_29 VPWR VGND VPWR VGND sky130_ef_sc_hd__decap_12
X_09366_ _01874_ _01875_ VGND VGND VPWR VPWR _01876_ sky130_fd_sc_hd__and2_1
XFILLER_12_328 VGND VGND VPWR VPWR sky130_fd_sc_hd__decap_3
XFILLER_40_637 VGND VGND VPWR VPWR sky130_fd_sc_hd__decap_6
XFILLER_138_525 VGND VGND VPWR VPWR sky130_fd_sc_hd__decap_6
X_09297_ _01798_ _01799_ _01783_ VGND VGND VPWR VPWR _01801_ sky130_fd_sc_hd__a21oi_1
X_08317_ _00557_ _00791_ VGND VGND VPWR VPWR _00792_ sky130_fd_sc_hd__xnor2_1
XFILLER_138_569 VGND VGND VPWR VPWR sky130_fd_sc_hd__fill_1
X_08248_ _00258_ _00622_ VGND VGND VPWR VPWR _00723_ sky130_fd_sc_hd__nand2_1
XFILLER_21_55 VGND VGND VPWR VPWR sky130_fd_sc_hd__fill_1
XFILLER_137_55 VGND VGND VPWR VPWR sky130_fd_sc_hd__fill_1
X_10210_ net231 _01243_ VGND VGND VPWR VPWR _00054_ sky130_fd_sc_hd__xor2_1
XFILLER_106_433 VPWR VGND VPWR VGND sky130_ef_sc_hd__decap_12
X_08179_ _00641_ _00654_ VGND VGND VPWR VPWR _00655_ sky130_fd_sc_hd__or2_1
XFILLER_133_241 VGND VGND VPWR VPWR sky130_fd_sc_hd__decap_4
XTAP_TAPCELL_ROW_95_1675 VGND VPWR sky130_fd_sc_hd__tapvpwrvgnd_1
X_11190_ _03538_ _03698_ _03696_ VGND VGND VPWR VPWR _03864_ sky130_fd_sc_hd__a21bo_1
XFILLER_133_263 VPWR VGND VPWR VGND sky130_ef_sc_hd__decap_12
X_10141_ _02363_ _02607_ _02235_ VGND VGND VPWR VPWR _02721_ sky130_fd_sc_hd__o21bai_1
XFILLER_106_477 VGND VGND VPWR VPWR sky130_fd_sc_hd__fill_1
Xoutput180 net180 VGND VGND VPWR VPWR y1[10] sky130_fd_sc_hd__buf_2
X_10072_ _02644_ _02645_ VGND VGND VPWR VPWR _02646_ sky130_fd_sc_hd__or2_1
Xoutput191 net191 VGND VGND VPWR VPWR y1[5] sky130_fd_sc_hd__buf_2
XFILLER_121_469 VPWR VGND VPWR VGND sky130_ef_sc_hd__decap_12
XFILLER_121_447 VGND VGND VPWR VPWR sky130_fd_sc_hd__fill_1
XFILLER_94_309 VGND VGND VPWR VPWR sky130_fd_sc_hd__fill_1
XFILLER_48_726 VGND VGND VPWR VPWR sky130_fd_sc_hd__fill_1
XTAP_TAPCELL_ROW_7_398 VGND VPWR sky130_fd_sc_hd__tapvpwrvgnd_1
XTAP_TAPCELL_ROW_126_2130 VGND VPWR sky130_fd_sc_hd__tapvpwrvgnd_1
XFILLER_47_225 VGND VGND VPWR VPWR sky130_fd_sc_hd__decap_4
XFILLER_101_193 VPWR VGND VPWR VGND sky130_ef_sc_hd__decap_12
XFILLER_75_556 VGND VGND VPWR VPWR sky130_fd_sc_hd__decap_4
XFILLER_63_718 VGND VGND VPWR VPWR sky130_fd_sc_hd__fill_1
XFILLER_46_41 VPWR VGND VPWR VGND sky130_ef_sc_hd__decap_12
XFILLER_90_526 VGND VGND VPWR VPWR sky130_fd_sc_hd__decap_6
XFILLER_56_792 VPWR VGND VPWR VGND sky130_ef_sc_hd__decap_12
XFILLER_46_85 VPWR VGND VPWR VGND sky130_ef_sc_hd__decap_12
X_10974_ _03626_ _03594_ VGND VGND VPWR VPWR _03627_ sky130_fd_sc_hd__and2b_1
X_12713_ net630 net621 net338 net320 VGND VGND VPWR VPWR _05522_ sky130_fd_sc_hd__and4_1
XFILLER_15_122 VGND VGND VPWR VPWR sky130_fd_sc_hd__decap_8
XFILLER_16_645 VGND VGND VPWR VPWR sky130_fd_sc_hd__decap_4
XFILLER_16_667 VGND VGND VPWR VPWR sky130_fd_sc_hd__decap_4
X_13693_ clknet_3_3__leaf_clk _00052_ net713 VGND VGND VPWR VPWR net228 sky130_fd_sc_hd__dfrtp_1
XFILLER_43_486 VPWR VGND VPWR VGND sky130_ef_sc_hd__decap_12
XTAP_TAPCELL_ROW_26_673 VGND VPWR sky130_fd_sc_hd__tapvpwrvgnd_1
X_12644_ _05424_ _05445_ VGND VGND VPWR VPWR _05446_ sky130_fd_sc_hd__nand2b_1
X_12575_ _05368_ _05369_ VGND VGND VPWR VPWR _05371_ sky130_fd_sc_hd__xor2_1
XFILLER_8_811 VGND VGND VPWR VPWR sky130_fd_sc_hd__fill_1
X_11526_ _04220_ _04229_ VGND VGND VPWR VPWR _04230_ sky130_fd_sc_hd__xnor2_1
XTAP_TAPCELL_ROW_137_2292 VGND VPWR sky130_fd_sc_hd__tapvpwrvgnd_1
XTAP_TAPCELL_ROW_137_2281 VGND VPWR sky130_fd_sc_hd__tapvpwrvgnd_1
XFILLER_7_57 VPWR VGND VPWR VGND sky130_ef_sc_hd__decap_12
XFILLER_109_293 VPWR VGND VPWR VGND sky130_ef_sc_hd__decap_12
XFILLER_109_271 VGND VGND VPWR VPWR sky130_fd_sc_hd__decap_8
X_11457_ _04026_ _04154_ VGND VGND VPWR VPWR _04155_ sky130_fd_sc_hd__xnor2_1
XFILLER_7_376 VPWR VGND VPWR VGND sky130_ef_sc_hd__decap_12
XTAP_TAPCELL_ROW_55_1103 VGND VPWR sky130_fd_sc_hd__tapvpwrvgnd_1
X_11388_ net492 _03770_ VGND VGND VPWR VPWR _04080_ sky130_fd_sc_hd__nand2_2
X_10408_ _03005_ _03006_ _03004_ VGND VGND VPWR VPWR _03009_ sky130_fd_sc_hd__o21bai_1
XFILLER_125_797 VPWR VGND VPWR VGND sky130_ef_sc_hd__decap_12
XFILLER_98_648 VPWR VGND VPWR VGND sky130_ef_sc_hd__decap_12
X_13127_ net428 net381 net379 net437 VGND VGND VPWR VPWR _05973_ sky130_fd_sc_hd__a22oi_1
X_10339_ _02905_ _02906_ _02932_ VGND VGND VPWR VPWR _02933_ sky130_fd_sc_hd__or3_1
XFILLER_100_609 VGND VGND VPWR VPWR sky130_fd_sc_hd__decap_6
X_13058_ _05741_ _05745_ _05896_ VGND VGND VPWR VPWR _05898_ sky130_fd_sc_hd__o21ai_1
XFILLER_97_169 VPWR VGND VPWR VGND sky130_ef_sc_hd__decap_12
XFILLER_94_810 VGND VGND VPWR VPWR sky130_fd_sc_hd__fill_2
XFILLER_87_81 VPWR VGND VPWR VGND sky130_ef_sc_hd__decap_12
X_12009_ _04701_ _04752_ VGND VGND VPWR VPWR _04753_ sky130_fd_sc_hd__nand2_1
XFILLER_120_491 VPWR VGND VPWR VGND sky130_ef_sc_hd__decap_12
XFILLER_93_331 VGND VGND VPWR VPWR sky130_fd_sc_hd__fill_1
XFILLER_16_3 VPWR VGND VPWR VGND sky130_ef_sc_hd__decap_12
XFILLER_66_589 VGND VGND VPWR VPWR sky130_fd_sc_hd__fill_2
XFILLER_47_770 VPWR VGND VPWR VGND sky130_ef_sc_hd__decap_12
X_07550_ _06778_ _06735_ VGND VGND VPWR VPWR _06779_ sky130_fd_sc_hd__and2b_1
XTAP_TAPCELL_ROW_66_1254 VGND VPWR sky130_fd_sc_hd__tapvpwrvgnd_1
X_09220_ _01713_ _01715_ VGND VGND VPWR VPWR _01717_ sky130_fd_sc_hd__xor2_1
X_07481_ _06708_ _06709_ VGND VGND VPWR VPWR _06711_ sky130_fd_sc_hd__xor2_1
XFILLER_34_475 VGND VGND VPWR VPWR sky130_fd_sc_hd__fill_1
XFILLER_22_659 VGND VGND VPWR VPWR sky130_fd_sc_hd__fill_1
X_09151_ _01465_ _01641_ VGND VGND VPWR VPWR _01642_ sky130_fd_sc_hd__xnor2_1
X_09082_ _01521_ _01565_ VGND VGND VPWR VPWR _01567_ sky130_fd_sc_hd__xnor2_1
X_08102_ _00482_ _00484_ VGND VGND VPWR VPWR _00578_ sky130_fd_sc_hd__nand2_1
XFILLER_135_517 VPWR VGND VPWR VGND sky130_ef_sc_hd__decap_12
X_08033_ _00504_ _00509_ VGND VGND VPWR VPWR _00510_ sky130_fd_sc_hd__xnor2_1
Xinput60 w13[2] VGND VGND VPWR VPWR net60 sky130_fd_sc_hd__buf_1
Xinput71 w20[5] VGND VGND VPWR VPWR net71 sky130_fd_sc_hd__clkbuf_2
Xinput82 w22[0] VGND VGND VPWR VPWR net82 sky130_fd_sc_hd__clkbuf_2
XFILLER_116_753 VGND VGND VPWR VPWR sky130_fd_sc_hd__decap_3
Xinput93 w23[3] VGND VGND VPWR VPWR net93 sky130_fd_sc_hd__clkbuf_2
XFILLER_89_615 VGND VGND VPWR VPWR sky130_fd_sc_hd__fill_1
XFILLER_88_114 VGND VGND VPWR VPWR sky130_fd_sc_hd__decap_3
X_09984_ _02535_ _02548_ VGND VGND VPWR VPWR _02550_ sky130_fd_sc_hd__and2_1
XFILLER_115_296 VPWR VGND VPWR VGND sky130_ef_sc_hd__decap_12
XFILLER_107_69 VPWR VGND VPWR VGND sky130_ef_sc_hd__decap_12
XFILLER_103_447 VGND VGND VPWR VPWR sky130_fd_sc_hd__fill_1
X_08935_ _01366_ _01404_ VGND VGND VPWR VPWR _01406_ sky130_fd_sc_hd__xor2_1
XFILLER_76_309 VGND VGND VPWR VPWR sky130_fd_sc_hd__decap_8
XFILLER_69_350 VGND VGND VPWR VPWR sky130_fd_sc_hd__decap_4
X_08866_ _01328_ _01329_ _01330_ VGND VGND VPWR VPWR _01332_ sky130_fd_sc_hd__nand3_1
XFILLER_84_331 VGND VGND VPWR VPWR sky130_fd_sc_hd__decap_6
XTAP_TAPCELL_ROW_4_357 VGND VPWR sky130_fd_sc_hd__tapvpwrvgnd_1
X_08797_ _01130_ _01262_ VGND VGND VPWR VPWR _01263_ sky130_fd_sc_hd__xor2_1
XFILLER_123_57 VPWR VGND VPWR VGND sky130_ef_sc_hd__decap_12
XFILLER_57_556 VGND VGND VPWR VPWR sky130_fd_sc_hd__decap_4
X_07817_ _00186_ _00188_ _00293_ VGND VGND VPWR VPWR _00295_ sky130_fd_sc_hd__and3_1
XFILLER_83_39 VPWR VGND VPWR VGND sky130_ef_sc_hd__decap_12
X_07748_ net434 net666 net425 net667 VGND VGND VPWR VPWR _00227_ sky130_fd_sc_hd__a22oi_1
XFILLER_25_420 VGND VGND VPWR VPWR sky130_fd_sc_hd__fill_1
XTAP_TAPCELL_ROW_121_2060 VGND VPWR sky130_fd_sc_hd__tapvpwrvgnd_1
XTAP_TAPCELL_ROW_43_919 VGND VPWR sky130_fd_sc_hd__tapvpwrvgnd_1
X_07679_ _00156_ _00157_ VGND VGND VPWR VPWR _00158_ sky130_fd_sc_hd__and2_1
X_09418_ net522 net343 _01767_ _01766_ VGND VGND VPWR VPWR _01933_ sky130_fd_sc_hd__a31o_1
XFILLER_13_659 VGND VGND VPWR VPWR sky130_fd_sc_hd__fill_1
XTAP_TAPCELL_ROW_23_632 VGND VPWR sky130_fd_sc_hd__tapvpwrvgnd_1
XFILLER_25_497 VGND VGND VPWR VPWR sky130_fd_sc_hd__fill_1
X_10690_ net638 net70 VGND VGND VPWR VPWR _03317_ sky130_fd_sc_hd__nand2_1
X_09349_ _01855_ _01856_ _01680_ VGND VGND VPWR VPWR _01859_ sky130_fd_sc_hd__a21oi_1
XFILLER_138_322 VGND VGND VPWR VPWR sky130_fd_sc_hd__decap_3
XTAP_TAPCELL_ROW_97_1704 VGND VPWR sky130_fd_sc_hd__tapvpwrvgnd_1
X_12360_ _05127_ _05135_ VGND VGND VPWR VPWR _05136_ sky130_fd_sc_hd__and2_1
XFILLER_32_65 VGND VGND VPWR VPWR sky130_fd_sc_hd__decap_3
XFILLER_120_3 VPWR VGND VPWR VGND sky130_ef_sc_hd__decap_12
XFILLER_20_180 VGND VGND VPWR VPWR sky130_fd_sc_hd__decap_8
X_11311_ _03993_ _03994_ VGND VGND VPWR VPWR _03996_ sky130_fd_sc_hd__xor2_1
XFILLER_126_528 VGND VGND VPWR VPWR sky130_fd_sc_hd__decap_4
X_12291_ _05056_ _05059_ _04913_ _04917_ VGND VGND VPWR VPWR _05061_ sky130_fd_sc_hd__o211a_1
XFILLER_107_753 VPWR VGND VPWR VGND sky130_ef_sc_hd__decap_12
XFILLER_4_357 VGND VGND VPWR VPWR sky130_fd_sc_hd__decap_6
X_11242_ _03801_ _03818_ _03816_ VGND VGND VPWR VPWR _03920_ sky130_fd_sc_hd__a21oi_1
XFILLER_121_200 VGND VGND VPWR VPWR sky130_fd_sc_hd__decap_3
XFILLER_107_797 VPWR VGND VPWR VGND sky130_ef_sc_hd__decap_12
XFILLER_4_368 VPWR VGND VPWR VGND sky130_ef_sc_hd__decap_12
X_11173_ _03830_ _03844_ VGND VGND VPWR VPWR _03845_ sky130_fd_sc_hd__xnor2_1
X_10124_ _02614_ _02701_ _02610_ VGND VGND VPWR VPWR _02702_ sky130_fd_sc_hd__and3b_1
XFILLER_79_147 VPWR VGND VPWR VGND sky130_ef_sc_hd__decap_12
XFILLER_121_277 VGND VGND VPWR VPWR sky130_fd_sc_hd__decap_3
XFILLER_79_169 VGND VGND VPWR VPWR sky130_fd_sc_hd__decap_8
X_10055_ _02547_ _02549_ _02625_ VGND VGND VPWR VPWR _02627_ sky130_fd_sc_hd__nor3_1
XFILLER_94_139 VGND VGND VPWR VPWR sky130_fd_sc_hd__fill_1
XFILLER_57_51 VGND VGND VPWR VPWR sky130_fd_sc_hd__decap_4
XTAP_TAPCELL_ROW_50_1022 VGND VPWR sky130_fd_sc_hd__tapvpwrvgnd_1
XFILLER_75_353 VGND VGND VPWR VPWR sky130_fd_sc_hd__decap_6
XFILLER_57_95 VGND VGND VPWR VPWR sky130_fd_sc_hd__fill_1
XFILLER_36_707 VGND VGND VPWR VPWR sky130_fd_sc_hd__fill_1
XFILLER_48_589 VGND VGND VPWR VPWR sky130_fd_sc_hd__fill_1
XFILLER_35_217 VGND VGND VPWR VPWR sky130_fd_sc_hd__decap_6
XTAP_TAPCELL_ROW_106_1833 VGND VPWR sky130_fd_sc_hd__tapvpwrvgnd_1
XFILLER_44_740 VGND VGND VPWR VPWR sky130_fd_sc_hd__decap_3
XFILLER_16_453 VGND VGND VPWR VPWR sky130_fd_sc_hd__fill_2
X_10957_ _03607_ _03606_ VGND VGND VPWR VPWR _03608_ sky130_fd_sc_hd__and2b_1
XFILLER_31_401 VGND VGND VPWR VPWR sky130_fd_sc_hd__fill_2
XFILLER_71_581 VGND VGND VPWR VPWR sky130_fd_sc_hd__fill_1
X_13676_ clknet_3_2__leaf_clk _00024_ net712 VGND VGND VPWR VPWR net211 sky130_fd_sc_hd__dfrtp_1
X_12627_ net507 net399 _05278_ _05277_ VGND VGND VPWR VPWR _05427_ sky130_fd_sc_hd__a31o_1
X_10888_ _03530_ _03531_ _03532_ VGND VGND VPWR VPWR _03534_ sky130_fd_sc_hd__o21ai_1
XFILLER_31_478 VGND VGND VPWR VPWR sky130_fd_sc_hd__decap_6
XFILLER_129_344 VGND VGND VPWR VPWR sky130_fd_sc_hd__decap_8
XTAP_TAPCELL_ROW_61_1184 VGND VPWR sky130_fd_sc_hd__tapvpwrvgnd_1
XPHY_EDGE_ROW_130_Left_269 VGND VGND VPWR VPWR sky130_fd_sc_hd__decap_3
X_12558_ _05350_ _05351_ VGND VGND VPWR VPWR _05353_ sky130_fd_sc_hd__nor2_1
XFILLER_8_674 VGND VGND VPWR VPWR sky130_fd_sc_hd__fill_1
XFILLER_7_140 VPWR VGND VPWR VGND sky130_ef_sc_hd__decap_12
XFILLER_11_191 VGND VGND VPWR VPWR sky130_fd_sc_hd__decap_6
XFILLER_129_388 VGND VGND VPWR VPWR sky130_fd_sc_hd__decap_4
X_12489_ net514 net396 _04985_ VGND VGND VPWR VPWR _05277_ sky130_fd_sc_hd__and3_1
X_11509_ net492 _00342_ _04080_ net286 VGND VGND VPWR VPWR _04212_ sky130_fd_sc_hd__o211ai_4
XFILLER_125_561 VGND VGND VPWR VPWR sky130_fd_sc_hd__decap_8
XTAP_TAPCELL_ROW_117_1995 VGND VPWR sky130_fd_sc_hd__tapvpwrvgnd_1
XFILLER_98_401 VPWR VGND VPWR VGND sky130_ef_sc_hd__decap_12
Xfanout609 net612 VGND VGND VPWR VPWR net609 sky130_fd_sc_hd__buf_2
X_06981_ net122 net435 VGND VGND VPWR VPWR _03128_ sky130_fd_sc_hd__nand2_1
XFILLER_58_309 VGND VGND VPWR VPWR sky130_fd_sc_hd__decap_8
X_08720_ _01178_ _01179_ _01186_ VGND VGND VPWR VPWR _01187_ sky130_fd_sc_hd__and3_1
XFILLER_79_692 VGND VGND VPWR VPWR sky130_fd_sc_hd__decap_8
X_08651_ _01093_ _01094_ _01117_ VGND VGND VPWR VPWR _01118_ sky130_fd_sc_hd__or3_1
XFILLER_82_813 VGND VGND VPWR VPWR sky130_fd_sc_hd__decap_4
XFILLER_66_353 VGND VGND VPWR VPWR sky130_fd_sc_hd__decap_3
XTAP_TAPCELL_ROW_1_316 VGND VPWR sky130_fd_sc_hd__tapvpwrvgnd_1
X_07602_ _00078_ _00079_ _00080_ VGND VGND VPWR VPWR _00082_ sky130_fd_sc_hd__a21o_1
XFILLER_27_729 VGND VGND VPWR VPWR sky130_fd_sc_hd__decap_3
X_08582_ net516 net352 VGND VGND VPWR VPWR _01050_ sky130_fd_sc_hd__nand2_1
XFILLER_26_239 VGND VGND VPWR VPWR sky130_fd_sc_hd__fill_1
X_07533_ net588 net579 VGND VGND VPWR VPWR _06762_ sky130_fd_sc_hd__or2_4
X_07464_ net153 _06693_ VGND VGND VPWR VPWR _06694_ sky130_fd_sc_hd__xnor2_4
X_09203_ _01696_ _01697_ VGND VGND VPWR VPWR _01698_ sky130_fd_sc_hd__or2_1
XFILLER_50_765 VPWR VGND VPWR VGND sky130_ef_sc_hd__decap_12
X_09134_ net262 net377 _01619_ _01621_ VGND VGND VPWR VPWR _01623_ sky130_fd_sc_hd__or4b_1
X_07395_ net510 net678 _04686_ VGND VGND VPWR VPWR _06625_ sky130_fd_sc_hd__and3_1
X_09065_ _01411_ _01421_ _01419_ _01418_ VGND VGND VPWR VPWR _01548_ sky130_fd_sc_hd__a2bb2o_1
XTAP_TAPCELL_ROW_79_1445 VGND VPWR sky130_fd_sc_hd__tapvpwrvgnd_1
XFILLER_135_369 VGND VGND VPWR VPWR sky130_fd_sc_hd__decap_6
X_08016_ _00486_ _00492_ VGND VGND VPWR VPWR _00493_ sky130_fd_sc_hd__xnor2_1
XFILLER_104_701 VPWR VGND VPWR VGND sky130_ef_sc_hd__decap_12
XTAP_TAPCELL_ROW_92_1634 VGND VPWR sky130_fd_sc_hd__tapvpwrvgnd_1
XTAP_TAPCELL_ROW_9_427 VGND VPWR sky130_fd_sc_hd__tapvpwrvgnd_1
X_09967_ net260 net344 VGND VGND VPWR VPWR _02531_ sky130_fd_sc_hd__nor2_1
XFILLER_77_629 VPWR VGND VPWR VGND sky130_ef_sc_hd__decap_12
XFILLER_131_597 VPWR VGND VPWR VGND sky130_ef_sc_hd__decap_12
X_08918_ net585 net357 net355 net595 VGND VGND VPWR VPWR _01388_ sky130_fd_sc_hd__a22o_1
XFILLER_94_27 VGND VGND VPWR VPWR sky130_fd_sc_hd__fill_1
XFILLER_58_821 VGND VGND VPWR VPWR sky130_fd_sc_hd__decap_3
X_09898_ _02454_ _02455_ VGND VGND VPWR VPWR _00057_ sky130_fd_sc_hd__and2b_1
X_08849_ net615 net377 VGND VGND VPWR VPWR _01315_ sky130_fd_sc_hd__nand2_1
XTAP_TAPCELL_ROW_28_702 VGND VPWR sky130_fd_sc_hd__tapvpwrvgnd_1
XFILLER_45_559 VGND VGND VPWR VPWR sky130_fd_sc_hd__fill_1
X_11860_ _04579_ _04593_ VGND VGND VPWR VPWR _04594_ sky130_fd_sc_hd__xnor2_1
X_11791_ _04330_ _04333_ _04518_ VGND VGND VPWR VPWR _04519_ sky130_fd_sc_hd__o21a_1
X_10811_ _03433_ _03448_ VGND VGND VPWR VPWR _03449_ sky130_fd_sc_hd__xnor2_1
XFILLER_26_762 VGND VGND VPWR VPWR sky130_fd_sc_hd__fill_2
XFILLER_26_784 VPWR VGND VPWR VGND sky130_ef_sc_hd__decap_12
X_13530_ _06215_ _06314_ _06412_ VGND VGND VPWR VPWR _06413_ sky130_fd_sc_hd__o21ai_1
X_10742_ net568 net561 net306 net305 VGND VGND VPWR VPWR _03373_ sky130_fd_sc_hd__and4_1
XFILLER_13_434 VGND VGND VPWR VPWR sky130_fd_sc_hd__fill_1
XFILLER_41_754 VPWR VGND VPWR VGND sky130_ef_sc_hd__decap_12
XFILLER_40_231 VGND VGND VPWR VPWR sky130_fd_sc_hd__fill_1
XFILLER_40_253 VGND VGND VPWR VPWR sky130_fd_sc_hd__decap_3
XTAP_TAPCELL_ROW_101_1763 VGND VPWR sky130_fd_sc_hd__tapvpwrvgnd_1
X_13461_ _06336_ _06337_ VGND VGND VPWR VPWR _06338_ sky130_fd_sc_hd__nand2_1
XFILLER_9_449 VPWR VGND VPWR VGND sky130_ef_sc_hd__decap_12
X_10673_ _03287_ _03296_ _03297_ VGND VGND VPWR VPWR _03298_ sky130_fd_sc_hd__nand3_1
XFILLER_138_141 VPWR VGND VPWR VGND sky130_ef_sc_hd__decap_12
X_13392_ net381 _05285_ net412 VGND VGND VPWR VPWR _06263_ sky130_fd_sc_hd__and3b_1
X_12412_ _05172_ _05191_ _05192_ VGND VGND VPWR VPWR _05193_ sky130_fd_sc_hd__and3_1
XTAP_TAPCELL_ROW_134_2240 VGND VPWR sky130_fd_sc_hd__tapvpwrvgnd_1
X_12343_ net497 net402 VGND VGND VPWR VPWR _05117_ sky130_fd_sc_hd__nand2_1
X_12274_ net470 net385 _04877_ _04875_ VGND VGND VPWR VPWR _05042_ sky130_fd_sc_hd__a31o_1
XFILLER_5_655 VPWR VGND VPWR VGND sky130_ef_sc_hd__decap_12
XFILLER_107_561 VPWR VGND VPWR VGND sky130_ef_sc_hd__decap_12
XFILLER_4_165 VPWR VGND VPWR VGND sky130_ef_sc_hd__decap_12
X_11225_ _03570_ _03573_ VGND VGND VPWR VPWR _03901_ sky130_fd_sc_hd__nor2_1
XFILLER_134_380 VPWR VGND VPWR VGND sky130_ef_sc_hd__decap_12
XFILLER_122_520 VPWR VGND VPWR VGND sky130_ef_sc_hd__decap_12
XFILLER_4_187 VGND VGND VPWR VPWR sky130_fd_sc_hd__decap_8
X_11156_ _03457_ _03824_ VGND VGND VPWR VPWR _03826_ sky130_fd_sc_hd__xnor2_1
X_10107_ _02494_ _02587_ VGND VGND VPWR VPWR _02683_ sky130_fd_sc_hd__xnor2_1
XFILLER_95_426 VGND VGND VPWR VPWR sky130_fd_sc_hd__fill_2
X_11087_ _03741_ _03748_ VGND VGND VPWR VPWR _03750_ sky130_fd_sc_hd__xor2_1
X_10038_ _02363_ _02607_ VGND VGND VPWR VPWR _02609_ sky130_fd_sc_hd__xor2_2
XFILLER_0_393 VGND VGND VPWR VPWR sky130_fd_sc_hd__decap_3
XFILLER_64_813 VGND VGND VPWR VPWR sky130_fd_sc_hd__decap_6
XFILLER_48_375 VPWR VGND VPWR VGND sky130_ef_sc_hd__decap_12
XFILLER_84_82 VGND VGND VPWR VPWR sky130_fd_sc_hd__fill_2
XFILLER_36_537 VGND VGND VPWR VPWR sky130_fd_sc_hd__fill_1
XFILLER_91_687 VGND VGND VPWR VPWR sky130_fd_sc_hd__decap_8
XFILLER_84_93 VGND VGND VPWR VPWR sky130_fd_sc_hd__fill_1
X_11989_ _04724_ _04728_ VGND VGND VPWR VPWR _04731_ sky130_fd_sc_hd__xnor2_1
XTAP_TAPCELL_ROW_63_1213 VGND VPWR sky130_fd_sc_hd__tapvpwrvgnd_1
XFILLER_16_294 VPWR VGND VPWR VGND sky130_ef_sc_hd__decap_12
X_13659_ clknet_3_7__leaf_clk _00066_ net718 VGND VGND VPWR VPWR net194 sky130_fd_sc_hd__dfrtp_1
XFILLER_83_3 VPWR VGND VPWR VGND sky130_ef_sc_hd__decap_12
XFILLER_31_275 VGND VGND VPWR VPWR sky130_fd_sc_hd__decap_4
X_07180_ _04969_ _04980_ _05264_ _05275_ VGND VGND VPWR VPWR _05297_ sky130_fd_sc_hd__o22a_1
XTAP_TAPCELL_ROW_14_495 VGND VPWR sky130_fd_sc_hd__tapvpwrvgnd_1
XFILLER_129_163 VGND VGND VPWR VPWR sky130_fd_sc_hd__decap_4
XFILLER_117_314 VGND VGND VPWR VPWR sky130_fd_sc_hd__fill_2
X_09821_ net331 net413 VGND VGND VPWR VPWR _02373_ sky130_fd_sc_hd__and2b_1
Xfanout439 net440 VGND VGND VPWR VPWR net439 sky130_fd_sc_hd__clkbuf_4
Xfanout406 net19 VGND VGND VPWR VPWR net406 sky130_fd_sc_hd__buf_2
Xfanout428 net432 VGND VGND VPWR VPWR net428 sky130_fd_sc_hd__clkbuf_4
XTAP_TAPCELL_ROW_74_1375 VGND VPWR sky130_fd_sc_hd__tapvpwrvgnd_1
Xfanout417 net160 VGND VGND VPWR VPWR net417 sky130_fd_sc_hd__buf_2
XFILLER_113_597 VGND VGND VPWR VPWR sky130_fd_sc_hd__fill_2
X_09752_ _02272_ _02297_ VGND VGND VPWR VPWR _02298_ sky130_fd_sc_hd__xnor2_2
X_08703_ _01167_ _01168_ _01166_ VGND VGND VPWR VPWR _01170_ sky130_fd_sc_hd__a21o_1
XFILLER_100_236 VGND VGND VPWR VPWR sky130_fd_sc_hd__fill_2
X_06964_ net686 net512 net504 net115 VGND VGND VPWR VPWR _02942_ sky130_fd_sc_hd__a22oi_1
X_09683_ _02186_ _02221_ VGND VGND VPWR VPWR _02222_ sky130_fd_sc_hd__and2b_1
XFILLER_73_109 VGND VGND VPWR VPWR sky130_fd_sc_hd__decap_3
XFILLER_67_673 VPWR VGND VPWR VGND sky130_ef_sc_hd__decap_12
X_06895_ _02173_ _02183_ VGND VGND VPWR VPWR _02194_ sky130_fd_sc_hd__or2_1
XFILLER_27_515 VGND VGND VPWR VPWR sky130_fd_sc_hd__decap_4
X_08634_ net596 net586 net44 net362 VGND VGND VPWR VPWR _01101_ sky130_fd_sc_hd__and4_1
XFILLER_82_643 VGND VGND VPWR VPWR sky130_fd_sc_hd__fill_1
XFILLER_66_194 VGND VGND VPWR VPWR sky130_fd_sc_hd__fill_2
XFILLER_64_19 VGND VGND VPWR VPWR sky130_fd_sc_hd__decap_8
XFILLER_54_345 VGND VGND VPWR VPWR sky130_fd_sc_hd__decap_8
X_08565_ net646 net376 net374 net656 VGND VGND VPWR VPWR _01033_ sky130_fd_sc_hd__a22o_1
XFILLER_82_665 VPWR VGND VPWR VGND sky130_ef_sc_hd__decap_12
XFILLER_70_805 VGND VGND VPWR VPWR sky130_fd_sc_hd__fill_1
X_07516_ net694 net554 net692 net563 VGND VGND VPWR VPWR _06745_ sky130_fd_sc_hd__a22o_1
XFILLER_80_29 VPWR VGND VPWR VGND sky130_ef_sc_hd__decap_12
X_08496_ _00909_ _00919_ _00907_ VGND VGND VPWR VPWR _00968_ sky130_fd_sc_hd__a21oi_1
XFILLER_22_242 VGND VGND VPWR VPWR sky130_fd_sc_hd__decap_8
X_07447_ _06657_ _06676_ VGND VGND VPWR VPWR _06677_ sky130_fd_sc_hd__xor2_1
XFILLER_10_415 VGND VGND VPWR VPWR sky130_fd_sc_hd__decap_4
XFILLER_22_253 VGND VGND VPWR VPWR sky130_fd_sc_hd__decap_6
XTAP_TAPCELL_ROW_33_771 VGND VPWR sky130_fd_sc_hd__tapvpwrvgnd_1
XTAP_TAPCELL_ROW_33_782 VGND VPWR sky130_fd_sc_hd__tapvpwrvgnd_1
XFILLER_136_601 VGND VGND VPWR VPWR sky130_fd_sc_hd__fill_2
X_07378_ _06606_ _06607_ VGND VGND VPWR VPWR _06608_ sky130_fd_sc_hd__xor2_1
XFILLER_135_111 VGND VGND VPWR VPWR sky130_fd_sc_hd__fill_1
X_09117_ _01602_ _01603_ VGND VGND VPWR VPWR _01604_ sky130_fd_sc_hd__nand2_1
XFILLER_136_656 VGND VGND VPWR VPWR sky130_fd_sc_hd__decap_4
XFILLER_136_645 VGND VGND VPWR VPWR sky130_fd_sc_hd__fill_1
X_09048_ net574 net567 net359 net358 VGND VGND VPWR VPWR _01530_ sky130_fd_sc_hd__and4_1
XFILLER_135_177 VGND VGND VPWR VPWR sky130_fd_sc_hd__fill_2
XFILLER_1_113 VPWR VGND VPWR VGND sky130_ef_sc_hd__decap_12
XFILLER_104_564 VGND VGND VPWR VPWR sky130_fd_sc_hd__fill_1
X_11010_ net609 net322 VGND VGND VPWR VPWR _03667_ sky130_fd_sc_hd__nand2_1
XFILLER_131_372 VGND VGND VPWR VPWR sky130_fd_sc_hd__decap_3
XFILLER_104_597 VPWR VGND VPWR VGND sky130_ef_sc_hd__decap_12
XFILLER_89_275 VGND VGND VPWR VPWR sky130_fd_sc_hd__decap_4
XFILLER_38_53 VPWR VGND VPWR VGND sky130_ef_sc_hd__decap_12
XFILLER_100_781 VPWR VGND VPWR VGND sky130_ef_sc_hd__decap_12
X_12961_ _05631_ _05634_ VGND VGND VPWR VPWR _05792_ sky130_fd_sc_hd__and2_1
XFILLER_46_813 VGND VGND VPWR VPWR sky130_fd_sc_hd__decap_6
XFILLER_38_97 VPWR VGND VPWR VGND sky130_ef_sc_hd__decap_12
X_12892_ _05714_ _05715_ VGND VGND VPWR VPWR _05717_ sky130_fd_sc_hd__xnor2_1
X_11912_ _04577_ _04578_ _04592_ _04590_ VGND VGND VPWR VPWR _04650_ sky130_fd_sc_hd__a31oi_1
XFILLER_54_41 VPWR VGND VPWR VGND sky130_ef_sc_hd__decap_12
X_11843_ _04573_ _04574_ VGND VGND VPWR VPWR _04575_ sky130_fd_sc_hd__xnor2_1
X_11774_ _04181_ _04315_ _04499_ VGND VGND VPWR VPWR _04500_ sky130_fd_sc_hd__a21o_1
X_13513_ _06392_ _06393_ VGND VGND VPWR VPWR _06395_ sky130_fd_sc_hd__nand2_1
X_10725_ _03060_ _03200_ _03352_ _03353_ VGND VGND VPWR VPWR _03355_ sky130_fd_sc_hd__a22o_1
X_13444_ _06226_ _06228_ _06239_ VGND VGND VPWR VPWR _06319_ sky130_fd_sc_hd__o21a_1
X_10656_ _03277_ _03249_ VGND VGND VPWR VPWR _03279_ sky130_fd_sc_hd__and2b_1
XTAP_TAPCELL_ROW_11_454 VGND VPWR sky130_fd_sc_hd__tapvpwrvgnd_1
XTAP_TAPCELL_ROW_11_465 VGND VPWR sky130_fd_sc_hd__tapvpwrvgnd_1
X_13375_ _06233_ _06243_ VGND VGND VPWR VPWR _06244_ sky130_fd_sc_hd__xor2_1
X_10587_ _03070_ _03076_ _03202_ _03203_ VGND VGND VPWR VPWR _03204_ sky130_fd_sc_hd__and4_1
X_12326_ _05096_ _05097_ VGND VGND VPWR VPWR _05098_ sky130_fd_sc_hd__nand2_1
XFILLER_55_7 VPWR VGND VPWR VGND sky130_ef_sc_hd__decap_12
XTAP_TAPCELL_ROW_114_1954 VGND VPWR sky130_fd_sc_hd__tapvpwrvgnd_1
XFILLER_114_339 VGND VGND VPWR VPWR sky130_fd_sc_hd__fill_1
X_12257_ _05019_ _05022_ VGND VGND VPWR VPWR _05023_ sky130_fd_sc_hd__xnor2_1
XFILLER_122_350 VGND VGND VPWR VPWR sky130_fd_sc_hd__fill_2
X_12188_ _04773_ _04946_ VGND VGND VPWR VPWR _04948_ sky130_fd_sc_hd__nand2_1
X_11208_ net552 net301 net299 net560 VGND VGND VPWR VPWR _03883_ sky130_fd_sc_hd__a22oi_1
XFILLER_110_501 VGND VGND VPWR VPWR sky130_fd_sc_hd__fill_1
XFILLER_110_545 VPWR VGND VPWR VGND sky130_ef_sc_hd__decap_12
X_11139_ _03805_ _03807_ VGND VGND VPWR VPWR _03808_ sky130_fd_sc_hd__xnor2_1
XFILLER_110_589 VGND VGND VPWR VPWR sky130_fd_sc_hd__fill_1
XFILLER_95_81 VGND VGND VPWR VPWR sky130_fd_sc_hd__decap_8
XFILLER_64_632 VPWR VGND VPWR VGND sky130_ef_sc_hd__decap_12
XFILLER_91_440 VGND VGND VPWR VPWR sky130_fd_sc_hd__fill_1
XFILLER_64_665 VGND VGND VPWR VPWR sky130_fd_sc_hd__decap_8
XFILLER_91_484 VPWR VGND VPWR VGND sky130_ef_sc_hd__decap_12
XFILLER_63_186 VPWR VGND VPWR VGND sky130_ef_sc_hd__decap_12
X_08350_ net258 net675 _00755_ _00756_ VGND VGND VPWR VPWR _00824_ sky130_fd_sc_hd__o22a_1
XTAP_TAPCELL_ROW_19_576 VGND VPWR sky130_fd_sc_hd__tapvpwrvgnd_1
XFILLER_24_529 VGND VGND VPWR VPWR sky130_fd_sc_hd__decap_3
X_07301_ net101 net631 net623 net710 VGND VGND VPWR VPWR _06532_ sky130_fd_sc_hd__a22o_1
X_08281_ net484 net475 net675 VGND VGND VPWR VPWR _00756_ sky130_fd_sc_hd__o21ai_1
X_07232_ _04438_ _05854_ VGND VGND VPWR VPWR _05865_ sky130_fd_sc_hd__xnor2_1
XFILLER_20_757 VPWR VGND VPWR VGND sky130_ef_sc_hd__decap_12
XTAP_TAPCELL_ROW_30_730 VGND VPWR sky130_fd_sc_hd__tapvpwrvgnd_1
X_07163_ _05078_ _05089_ _05100_ VGND VGND VPWR VPWR _05111_ sky130_fd_sc_hd__or3_1
XTAP_TAPCELL_ROW_30_741 VGND VPWR sky130_fd_sc_hd__tapvpwrvgnd_1
XFILLER_118_656 VGND VGND VPWR VPWR sky130_fd_sc_hd__fill_1
XTAP_TAPCELL_ROW_76_1404 VGND VPWR sky130_fd_sc_hd__tapvpwrvgnd_1
X_07094_ net592 net582 net693 net691 VGND VGND VPWR VPWR _04362_ sky130_fd_sc_hd__and4_1
XFILLER_120_309 VGND VGND VPWR VPWR sky130_fd_sc_hd__fill_1
X_09804_ _02340_ _02353_ VGND VGND VPWR VPWR _02354_ sky130_fd_sc_hd__xnor2_1
Xfanout247 _05603_ VGND VGND VPWR VPWR net247 sky130_fd_sc_hd__clkbuf_4
XFILLER_115_69 VPWR VGND VPWR VGND sky130_ef_sc_hd__decap_12
XFILLER_101_567 VGND VGND VPWR VPWR sky130_fd_sc_hd__fill_1
XFILLER_86_245 VGND VGND VPWR VPWR sky130_fd_sc_hd__decap_6
Xfanout269 net98 VGND VGND VPWR VPWR net269 sky130_fd_sc_hd__clkbuf_4
Xfanout258 _01376_ VGND VGND VPWR VPWR net258 sky130_fd_sc_hd__buf_2
X_07996_ net484 net677 net475 net681 VGND VGND VPWR VPWR _00473_ sky130_fd_sc_hd__a22oi_1
X_09735_ _01991_ _02145_ _01989_ VGND VGND VPWR VPWR _02279_ sky130_fd_sc_hd__a21o_1
XFILLER_46_109 VGND VGND VPWR VPWR sky130_fd_sc_hd__decap_8
XFILLER_28_813 VGND VGND VPWR VPWR sky130_fd_sc_hd__decap_8
X_06947_ _02750_ _02739_ VGND VGND VPWR VPWR _02760_ sky130_fd_sc_hd__and2b_1
X_09666_ _02201_ _02202_ VGND VGND VPWR VPWR _02203_ sky130_fd_sc_hd__nor2_1
XFILLER_131_57 VPWR VGND VPWR VGND sky130_ef_sc_hd__decap_12
X_08617_ _01053_ _01081_ _01083_ VGND VGND VPWR VPWR _01084_ sky130_fd_sc_hd__a21o_1
XTAP_TAPCELL_ROW_87_1566 VGND VPWR sky130_fd_sc_hd__tapvpwrvgnd_1
XTAP_TAPCELL_ROW_87_1555 VGND VPWR sky130_fd_sc_hd__tapvpwrvgnd_1
XFILLER_82_462 VPWR VGND VPWR VGND sky130_ef_sc_hd__decap_12
X_06878_ net467 net670 VGND VGND VPWR VPWR _02009_ sky130_fd_sc_hd__nand2_1
XTAP_TAPCELL_ROW_38_852 VGND VPWR sky130_fd_sc_hd__tapvpwrvgnd_1
X_09597_ _01974_ _01975_ _01978_ VGND VGND VPWR VPWR _02128_ sky130_fd_sc_hd__o21bai_2
XFILLER_91_39 VPWR VGND VPWR VGND sky130_ef_sc_hd__decap_12
XFILLER_54_197 VPWR VGND VPWR VGND sky130_ef_sc_hd__decap_12
X_08548_ net530 net524 net351 VGND VGND VPWR VPWR _01017_ sky130_fd_sc_hd__and3_1
XFILLER_70_657 VPWR VGND VPWR VGND sky130_ef_sc_hd__decap_12
XFILLER_23_540 VPWR VGND VPWR VGND sky130_ef_sc_hd__decap_12
XFILLER_11_713 VGND VGND VPWR VPWR sky130_fd_sc_hd__decap_3
X_08479_ _00876_ _00878_ _00951_ VGND VGND VPWR VPWR _00952_ sky130_fd_sc_hd__a21oi_1
XTAP_TAPCELL_ROW_118_2010 VGND VPWR sky130_fd_sc_hd__tapvpwrvgnd_1
X_11490_ _04070_ _04074_ net249 VGND VGND VPWR VPWR _04191_ sky130_fd_sc_hd__o21ai_1
X_10510_ net520 net291 net290 net528 VGND VGND VPWR VPWR _03120_ sky130_fd_sc_hd__a22oi_1
XFILLER_11_768 VPWR VGND VPWR VGND sky130_ef_sc_hd__decap_12
X_10441_ _02903_ _03044_ VGND VGND VPWR VPWR _03045_ sky130_fd_sc_hd__nor2_1
XFILLER_10_289 VPWR VGND VPWR VGND sky130_ef_sc_hd__decap_12
X_13160_ _05831_ _05858_ _05857_ VGND VGND VPWR VPWR _06010_ sky130_fd_sc_hd__a21oi_2
X_10372_ net443 net90 VGND VGND VPWR VPWR _02969_ sky130_fd_sc_hd__nand2_1
XFILLER_40_65 VPWR VGND VPWR VGND sky130_ef_sc_hd__decap_12
X_13091_ _05795_ _05808_ _05807_ VGND VGND VPWR VPWR _05934_ sky130_fd_sc_hd__o21a_1
X_12111_ _04855_ _04856_ _04862_ VGND VGND VPWR VPWR _04864_ sky130_fd_sc_hd__a21o_1
XFILLER_2_411 VGND VGND VPWR VPWR sky130_fd_sc_hd__decap_8
X_12042_ _04781_ _04784_ VGND VGND VPWR VPWR _04788_ sky130_fd_sc_hd__xnor2_1
XFILLER_120_821 VGND VGND VPWR VPWR sky130_fd_sc_hd__decap_3
XFILLER_104_372 VGND VGND VPWR VPWR sky130_fd_sc_hd__decap_6
XFILLER_2_499 VGND VGND VPWR VPWR sky130_fd_sc_hd__decap_3
XFILLER_78_757 VGND VGND VPWR VPWR sky130_fd_sc_hd__fill_1
XTAP_TAPCELL_ROW_129_2172 VGND VPWR sky130_fd_sc_hd__tapvpwrvgnd_1
XFILLER_77_278 VGND VGND VPWR VPWR sky130_fd_sc_hd__fill_2
XFILLER_1_15 VPWR VGND VPWR VGND sky130_ef_sc_hd__decap_12
X_12944_ _05758_ _05772_ VGND VGND VPWR VPWR _05773_ sky130_fd_sc_hd__xor2_1
XFILLER_86_790 VPWR VGND VPWR VGND sky130_ef_sc_hd__decap_12
XFILLER_65_73 VGND VGND VPWR VPWR sky130_fd_sc_hd__fill_1
XFILLER_46_676 VPWR VGND VPWR VGND sky130_ef_sc_hd__decap_12
XFILLER_45_131 VGND VGND VPWR VPWR sky130_fd_sc_hd__decap_8
XFILLER_34_805 VGND VGND VPWR VPWR sky130_fd_sc_hd__decap_6
XFILLER_73_473 VPWR VGND VPWR VGND sky130_ef_sc_hd__decap_12
X_12875_ _05531_ _05697_ VGND VGND VPWR VPWR _05698_ sky130_fd_sc_hd__nand2_1
XFILLER_61_635 VGND VGND VPWR VPWR sky130_fd_sc_hd__decap_8
XFILLER_60_112 VGND VGND VPWR VPWR sky130_fd_sc_hd__decap_8
XFILLER_60_101 VGND VGND VPWR VPWR sky130_fd_sc_hd__fill_2
XTAP_TAPCELL_ROW_16_524 VGND VPWR sky130_fd_sc_hd__tapvpwrvgnd_1
XTAP_TAPCELL_ROW_16_535 VGND VPWR sky130_fd_sc_hd__tapvpwrvgnd_1
X_11826_ _04550_ _04555_ VGND VGND VPWR VPWR _04556_ sky130_fd_sc_hd__nor2_1
XFILLER_60_156 VGND VGND VPWR VPWR sky130_fd_sc_hd__fill_1
X_11757_ _04391_ _04396_ _04398_ VGND VGND VPWR VPWR _04481_ sky130_fd_sc_hd__o21a_1
X_10708_ _03333_ _03334_ _03304_ VGND VGND VPWR VPWR _03337_ sky130_fd_sc_hd__a21o_1
X_11688_ _04381_ _04404_ VGND VGND VPWR VPWR _04407_ sky130_fd_sc_hd__xor2_1
XFILLER_127_420 VGND VGND VPWR VPWR sky130_fd_sc_hd__fill_1
X_13427_ _06209_ _06212_ _06299_ VGND VGND VPWR VPWR _06300_ sky130_fd_sc_hd__o21bai_1
X_10639_ _03109_ _03111_ _03110_ VGND VGND VPWR VPWR _03261_ sky130_fd_sc_hd__o21bai_1
X_13358_ _06220_ _06224_ VGND VGND VPWR VPWR _06226_ sky130_fd_sc_hd__and2_1
XTAP_TAPCELL_ROW_58_1134 VGND VPWR sky130_fd_sc_hd__tapvpwrvgnd_1
X_12309_ _04943_ _04945_ _04942_ VGND VGND VPWR VPWR _05080_ sky130_fd_sc_hd__o21ba_1
XTAP_TAPCELL_ROW_58_1145 VGND VPWR sky130_fd_sc_hd__tapvpwrvgnd_1
XFILLER_102_309 VPWR VGND VPWR VGND sky130_ef_sc_hd__decap_12
X_13289_ _06073_ _06150_ VGND VGND VPWR VPWR _06151_ sky130_fd_sc_hd__xnor2_2
XFILLER_46_3 VPWR VGND VPWR VGND sky130_ef_sc_hd__decap_12
XFILLER_111_821 VGND VGND VPWR VPWR sky130_fd_sc_hd__decap_3
XTAP_TAPCELL_ROW_71_1334 VGND VPWR sky130_fd_sc_hd__tapvpwrvgnd_1
XTAP_TAPCELL_ROW_71_1323 VGND VPWR sky130_fd_sc_hd__tapvpwrvgnd_1
XPHY_EDGE_ROW_18_Right_18 VGND VGND VPWR VPWR sky130_fd_sc_hd__decap_3
XFILLER_110_331 VGND VGND VPWR VPWR sky130_fd_sc_hd__fill_2
X_07850_ _00326_ _00327_ VGND VGND VPWR VPWR _00328_ sky130_fd_sc_hd__or2_1
XFILLER_110_375 VGND VGND VPWR VPWR sky130_fd_sc_hd__decap_4
XFILLER_110_353 VGND VGND VPWR VPWR sky130_fd_sc_hd__decap_6
XFILLER_68_289 VPWR VGND VPWR VGND sky130_ef_sc_hd__decap_12
X_07781_ net105 _00259_ VGND VGND VPWR VPWR _00260_ sky130_fd_sc_hd__and2_1
XFILLER_56_429 VGND VGND VPWR VPWR sky130_fd_sc_hd__fill_2
XFILLER_56_418 VGND VGND VPWR VPWR sky130_fd_sc_hd__fill_2
XFILLER_28_109 VGND VGND VPWR VPWR sky130_fd_sc_hd__decap_4
X_09520_ net361 net360 net533 net539 VGND VGND VPWR VPWR _02044_ sky130_fd_sc_hd__and4b_1
XFILLER_110_386 VGND VGND VPWR VPWR sky130_fd_sc_hd__fill_2
XFILLER_83_237 VGND VGND VPWR VPWR sky130_fd_sc_hd__decap_4
Xinput3 w00[1] VGND VGND VPWR VPWR net3 sky130_fd_sc_hd__buf_1
XFILLER_64_462 VPWR VGND VPWR VGND sky130_ef_sc_hd__decap_12
XFILLER_36_153 VGND VGND VPWR VPWR sky130_fd_sc_hd__decap_8
X_09451_ _01952_ _01968_ VGND VGND VPWR VPWR _01969_ sky130_fd_sc_hd__nor2_1
XFILLER_92_793 VPWR VGND VPWR VGND sky130_ef_sc_hd__decap_12
XFILLER_91_281 VGND VGND VPWR VPWR sky130_fd_sc_hd__fill_1
XTAP_TAPCELL_ROW_69_1296 VGND VPWR sky130_fd_sc_hd__tapvpwrvgnd_1
XTAP_TAPCELL_ROW_35_800 VGND VPWR sky130_fd_sc_hd__tapvpwrvgnd_1
XTAP_TAPCELL_ROW_35_811 VGND VPWR sky130_fd_sc_hd__tapvpwrvgnd_1
X_09382_ _01726_ _01893_ VGND VGND VPWR VPWR _01894_ sky130_fd_sc_hd__nor2_1
XFILLER_24_337 VPWR VGND VPWR VGND sky130_ef_sc_hd__decap_12
XPHY_EDGE_ROW_27_Right_27 VGND VGND VPWR VPWR sky130_fd_sc_hd__decap_3
XFILLER_36_197 VGND VGND VPWR VPWR sky130_fd_sc_hd__decap_3
X_08402_ _00852_ _00875_ VGND VGND VPWR VPWR _00876_ sky130_fd_sc_hd__or2_1
X_08333_ _00726_ _00806_ _00803_ VGND VGND VPWR VPWR _00807_ sky130_fd_sc_hd__mux2_1
XFILLER_51_178 VPWR VGND VPWR VGND sky130_ef_sc_hd__decap_12
XTAP_TAPCELL_ROW_82_1485 VGND VPWR sky130_fd_sc_hd__tapvpwrvgnd_1
X_08264_ _00737_ _00738_ VGND VGND VPWR VPWR _00739_ sky130_fd_sc_hd__and2_1
XFILLER_138_729 VGND VGND VPWR VPWR sky130_fd_sc_hd__fill_2
X_08195_ _00668_ _00669_ VGND VGND VPWR VPWR _00671_ sky130_fd_sc_hd__xor2_2
X_07215_ net703 net537 _05668_ VGND VGND VPWR VPWR _05679_ sky130_fd_sc_hd__a21o_1
X_07146_ _04893_ _04904_ _04915_ VGND VGND VPWR VPWR _04926_ sky130_fd_sc_hd__and3_1
X_07077_ _04134_ _04156_ VGND VGND VPWR VPWR _04177_ sky130_fd_sc_hd__xnor2_2
XFILLER_133_467 VPWR VGND VPWR VGND sky130_ef_sc_hd__decap_12
XFILLER_105_169 VGND VGND VPWR VPWR sky130_fd_sc_hd__decap_6
XFILLER_10_79 VGND VGND VPWR VPWR sky130_fd_sc_hd__decap_4
XPHY_EDGE_ROW_36_Right_36 VGND VGND VPWR VPWR sky130_fd_sc_hd__decap_3
XFILLER_102_821 VGND VGND VPWR VPWR sky130_fd_sc_hd__decap_3
XFILLER_59_201 VGND VGND VPWR VPWR sky130_fd_sc_hd__fill_1
XFILLER_120_139 VGND VGND VPWR VPWR sky130_fd_sc_hd__fill_1
XFILLER_114_692 VGND VGND VPWR VPWR sky130_fd_sc_hd__fill_1
XFILLER_59_223 VGND VGND VPWR VPWR sky130_fd_sc_hd__fill_1
XFILLER_101_364 VPWR VGND VPWR VGND sky130_ef_sc_hd__decap_12
XFILLER_75_727 VGND VGND VPWR VPWR sky130_fd_sc_hd__fill_1
XFILLER_75_705 VGND VGND VPWR VPWR sky130_fd_sc_hd__decap_8
XFILLER_19_55 VGND VGND VPWR VPWR sky130_fd_sc_hd__fill_1
X_09718_ _01959_ _02117_ VGND VGND VPWR VPWR _02261_ sky130_fd_sc_hd__nor2_1
XFILLER_74_237 VGND VGND VPWR VPWR sky130_fd_sc_hd__fill_2
X_07979_ _00319_ _00455_ VGND VGND VPWR VPWR _00456_ sky130_fd_sc_hd__nand2b_1
XFILLER_28_610 VGND VGND VPWR VPWR sky130_fd_sc_hd__decap_3
XFILLER_28_643 VGND VGND VPWR VPWR sky130_fd_sc_hd__fill_1
XFILLER_90_719 VPWR VGND VPWR VGND sky130_ef_sc_hd__decap_12
XFILLER_83_771 VGND VGND VPWR VPWR sky130_fd_sc_hd__fill_2
X_10990_ _03641_ _03643_ _03644_ VGND VGND VPWR VPWR _03645_ sky130_fd_sc_hd__nand3_1
X_09649_ _02182_ _02184_ VGND VGND VPWR VPWR _02185_ sky130_fd_sc_hd__nor2_1
XFILLER_83_793 VGND VGND VPWR VPWR sky130_fd_sc_hd__decap_8
XPHY_EDGE_ROW_45_Right_45 VGND VGND VPWR VPWR sky130_fd_sc_hd__decap_3
XFILLER_15_326 VGND VGND VPWR VPWR sky130_fd_sc_hd__fill_2
XFILLER_27_164 VGND VGND VPWR VPWR sky130_fd_sc_hd__decap_4
XFILLER_28_698 VGND VGND VPWR VPWR sky130_fd_sc_hd__fill_2
XTAP_TAPCELL_ROW_124_2091 VGND VPWR sky130_fd_sc_hd__tapvpwrvgnd_1
X_12660_ net495 net398 VGND VGND VPWR VPWR _05464_ sky130_fd_sc_hd__nand2_1
X_11611_ _04320_ _04321_ VGND VGND VPWR VPWR _04322_ sky130_fd_sc_hd__nor2_1
X_12591_ _05213_ _05388_ VGND VGND VPWR VPWR _05389_ sky130_fd_sc_hd__and2_1
XFILLER_23_370 VPWR VGND VPWR VGND sky130_ef_sc_hd__decap_12
XFILLER_30_329 VPWR VGND VPWR VGND sky130_ef_sc_hd__decap_12
XFILLER_129_729 VPWR VGND VPWR VGND sky130_ef_sc_hd__decap_12
XFILLER_51_31 VPWR VGND VPWR VGND sky130_ef_sc_hd__decap_12
X_11542_ net261 net319 _04129_ _04132_ VGND VGND VPWR VPWR _04247_ sky130_fd_sc_hd__o31ai_1
XFILLER_109_420 VPWR VGND VPWR VGND sky130_ef_sc_hd__decap_12
XFILLER_51_86 VGND VGND VPWR VPWR sky130_fd_sc_hd__fill_2
XFILLER_7_547 VGND VGND VPWR VPWR sky130_fd_sc_hd__decap_8
XFILLER_7_536 VGND VGND VPWR VPWR sky130_fd_sc_hd__decap_8
X_11473_ _04098_ _04100_ VGND VGND VPWR VPWR _04172_ sky130_fd_sc_hd__nor2_1
X_13212_ _05920_ _05922_ _06063_ VGND VGND VPWR VPWR _06066_ sky130_fd_sc_hd__and3_1
X_10424_ _02982_ _03022_ _03024_ VGND VGND VPWR VPWR _03026_ sky130_fd_sc_hd__or3_4
X_13143_ _05989_ _05990_ VGND VGND VPWR VPWR _05991_ sky130_fd_sc_hd__and2_1
XPHY_EDGE_ROW_54_Right_54 VGND VGND VPWR VPWR sky130_fd_sc_hd__decap_3
XFILLER_124_456 VGND VGND VPWR VPWR sky130_fd_sc_hd__fill_1
XTAP_TAPCELL_ROW_111_1913 VGND VPWR sky130_fd_sc_hd__tapvpwrvgnd_1
XTAP_TAPCELL_ROW_111_1902 VGND VPWR sky130_fd_sc_hd__tapvpwrvgnd_1
XFILLER_3_753 VPWR VGND VPWR VGND sky130_ef_sc_hd__decap_12
X_10355_ net527 net291 VGND VGND VPWR VPWR _02950_ sky130_fd_sc_hd__nand2_1
XFILLER_111_106 VGND VGND VPWR VPWR sky130_fd_sc_hd__decap_6
X_13074_ _05914_ _05603_ VGND VGND VPWR VPWR _05915_ sky130_fd_sc_hd__nand2b_1
XFILLER_78_521 VGND VGND VPWR VPWR sky130_fd_sc_hd__decap_6
X_10286_ _02873_ _02874_ VGND VGND VPWR VPWR _02875_ sky130_fd_sc_hd__nor2_1
XFILLER_3_797 VPWR VGND VPWR VGND sky130_ef_sc_hd__decap_12
XFILLER_120_640 VGND VGND VPWR VPWR sky130_fd_sc_hd__decap_4
X_12025_ _04730_ _04768_ VGND VGND VPWR VPWR _04769_ sky130_fd_sc_hd__nor2_1
XTAP_TAPCELL_ROW_53_1064 VGND VPWR sky130_fd_sc_hd__tapvpwrvgnd_1
XFILLER_78_576 VPWR VGND VPWR VGND sky130_ef_sc_hd__decap_12
XFILLER_76_61 VGND VGND VPWR VPWR sky130_fd_sc_hd__fill_1
XFILLER_120_695 VGND VGND VPWR VPWR sky130_fd_sc_hd__decap_4
XFILLER_76_94 VGND VGND VPWR VPWR sky130_fd_sc_hd__fill_1
XFILLER_76_83 VGND VGND VPWR VPWR sky130_fd_sc_hd__fill_1
XFILLER_66_749 VGND VGND VPWR VPWR sky130_fd_sc_hd__decap_6
XFILLER_93_568 VGND VGND VPWR VPWR sky130_fd_sc_hd__decap_6
XPHY_EDGE_ROW_63_Right_63 VGND VGND VPWR VPWR sky130_fd_sc_hd__decap_3
XTAP_TAPCELL_ROW_109_1886 VGND VPWR sky130_fd_sc_hd__tapvpwrvgnd_1
XTAP_TAPCELL_ROW_109_1875 VGND VPWR sky130_fd_sc_hd__tapvpwrvgnd_1
X_12927_ _05587_ _05590_ _05585_ VGND VGND VPWR VPWR _05754_ sky130_fd_sc_hd__a21oi_1
XFILLER_18_175 VPWR VGND VPWR VGND sky130_ef_sc_hd__decap_12
XFILLER_73_281 VGND VGND VPWR VPWR sky130_fd_sc_hd__decap_8
X_12858_ net613 net353 _05523_ _05522_ VGND VGND VPWR VPWR _05680_ sky130_fd_sc_hd__a31o_1
XFILLER_18_197 VGND VGND VPWR VPWR sky130_fd_sc_hd__decap_4
XFILLER_33_134 VPWR VGND VPWR VGND sky130_ef_sc_hd__decap_12
X_11809_ _04168_ _04423_ _04421_ VGND VGND VPWR VPWR _04539_ sky130_fd_sc_hd__a21oi_1
X_12789_ _05600_ _05603_ VGND VGND VPWR VPWR _05604_ sky130_fd_sc_hd__xor2_1
XFILLER_14_381 VGND VGND VPWR VPWR sky130_fd_sc_hd__fill_1
XFILLER_119_206 VPWR VGND VPWR VGND sky130_ef_sc_hd__decap_12
XTAP_TAPCELL_ROW_40_880 VGND VPWR sky130_fd_sc_hd__tapvpwrvgnd_1
XPHY_EDGE_ROW_72_Right_72 VGND VGND VPWR VPWR sky130_fd_sc_hd__decap_3
X_07000_ _03314_ _03325_ VGND VGND VPWR VPWR _03336_ sky130_fd_sc_hd__or2_1
XFILLER_127_294 VPWR VGND VPWR VGND sky130_ef_sc_hd__decap_12
XFILLER_6_580 VGND VGND VPWR VPWR sky130_fd_sc_hd__fill_1
XFILLER_115_456 VGND VGND VPWR VPWR sky130_fd_sc_hd__decap_4
X_08951_ net531 net524 net346 net344 VGND VGND VPWR VPWR _01424_ sky130_fd_sc_hd__nand4_1
XFILLER_103_629 VPWR VGND VPWR VGND sky130_ef_sc_hd__decap_12
XFILLER_102_117 VGND VGND VPWR VPWR sky130_fd_sc_hd__fill_2
XFILLER_130_437 VGND VGND VPWR VPWR sky130_fd_sc_hd__fill_1
X_08882_ net722 _01346_ _01210_ _01212_ VGND VGND VPWR VPWR _01349_ sky130_fd_sc_hd__a211oi_1
X_07902_ _00379_ _00366_ VGND VGND VPWR VPWR _00380_ sky130_fd_sc_hd__nand2b_1
XFILLER_96_362 VGND VGND VPWR VPWR sky130_fd_sc_hd__fill_2
XFILLER_96_351 VGND VGND VPWR VPWR sky130_fd_sc_hd__decap_4
XFILLER_57_716 VPWR VGND VPWR VGND sky130_ef_sc_hd__decap_12
X_07833_ _00308_ _00309_ _00307_ VGND VGND VPWR VPWR _00311_ sky130_fd_sc_hd__o21ba_1
XPHY_EDGE_ROW_81_Right_81 VGND VGND VPWR VPWR sky130_fd_sc_hd__decap_3
XPHY_EDGE_ROW_16_Left_155 VGND VGND VPWR VPWR sky130_fd_sc_hd__decap_3
X_07764_ _06664_ _00091_ _00093_ VGND VGND VPWR VPWR _00243_ sky130_fd_sc_hd__o21bai_2
X_09503_ _02024_ _02025_ VGND VGND VPWR VPWR _00067_ sky130_fd_sc_hd__xnor2_1
XFILLER_112_26 VGND VGND VPWR VPWR sky130_fd_sc_hd__fill_2
XTAP_TAPCELL_ROW_84_1514 VGND VPWR sky130_fd_sc_hd__tapvpwrvgnd_1
XFILLER_71_207 VGND VGND VPWR VPWR sky130_fd_sc_hd__fill_1
X_07695_ _06763_ _00173_ _06765_ VGND VGND VPWR VPWR _00174_ sky130_fd_sc_hd__o21ba_2
X_09434_ _01912_ _01949_ VGND VGND VPWR VPWR _01950_ sky130_fd_sc_hd__xor2_1
XFILLER_72_19 VGND VGND VPWR VPWR sky130_fd_sc_hd__decap_8
XTAP_TAPCELL_ROW_48_991 VGND VPWR sky130_fd_sc_hd__tapvpwrvgnd_1
XFILLER_25_679 VGND VGND VPWR VPWR sky130_fd_sc_hd__fill_1
XFILLER_40_605 VGND VGND VPWR VPWR sky130_fd_sc_hd__fill_1
X_09365_ net551 net361 _01704_ _01702_ net359 VGND VGND VPWR VPWR _01875_ sky130_fd_sc_hd__a32o_1
XFILLER_52_498 VPWR VGND VPWR VGND sky130_ef_sc_hd__decap_12
X_09296_ _01783_ _01798_ _01799_ VGND VGND VPWR VPWR _01800_ sky130_fd_sc_hd__and3_1
X_08316_ _00789_ _00790_ VGND VGND VPWR VPWR _00791_ sky130_fd_sc_hd__nor2_1
XPHY_EDGE_ROW_25_Left_164 VGND VGND VPWR VPWR sky130_fd_sc_hd__decap_3
XFILLER_138_559 VGND VGND VPWR VPWR sky130_fd_sc_hd__fill_1
XPHY_EDGE_ROW_90_Right_90 VGND VGND VPWR VPWR sky130_fd_sc_hd__decap_3
X_08247_ _00258_ _00260_ _00622_ VGND VGND VPWR VPWR _00722_ sky130_fd_sc_hd__or3_1
XFILLER_119_762 VPWR VGND VPWR VGND sky130_ef_sc_hd__decap_12
XFILLER_118_250 VGND VGND VPWR VPWR sky130_fd_sc_hd__fill_2
X_08178_ _00642_ _00653_ VGND VGND VPWR VPWR _00654_ sky130_fd_sc_hd__xnor2_1
XFILLER_4_528 VGND VGND VPWR VPWR sky130_fd_sc_hd__decap_4
XFILLER_106_445 VGND VGND VPWR VPWR sky130_fd_sc_hd__decap_4
XTAP_TAPCELL_ROW_95_1676 VGND VPWR sky130_fd_sc_hd__tapvpwrvgnd_1
X_07129_ net683 _03030_ _04729_ VGND VGND VPWR VPWR _04740_ sky130_fd_sc_hd__a21o_1
X_10140_ _02333_ _02637_ _02719_ VGND VGND VPWR VPWR _02720_ sky130_fd_sc_hd__a21o_1
XFILLER_133_275 VGND VGND VPWR VPWR sky130_fd_sc_hd__decap_4
Xoutput170 net170 VGND VGND VPWR VPWR y0[1] sky130_fd_sc_hd__buf_2
Xoutput192 net192 VGND VGND VPWR VPWR y1[6] sky130_fd_sc_hd__buf_2
Xoutput181 net181 VGND VGND VPWR VPWR y1[11] sky130_fd_sc_hd__buf_2
X_10071_ _02464_ _02643_ VGND VGND VPWR VPWR _02645_ sky130_fd_sc_hd__and2_1
XTAP_TAPCELL_ROW_7_399 VGND VPWR sky130_fd_sc_hd__tapvpwrvgnd_1
XPHY_EDGE_ROW_34_Left_173 VGND VGND VPWR VPWR sky130_fd_sc_hd__decap_3
XTAP_TAPCELL_ROW_126_2131 VGND VPWR sky130_fd_sc_hd__tapvpwrvgnd_1
XTAP_TAPCELL_ROW_126_2120 VGND VPWR sky130_fd_sc_hd__tapvpwrvgnd_1
XFILLER_101_161 VGND VGND VPWR VPWR sky130_fd_sc_hd__decap_6
XFILLER_46_53 VPWR VGND VPWR VGND sky130_ef_sc_hd__decap_12
X_10973_ _03611_ _03625_ VGND VGND VPWR VPWR _03626_ sky130_fd_sc_hd__xnor2_1
X_12712_ _05512_ _05520_ VGND VGND VPWR VPWR _05521_ sky130_fd_sc_hd__xor2_1
XFILLER_71_741 VPWR VGND VPWR VGND sky130_ef_sc_hd__decap_12
XFILLER_46_97 VPWR VGND VPWR VGND sky130_ef_sc_hd__decap_12
XFILLER_71_785 VPWR VGND VPWR VGND sky130_ef_sc_hd__decap_12
X_13692_ clknet_3_3__leaf_clk _00051_ net713 VGND VGND VPWR VPWR net227 sky130_fd_sc_hd__dfrtp_1
XFILLER_43_454 VGND VGND VPWR VPWR sky130_fd_sc_hd__decap_6
XTAP_TAPCELL_ROW_26_674 VGND VPWR sky130_fd_sc_hd__tapvpwrvgnd_1
X_12643_ _05442_ _05443_ VGND VGND VPWR VPWR _05445_ sky130_fd_sc_hd__xnor2_1
XFILLER_62_41 VPWR VGND VPWR VGND sky130_ef_sc_hd__decap_12
XFILLER_43_498 VGND VGND VPWR VPWR sky130_fd_sc_hd__decap_6
XPHY_EDGE_ROW_43_Left_182 VGND VGND VPWR VPWR sky130_fd_sc_hd__decap_3
XFILLER_129_526 VGND VGND VPWR VPWR sky130_fd_sc_hd__decap_3
X_12574_ _05368_ _05369_ VGND VGND VPWR VPWR _05370_ sky130_fd_sc_hd__nand2b_1
XFILLER_62_85 VPWR VGND VPWR VGND sky130_ef_sc_hd__decap_12
X_11525_ _04222_ _04227_ VGND VGND VPWR VPWR _04229_ sky130_fd_sc_hd__xnor2_1
XTAP_TAPCELL_ROW_137_2282 VGND VPWR sky130_fd_sc_hd__tapvpwrvgnd_1
XFILLER_7_69 VPWR VGND VPWR VGND sky130_ef_sc_hd__decap_12
X_11456_ _04151_ _04152_ VGND VGND VPWR VPWR _04154_ sky130_fd_sc_hd__xor2_1
XFILLER_7_388 VGND VGND VPWR VPWR sky130_fd_sc_hd__decap_4
XFILLER_125_754 VGND VGND VPWR VPWR sky130_fd_sc_hd__decap_8
X_11387_ net492 _03770_ VGND VGND VPWR VPWR _04078_ sky130_fd_sc_hd__and2_1
X_10407_ _03004_ _03005_ _03006_ VGND VGND VPWR VPWR _03007_ sky130_fd_sc_hd__or3_1
XFILLER_124_253 VGND VGND VPWR VPWR sky130_fd_sc_hd__fill_1
X_13126_ net437 net428 net381 net379 VGND VGND VPWR VPWR _05972_ sky130_fd_sc_hd__and4_1
XFILLER_3_561 VGND VGND VPWR VPWR sky130_fd_sc_hd__decap_8
X_10338_ _02926_ _02929_ VGND VGND VPWR VPWR _02932_ sky130_fd_sc_hd__xnor2_1
XFILLER_112_448 VPWR VGND VPWR VGND sky130_ef_sc_hd__decap_12
X_13057_ _05894_ _05895_ VGND VGND VPWR VPWR _05896_ sky130_fd_sc_hd__xnor2_1
XPHY_EDGE_ROW_52_Left_191 VGND VGND VPWR VPWR sky130_fd_sc_hd__decap_3
XFILLER_87_93 VGND VGND VPWR VPWR sky130_fd_sc_hd__decap_3
XFILLER_78_362 VGND VGND VPWR VPWR sky130_fd_sc_hd__fill_2
X_12008_ _04749_ _04750_ VGND VGND VPWR VPWR _04752_ sky130_fd_sc_hd__and2b_1
X_10269_ _02853_ _02854_ VGND VGND VPWR VPWR _02857_ sky130_fd_sc_hd__xor2_1
XFILLER_39_727 VGND VGND VPWR VPWR sky130_fd_sc_hd__fill_1
XFILLER_81_505 VPWR VGND VPWR VGND sky130_ef_sc_hd__decap_12
XFILLER_38_259 VGND VGND VPWR VPWR sky130_fd_sc_hd__fill_1
XFILLER_47_782 VGND VGND VPWR VPWR sky130_fd_sc_hd__fill_2
X_07480_ _06708_ _06709_ VGND VGND VPWR VPWR _06710_ sky130_fd_sc_hd__and2b_1
XFILLER_46_270 VPWR VGND VPWR VGND sky130_ef_sc_hd__decap_12
XFILLER_34_443 VPWR VGND VPWR VGND sky130_ef_sc_hd__decap_12
XTAP_TAPCELL_ROW_66_1255 VGND VPWR sky130_fd_sc_hd__tapvpwrvgnd_1
XFILLER_62_774 VGND VGND VPWR VPWR sky130_fd_sc_hd__fill_1
XTAP_TAPCELL_ROW_45_950 VGND VPWR sky130_fd_sc_hd__tapvpwrvgnd_1
X_09150_ _01639_ _01640_ VGND VGND VPWR VPWR _01641_ sky130_fd_sc_hd__and2b_1
X_09081_ _01521_ _01565_ VGND VGND VPWR VPWR _01566_ sky130_fd_sc_hd__nand2b_1
X_08101_ _00454_ _00456_ VGND VGND VPWR VPWR _00577_ sky130_fd_sc_hd__nand2_1
X_08032_ _00507_ _00508_ VGND VGND VPWR VPWR _00509_ sky130_fd_sc_hd__xnor2_1
Xinput50 w12[0] VGND VGND VPWR VPWR net50 sky130_fd_sc_hd__dlymetal6s2s_1
Xinput61 w13[3] VGND VGND VPWR VPWR net61 sky130_fd_sc_hd__clkbuf_2
XFILLER_135_529 VGND VGND VPWR VPWR sky130_fd_sc_hd__fill_2
XFILLER_128_570 VPWR VGND VPWR VGND sky130_ef_sc_hd__decap_12
Xinput72 w20[6] VGND VGND VPWR VPWR net72 sky130_fd_sc_hd__buf_2
Xinput83 w22[1] VGND VGND VPWR VPWR net83 sky130_fd_sc_hd__dlymetal6s2s_1
Xinput94 w23[4] VGND VGND VPWR VPWR net94 sky130_fd_sc_hd__buf_1
X_09983_ _02535_ _02548_ VGND VGND VPWR VPWR _02549_ sky130_fd_sc_hd__nor2_1
XFILLER_107_15 VPWR VGND VPWR VGND sky130_ef_sc_hd__decap_12
XFILLER_131_746 VPWR VGND VPWR VGND sky130_ef_sc_hd__decap_12
X_08934_ _01404_ _01366_ VGND VGND VPWR VPWR _01405_ sky130_fd_sc_hd__and2b_1
XFILLER_67_19 VPWR VGND VPWR VGND sky130_ef_sc_hd__decap_12
XFILLER_69_362 VGND VGND VPWR VPWR sky130_fd_sc_hd__fill_1
XFILLER_57_502 VGND VGND VPWR VPWR sky130_fd_sc_hd__fill_2
X_08865_ _01329_ _01328_ _01330_ VGND VGND VPWR VPWR _01331_ sky130_fd_sc_hd__and3_1
XTAP_TAPCELL_ROW_4_358 VGND VPWR sky130_fd_sc_hd__tapvpwrvgnd_1
X_08796_ _01258_ _01259_ VGND VGND VPWR VPWR _01262_ sky130_fd_sc_hd__xnor2_2
X_07816_ _00186_ _00188_ _00293_ VGND VGND VPWR VPWR _00294_ sky130_fd_sc_hd__a21oi_2
XFILLER_123_69 VPWR VGND VPWR VGND sky130_ef_sc_hd__decap_12
XFILLER_84_376 VGND VGND VPWR VPWR sky130_fd_sc_hd__fill_2
XFILLER_84_365 VGND VGND VPWR VPWR sky130_fd_sc_hd__decap_4
X_07747_ net667 net434 net665 net425 VGND VGND VPWR VPWR _00226_ sky130_fd_sc_hd__and4_1
XTAP_TAPCELL_ROW_121_2050 VGND VPWR sky130_fd_sc_hd__tapvpwrvgnd_1
XFILLER_53_785 VPWR VGND VPWR VGND sky130_ef_sc_hd__decap_12
XPHY_EDGE_ROW_0_Right_0 VGND VGND VPWR VPWR sky130_fd_sc_hd__decap_3
X_07678_ net697 net547 _06745_ _06744_ VGND VGND VPWR VPWR _00157_ sky130_fd_sc_hd__a31o_1
X_09417_ _01918_ _01930_ VGND VGND VPWR VPWR _01931_ sky130_fd_sc_hd__xor2_2
XFILLER_12_115 VGND VGND VPWR VPWR sky130_fd_sc_hd__decap_3
XFILLER_138_301 VGND VGND VPWR VPWR sky130_fd_sc_hd__decap_3
X_09348_ _01680_ _01855_ _01856_ VGND VGND VPWR VPWR _01858_ sky130_fd_sc_hd__and3_1
XFILLER_12_137 VGND VGND VPWR VPWR sky130_fd_sc_hd__decap_3
XTAP_TAPCELL_ROW_23_633 VGND VPWR sky130_fd_sc_hd__tapvpwrvgnd_1
XTAP_TAPCELL_ROW_97_1705 VGND VPWR sky130_fd_sc_hd__tapvpwrvgnd_1
XFILLER_21_671 VGND VGND VPWR VPWR sky130_fd_sc_hd__fill_1
X_09279_ _01617_ _01628_ _01625_ VGND VGND VPWR VPWR _01782_ sky130_fd_sc_hd__a21oi_1
XFILLER_20_192 VGND VGND VPWR VPWR sky130_fd_sc_hd__decap_4
X_11310_ _03993_ _03994_ VGND VGND VPWR VPWR _03995_ sky130_fd_sc_hd__and2_1
XFILLER_113_3 VPWR VGND VPWR VGND sky130_ef_sc_hd__decap_12
X_12290_ _04913_ _04917_ net232 _05059_ VGND VGND VPWR VPWR _05060_ sky130_fd_sc_hd__a211oi_2
XFILLER_4_325 VGND VGND VPWR VPWR sky130_fd_sc_hd__fill_1
XFILLER_107_765 VPWR VGND VPWR VGND sky130_ef_sc_hd__decap_12
X_11241_ _03781_ _03794_ _03793_ VGND VGND VPWR VPWR _03919_ sky130_fd_sc_hd__o21ai_1
XFILLER_106_275 VGND VGND VPWR VPWR sky130_fd_sc_hd__fill_1
XFILLER_106_253 VGND VGND VPWR VPWR sky130_fd_sc_hd__fill_1
X_11172_ _03840_ _03841_ VGND VGND VPWR VPWR _03844_ sky130_fd_sc_hd__xnor2_1
XFILLER_122_757 VPWR VGND VPWR VGND sky130_ef_sc_hd__decap_12
XFILLER_121_223 VGND VGND VPWR VPWR sky130_fd_sc_hd__fill_1
X_10123_ net525 net342 _02613_ _02612_ VGND VGND VPWR VPWR _02701_ sky130_fd_sc_hd__a31oi_1
XFILLER_106_297 VGND VGND VPWR VPWR sky130_fd_sc_hd__decap_8
XFILLER_79_159 VGND VGND VPWR VPWR sky130_fd_sc_hd__decap_8
XFILLER_48_502 VGND VGND VPWR VPWR sky130_fd_sc_hd__fill_1
X_10054_ _02547_ _02549_ _02625_ VGND VGND VPWR VPWR _02626_ sky130_fd_sc_hd__o21a_1
XTAP_TAPCELL_ROW_50_1023 VGND VPWR sky130_fd_sc_hd__tapvpwrvgnd_1
XFILLER_48_513 VGND VGND VPWR VPWR sky130_fd_sc_hd__decap_8
XFILLER_63_505 VGND VGND VPWR VPWR sky130_fd_sc_hd__fill_1
XPHY_EDGE_ROW_121_Right_121 VGND VGND VPWR VPWR sky130_fd_sc_hd__decap_3
XTAP_TAPCELL_ROW_106_1834 VGND VPWR sky130_fd_sc_hd__tapvpwrvgnd_1
XFILLER_16_421 VPWR VGND VPWR VGND sky130_ef_sc_hd__decap_12
XFILLER_73_51 VGND VGND VPWR VPWR sky130_fd_sc_hd__decap_4
X_10956_ _03425_ _03426_ _03424_ VGND VGND VPWR VPWR _03607_ sky130_fd_sc_hd__a21oi_1
X_13675_ clknet_3_2__leaf_clk _00023_ net712 VGND VGND VPWR VPWR net210 sky130_fd_sc_hd__dfrtp_1
X_10887_ _03355_ _03359_ _03354_ VGND VGND VPWR VPWR _03532_ sky130_fd_sc_hd__a21oi_1
X_12626_ _05280_ _05291_ _05290_ VGND VGND VPWR VPWR _05426_ sky130_fd_sc_hd__a21bo_1
XFILLER_31_446 VGND VGND VPWR VPWR sky130_fd_sc_hd__fill_2
XFILLER_31_457 VGND VGND VPWR VPWR sky130_fd_sc_hd__fill_1
XFILLER_31_468 VGND VGND VPWR VPWR sky130_fd_sc_hd__decap_3
X_12557_ _05348_ _05349_ net648 net8 VGND VGND VPWR VPWR _05351_ sky130_fd_sc_hd__and4bb_1
XTAP_TAPCELL_ROW_61_1185 VGND VPWR sky130_fd_sc_hd__tapvpwrvgnd_1
X_12488_ _05143_ _05164_ _05162_ VGND VGND VPWR VPWR _05276_ sky130_fd_sc_hd__a21o_1
XFILLER_7_152 VGND VGND VPWR VPWR sky130_fd_sc_hd__fill_2
X_11508_ _04103_ _04115_ _04114_ VGND VGND VPWR VPWR _04211_ sky130_fd_sc_hd__a21bo_1
X_11439_ _04128_ _04133_ VGND VGND VPWR VPWR _04136_ sky130_fd_sc_hd__xor2_1
XTAP_TAPCELL_ROW_117_1996 VGND VPWR sky130_fd_sc_hd__tapvpwrvgnd_1
XFILLER_112_201 VGND VGND VPWR VPWR sky130_fd_sc_hd__fill_2
XFILLER_98_413 VGND VGND VPWR VPWR sky130_fd_sc_hd__decap_6
XFILLER_112_212 VPWR VGND VPWR VGND sky130_ef_sc_hd__decap_12
X_13109_ net384 net412 VGND VGND VPWR VPWR _05954_ sky130_fd_sc_hd__and2b_1
XFILLER_86_608 VPWR VGND VPWR VGND sky130_ef_sc_hd__decap_12
X_06980_ _03095_ _03106_ VGND VGND VPWR VPWR _03117_ sky130_fd_sc_hd__or2_1
XFILLER_79_671 VGND VGND VPWR VPWR sky130_fd_sc_hd__fill_1
X_08650_ _01112_ _01115_ VGND VGND VPWR VPWR _01117_ sky130_fd_sc_hd__xnor2_1
XFILLER_94_641 VGND VGND VPWR VPWR sky130_fd_sc_hd__decap_3
XFILLER_78_192 VGND VGND VPWR VPWR sky130_fd_sc_hd__fill_1
X_07601_ _00078_ _00079_ _00080_ VGND VGND VPWR VPWR _00081_ sky130_fd_sc_hd__nand3_1
XTAP_TAPCELL_ROW_1_317 VGND VPWR sky130_fd_sc_hd__tapvpwrvgnd_1
X_08581_ _01046_ _01047_ VGND VGND VPWR VPWR _01049_ sky130_fd_sc_hd__xor2_1
XFILLER_19_281 VPWR VGND VPWR VGND sky130_ef_sc_hd__decap_12
X_07532_ net592 net582 net113 VGND VGND VPWR VPWR _06761_ sky130_fd_sc_hd__and3_1
X_07463_ net533 net600 VGND VGND VPWR VPWR _06693_ sky130_fd_sc_hd__xnor2_4
XFILLER_35_785 VPWR VGND VPWR VGND sky130_ef_sc_hd__decap_12
X_09202_ _01694_ _01695_ VGND VGND VPWR VPWR _01697_ sky130_fd_sc_hd__and2_1
XFILLER_50_777 VPWR VGND VPWR VGND sky130_ef_sc_hd__decap_12
X_09133_ net600 _01409_ _01620_ _01621_ VGND VGND VPWR VPWR _01622_ sky130_fd_sc_hd__a22o_1
X_07394_ _06301_ _06497_ _06486_ VGND VGND VPWR VPWR _06624_ sky130_fd_sc_hd__o21bai_1
XFILLER_136_805 VGND VGND VPWR VPWR sky130_fd_sc_hd__decap_6
X_09064_ _01528_ _01546_ VGND VGND VPWR VPWR _01547_ sky130_fd_sc_hd__xnor2_1
XTAP_TAPCELL_ROW_79_1446 VGND VPWR sky130_fd_sc_hd__tapvpwrvgnd_1
XFILLER_135_337 VGND VGND VPWR VPWR sky130_fd_sc_hd__decap_4
XFILLER_116_540 VGND VGND VPWR VPWR sky130_fd_sc_hd__fill_1
X_08015_ _00487_ _00490_ VGND VGND VPWR VPWR _00492_ sky130_fd_sc_hd__xnor2_1
XFILLER_116_562 VGND VGND VPWR VPWR sky130_fd_sc_hd__decap_4
XFILLER_104_713 VPWR VGND VPWR VGND sky130_ef_sc_hd__decap_12
XTAP_TAPCELL_ROW_92_1635 VGND VPWR sky130_fd_sc_hd__tapvpwrvgnd_1
XFILLER_78_29 VPWR VGND VPWR VGND sky130_ef_sc_hd__decap_12
XTAP_TAPCELL_ROW_9_428 VGND VPWR sky130_fd_sc_hd__tapvpwrvgnd_1
XFILLER_104_757 VPWR VGND VPWR VGND sky130_ef_sc_hd__decap_12
XFILLER_103_223 VGND VGND VPWR VPWR sky130_fd_sc_hd__fill_1
XFILLER_103_212 VGND VGND VPWR VPWR sky130_fd_sc_hd__decap_3
XFILLER_1_328 VGND VGND VPWR VPWR sky130_fd_sc_hd__decap_8
X_09966_ _02528_ _02529_ VGND VGND VPWR VPWR _02530_ sky130_fd_sc_hd__nor2_1
X_09897_ _02447_ _02449_ _02450_ _02453_ VGND VGND VPWR VPWR _02455_ sky130_fd_sc_hd__or4_1
X_08917_ net595 net585 net357 net355 VGND VGND VPWR VPWR _01386_ sky130_fd_sc_hd__and4_1
XFILLER_103_289 VGND VGND VPWR VPWR sky130_fd_sc_hd__decap_4
X_08848_ _01312_ _01313_ VGND VGND VPWR VPWR _01314_ sky130_fd_sc_hd__or2_1
XFILLER_69_181 VGND VGND VPWR VPWR sky130_fd_sc_hd__decap_6
XFILLER_57_354 VPWR VGND VPWR VGND sky130_ef_sc_hd__decap_12
XFILLER_45_505 VPWR VGND VPWR VGND sky130_ef_sc_hd__decap_12
XTAP_TAPCELL_ROW_28_703 VGND VPWR sky130_fd_sc_hd__tapvpwrvgnd_1
X_08779_ _01055_ _01090_ _01119_ _01123_ VGND VGND VPWR VPWR _01245_ sky130_fd_sc_hd__o31a_1
XFILLER_27_55 VGND VGND VPWR VPWR sky130_fd_sc_hd__fill_1
XFILLER_72_368 VGND VGND VPWR VPWR sky130_fd_sc_hd__decap_3
XFILLER_72_357 VGND VGND VPWR VPWR sky130_fd_sc_hd__decap_6
X_11790_ _04506_ _04516_ VGND VGND VPWR VPWR _04518_ sky130_fd_sc_hd__xnor2_1
X_10810_ _03443_ _03446_ VGND VGND VPWR VPWR _03448_ sky130_fd_sc_hd__xor2_1
XFILLER_41_711 VGND VGND VPWR VPWR sky130_fd_sc_hd__fill_1
X_10741_ _03371_ VGND VGND VPWR VPWR _03372_ sky130_fd_sc_hd__inv_2
XFILLER_26_796 VPWR VGND VPWR VGND sky130_ef_sc_hd__decap_12
X_13460_ net256 net379 net254 VGND VGND VPWR VPWR _06337_ sky130_fd_sc_hd__or3_1
XFILLER_41_766 VPWR VGND VPWR VGND sky130_ef_sc_hd__decap_12
XFILLER_9_417 VGND VGND VPWR VPWR sky130_fd_sc_hd__decap_3
XFILLER_13_446 VGND VGND VPWR VPWR sky130_fd_sc_hd__fill_2
XTAP_TAPCELL_ROW_101_1764 VGND VPWR sky130_fd_sc_hd__tapvpwrvgnd_1
X_12411_ _05187_ _05189_ _05190_ VGND VGND VPWR VPWR _05192_ sky130_fd_sc_hd__a21o_1
X_10672_ _03293_ _03294_ _03295_ VGND VGND VPWR VPWR _03297_ sky130_fd_sc_hd__a21o_1
XFILLER_138_153 VPWR VGND VPWR VGND sky130_ef_sc_hd__decap_12
X_13391_ net256 net381 net254 VGND VGND VPWR VPWR _06262_ sky130_fd_sc_hd__o21a_1
XTAP_TAPCELL_ROW_134_2241 VGND VPWR sky130_fd_sc_hd__tapvpwrvgnd_1
X_12342_ _05114_ _05115_ VGND VGND VPWR VPWR _05116_ sky130_fd_sc_hd__or2_1
XFILLER_138_197 VPWR VGND VPWR VGND sky130_ef_sc_hd__decap_12
X_12273_ _05037_ _05039_ _05018_ VGND VGND VPWR VPWR _05041_ sky130_fd_sc_hd__o21ai_1
XFILLER_107_573 VPWR VGND VPWR VGND sky130_ef_sc_hd__decap_12
XFILLER_5_667 VGND VGND VPWR VPWR sky130_fd_sc_hd__decap_4
XFILLER_4_15 VPWR VGND VPWR VGND sky130_ef_sc_hd__decap_12
X_11224_ _03769_ _03779_ _03778_ VGND VGND VPWR VPWR _03900_ sky130_fd_sc_hd__a21o_1
XFILLER_134_392 VGND VGND VPWR VPWR sky130_fd_sc_hd__decap_4
XFILLER_4_177 VGND VGND VPWR VPWR sky130_fd_sc_hd__decap_6
X_11155_ _03455_ _03824_ VGND VGND VPWR VPWR _03825_ sky130_fd_sc_hd__nand2_1
X_10106_ _02681_ _02682_ VGND VGND VPWR VPWR _00059_ sky130_fd_sc_hd__xor2_1
XFILLER_95_438 VGND VGND VPWR VPWR sky130_fd_sc_hd__decap_8
XFILLER_68_95 VGND VGND VPWR VPWR sky130_fd_sc_hd__decap_3
XFILLER_0_350 VGND VGND VPWR VPWR sky130_fd_sc_hd__decap_3
X_11086_ _03741_ _03748_ VGND VGND VPWR VPWR _03749_ sky130_fd_sc_hd__nor2_1
X_10037_ net260 net342 _02528_ _02529_ VGND VGND VPWR VPWR _02607_ sky130_fd_sc_hd__o22a_1
XFILLER_48_387 VPWR VGND VPWR VGND sky130_ef_sc_hd__decap_12
XFILLER_48_365 VGND VGND VPWR VPWR sky130_fd_sc_hd__decap_6
XFILLER_90_132 VGND VGND VPWR VPWR sky130_fd_sc_hd__decap_8
X_11988_ _04724_ _04728_ VGND VGND VPWR VPWR _04730_ sky130_fd_sc_hd__nand2b_1
XTAP_TAPCELL_ROW_63_1214 VGND VPWR sky130_fd_sc_hd__tapvpwrvgnd_1
X_10939_ _03566_ _03586_ VGND VGND VPWR VPWR _03589_ sky130_fd_sc_hd__xnor2_1
XFILLER_16_273 VGND VGND VPWR VPWR sky130_fd_sc_hd__decap_3
XFILLER_17_785 VPWR VGND VPWR VGND sky130_ef_sc_hd__decap_12
XFILLER_71_390 VGND VGND VPWR VPWR sky130_fd_sc_hd__fill_2
XFILLER_31_232 VGND VGND VPWR VPWR sky130_fd_sc_hd__fill_2
X_13658_ clknet_3_7__leaf_clk _00065_ net718 VGND VGND VPWR VPWR net193 sky130_fd_sc_hd__dfrtp_1
X_12609_ net266 net695 _05226_ VGND VGND VPWR VPWR _05408_ sky130_fd_sc_hd__o21a_1
X_13589_ _06474_ _06475_ VGND VGND VPWR VPWR _06478_ sky130_fd_sc_hd__xor2_1
XFILLER_76_3 VPWR VGND VPWR VGND sky130_ef_sc_hd__decap_12
XTAP_TAPCELL_ROW_14_496 VGND VPWR sky130_fd_sc_hd__tapvpwrvgnd_1
XFILLER_117_348 VGND VGND VPWR VPWR sky130_fd_sc_hd__decap_4
XFILLER_132_307 VGND VGND VPWR VPWR sky130_fd_sc_hd__fill_1
XFILLER_125_381 VGND VGND VPWR VPWR sky130_fd_sc_hd__decap_8
XTAP_TAPCELL_ROW_74_1365 VGND VPWR sky130_fd_sc_hd__tapvpwrvgnd_1
Xfanout418 net421 VGND VGND VPWR VPWR net418 sky130_fd_sc_hd__clkbuf_4
X_09820_ _02263_ _02266_ VGND VGND VPWR VPWR _02372_ sky130_fd_sc_hd__nor2_1
Xfanout429 net432 VGND VGND VPWR VPWR net429 sky130_fd_sc_hd__dlymetal6s2s_1
XFILLER_86_405 VGND VGND VPWR VPWR sky130_fd_sc_hd__decap_8
Xfanout407 net18 VGND VGND VPWR VPWR net407 sky130_fd_sc_hd__buf_2
XTAP_TAPCELL_ROW_74_1376 VGND VPWR sky130_fd_sc_hd__tapvpwrvgnd_1
X_09751_ _02294_ _02295_ VGND VGND VPWR VPWR _02297_ sky130_fd_sc_hd__xnor2_2
X_06963_ net687 net686 net512 net503 VGND VGND VPWR VPWR _02931_ sky130_fd_sc_hd__and4_1
XFILLER_104_27 VGND VGND VPWR VPWR sky130_fd_sc_hd__fill_1
X_08702_ _01166_ _01167_ _01168_ VGND VGND VPWR VPWR _01169_ sky130_fd_sc_hd__nand3_1
XFILLER_67_641 VPWR VGND VPWR VGND sky130_ef_sc_hd__decap_12
X_09682_ _02187_ _02219_ VGND VGND VPWR VPWR _02221_ sky130_fd_sc_hd__xnor2_1
XFILLER_67_685 VPWR VGND VPWR VGND sky130_ef_sc_hd__decap_12
X_06894_ net114 net511 VGND VGND VPWR VPWR _02183_ sky130_fd_sc_hd__nand2_1
X_08633_ _01098_ _01099_ VGND VGND VPWR VPWR _01100_ sky130_fd_sc_hd__nor2_1
X_08564_ net656 net646 net376 net374 VGND VGND VPWR VPWR _01032_ sky130_fd_sc_hd__and4_1
XFILLER_82_677 VGND VGND VPWR VPWR sky130_fd_sc_hd__decap_8
XFILLER_81_165 VGND VGND VPWR VPWR sky130_fd_sc_hd__decap_3
XFILLER_120_15 VPWR VGND VPWR VGND sky130_ef_sc_hd__decap_12
XFILLER_81_176 VPWR VGND VPWR VGND sky130_ef_sc_hd__decap_12
X_07515_ net694 net563 net554 net692 VGND VGND VPWR VPWR _06744_ sky130_fd_sc_hd__and4_1
XFILLER_80_19 VGND VGND VPWR VPWR sky130_fd_sc_hd__decap_8
XFILLER_50_530 VGND VGND VPWR VPWR sky130_fd_sc_hd__fill_2
XFILLER_22_221 VPWR VGND VPWR VGND sky130_ef_sc_hd__decap_12
X_08495_ _00799_ _00958_ _00957_ VGND VGND VPWR VPWR _00967_ sky130_fd_sc_hd__a21bo_1
X_07446_ _06528_ _06674_ VGND VGND VPWR VPWR _06676_ sky130_fd_sc_hd__xor2_1
XFILLER_22_265 VGND VGND VPWR VPWR sky130_fd_sc_hd__fill_1
XTAP_TAPCELL_ROW_33_772 VGND VPWR sky130_fd_sc_hd__tapvpwrvgnd_1
X_07377_ net687 net476 _04569_ VGND VGND VPWR VPWR _06607_ sky130_fd_sc_hd__and3_1
XFILLER_13_57 VPWR VGND VPWR VGND sky130_ef_sc_hd__decap_12
XTAP_TAPCELL_ROW_33_783 VGND VPWR sky130_fd_sc_hd__tapvpwrvgnd_1
XFILLER_129_57 VPWR VGND VPWR VGND sky130_ef_sc_hd__decap_12
X_09116_ _01600_ _01601_ _01588_ VGND VGND VPWR VPWR _01603_ sky130_fd_sc_hd__a21o_1
X_09047_ _01527_ VGND VGND VPWR VPWR _01528_ sky130_fd_sc_hd__inv_2
XFILLER_108_359 VGND VGND VPWR VPWR sky130_fd_sc_hd__fill_1
XFILLER_135_167 VGND VGND VPWR VPWR sky130_fd_sc_hd__fill_1
XFILLER_124_819 VGND VGND VPWR VPWR sky130_fd_sc_hd__fill_1
XFILLER_123_307 VGND VGND VPWR VPWR sky130_fd_sc_hd__fill_2
XFILLER_1_125 VPWR VGND VPWR VGND sky130_ef_sc_hd__decap_12
XPHY_EDGE_ROW_8_Left_147 VGND VGND VPWR VPWR sky130_fd_sc_hd__decap_3
X_09949_ _02396_ _02405_ _02404_ VGND VGND VPWR VPWR _02512_ sky130_fd_sc_hd__a21oi_1
XFILLER_1_169 VPWR VGND VPWR VGND sky130_ef_sc_hd__decap_12
XFILLER_77_449 VGND VGND VPWR VPWR sky130_fd_sc_hd__decap_8
XFILLER_92_419 VGND VGND VPWR VPWR sky130_fd_sc_hd__fill_1
X_12960_ _05789_ _05790_ VGND VGND VPWR VPWR _05791_ sky130_fd_sc_hd__nor2_1
XFILLER_58_685 VPWR VGND VPWR VGND sky130_ef_sc_hd__decap_12
XFILLER_46_803 VGND VGND VPWR VPWR sky130_fd_sc_hd__decap_8
XFILLER_38_65 VPWR VGND VPWR VGND sky130_ef_sc_hd__decap_12
XFILLER_100_793 VPWR VGND VPWR VGND sky130_ef_sc_hd__decap_12
X_12891_ _05715_ _05714_ VGND VGND VPWR VPWR _05716_ sky130_fd_sc_hd__and2b_1
XFILLER_73_644 VGND VGND VPWR VPWR sky130_fd_sc_hd__fill_2
X_11911_ _04647_ _04648_ VGND VGND VPWR VPWR _04649_ sky130_fd_sc_hd__xnor2_1
XFILLER_61_817 VGND VGND VPWR VPWR sky130_fd_sc_hd__decap_3
X_11842_ _04464_ _04490_ _04462_ VGND VGND VPWR VPWR _04574_ sky130_fd_sc_hd__a21oi_1
XFILLER_54_53 VPWR VGND VPWR VGND sky130_ef_sc_hd__decap_12
X_13512_ _06392_ _06393_ VGND VGND VPWR VPWR _06394_ sky130_fd_sc_hd__nor2_1
XFILLER_53_390 VGND VGND VPWR VPWR sky130_fd_sc_hd__fill_2
X_11773_ _04312_ _04498_ VGND VGND VPWR VPWR _04499_ sky130_fd_sc_hd__xor2_1
XFILLER_14_755 VGND VGND VPWR VPWR sky130_fd_sc_hd__fill_1
XFILLER_9_225 VPWR VGND VPWR VGND sky130_ef_sc_hd__decap_12
XFILLER_13_254 VGND VGND VPWR VPWR sky130_fd_sc_hd__decap_4
X_10724_ _03060_ _03353_ _03352_ _03200_ VGND VGND VPWR VPWR _03354_ sky130_fd_sc_hd__and4_1
X_13443_ _05971_ _06238_ _05826_ VGND VGND VPWR VPWR _06318_ sky130_fd_sc_hd__o21a_1
XFILLER_70_41 VPWR VGND VPWR VGND sky130_ef_sc_hd__decap_12
X_10655_ _03249_ _03277_ VGND VGND VPWR VPWR _03278_ sky130_fd_sc_hd__and2b_1
X_13374_ _06234_ _06242_ VGND VGND VPWR VPWR _06243_ sky130_fd_sc_hd__xnor2_1
XFILLER_70_85 VGND VGND VPWR VPWR sky130_fd_sc_hd__decap_4
XTAP_TAPCELL_ROW_11_455 VGND VPWR sky130_fd_sc_hd__tapvpwrvgnd_1
X_12325_ net573 net660 _04952_ _04951_ VGND VGND VPWR VPWR _05097_ sky130_fd_sc_hd__a31o_1
X_10586_ _03198_ _03199_ _03201_ VGND VGND VPWR VPWR _03203_ sky130_fd_sc_hd__a21o_1
XFILLER_5_453 VGND VGND VPWR VPWR sky130_fd_sc_hd__decap_8
XFILLER_5_442 VGND VGND VPWR VPWR sky130_fd_sc_hd__decap_6
XTAP_TAPCELL_ROW_114_1955 VGND VPWR sky130_fd_sc_hd__tapvpwrvgnd_1
X_12256_ _05020_ _05021_ VGND VGND VPWR VPWR _05022_ sky130_fd_sc_hd__and2b_1
XFILLER_5_486 VGND VGND VPWR VPWR sky130_fd_sc_hd__fill_1
X_12187_ _04944_ _04945_ VGND VGND VPWR VPWR _04946_ sky130_fd_sc_hd__xnor2_1
X_11207_ net560 net552 net301 net299 VGND VGND VPWR VPWR _03881_ sky130_fd_sc_hd__and4_1
X_11138_ net415 net278 VGND VGND VPWR VPWR _03807_ sky130_fd_sc_hd__nand2_1
XFILLER_110_557 VGND VGND VPWR VPWR sky130_fd_sc_hd__decap_8
XFILLER_95_246 VGND VGND VPWR VPWR sky130_fd_sc_hd__decap_3
X_11069_ net310 net308 net537 net532 VGND VGND VPWR VPWR _03731_ sky130_fd_sc_hd__and4b_1
XFILLER_0_191 VGND VGND VPWR VPWR sky130_fd_sc_hd__fill_1
XFILLER_91_463 VGND VGND VPWR VPWR sky130_fd_sc_hd__decap_4
XFILLER_17_582 VPWR VGND VPWR VGND sky130_ef_sc_hd__decap_12
XTAP_TAPCELL_ROW_19_577 VGND VPWR sky130_fd_sc_hd__tapvpwrvgnd_1
X_07300_ net710 net709 net631 net623 VGND VGND VPWR VPWR _06531_ sky130_fd_sc_hd__and4_1
XFILLER_63_198 VPWR VGND VPWR VGND sky130_ef_sc_hd__decap_12
X_08280_ net484 net475 net675 VGND VGND VPWR VPWR _00755_ sky130_fd_sc_hd__and3_2
X_07231_ _05744_ _05843_ VGND VGND VPWR VPWR _05854_ sky130_fd_sc_hd__xor2_1
XFILLER_20_747 VGND VGND VPWR VPWR sky130_fd_sc_hd__decap_8
XTAP_TAPCELL_ROW_30_731 VGND VPWR sky130_fd_sc_hd__tapvpwrvgnd_1
X_07162_ net642 net708 net707 net650 VGND VGND VPWR VPWR _05100_ sky130_fd_sc_hd__a22oi_2
XFILLER_20_769 VPWR VGND VPWR VGND sky130_ef_sc_hd__decap_12
XTAP_TAPCELL_ROW_76_1405 VGND VPWR sky130_fd_sc_hd__tapvpwrvgnd_1
XFILLER_105_318 VGND VGND VPWR VPWR sky130_fd_sc_hd__fill_2
X_07093_ _04329_ _04340_ VGND VGND VPWR VPWR _04351_ sky130_fd_sc_hd__nand2_1
X_09803_ _02350_ _02351_ VGND VGND VPWR VPWR _02353_ sky130_fd_sc_hd__xnor2_1
XFILLER_115_15 VPWR VGND VPWR VGND sky130_ef_sc_hd__decap_12
XFILLER_59_427 VGND VGND VPWR VPWR sky130_fd_sc_hd__decap_3
Xfanout259 _01376_ VGND VGND VPWR VPWR net259 sky130_fd_sc_hd__buf_4
XFILLER_101_535 VPWR VGND VPWR VGND sky130_ef_sc_hd__decap_12
XFILLER_75_19 VPWR VGND VPWR VGND sky130_ef_sc_hd__decap_12
XFILLER_59_449 VGND VGND VPWR VPWR sky130_fd_sc_hd__decap_6
X_07995_ net681 net484 net677 net475 VGND VGND VPWR VPWR _00472_ sky130_fd_sc_hd__and4_1
Xfanout248 _03901_ VGND VGND VPWR VPWR net248 sky130_fd_sc_hd__clkbuf_4
X_09734_ _02139_ _02277_ VGND VGND VPWR VPWR _02278_ sky130_fd_sc_hd__xnor2_2
X_06946_ _02619_ _02652_ VGND VGND VPWR VPWR _02750_ sky130_fd_sc_hd__nor2_1
X_09665_ _02042_ _02046_ _02200_ VGND VGND VPWR VPWR _02202_ sky130_fd_sc_hd__nor3_1
XFILLER_67_482 VGND VGND VPWR VPWR sky130_fd_sc_hd__fill_1
X_06877_ _01605_ _01976_ VGND VGND VPWR VPWR _01998_ sky130_fd_sc_hd__xor2_1
XFILLER_27_324 VGND VGND VPWR VPWR sky130_fd_sc_hd__decap_4
X_08616_ _01051_ _01082_ VGND VGND VPWR VPWR _01083_ sky130_fd_sc_hd__nor2_1
XTAP_TAPCELL_ROW_87_1567 VGND VPWR sky130_fd_sc_hd__tapvpwrvgnd_1
XTAP_TAPCELL_ROW_87_1556 VGND VPWR sky130_fd_sc_hd__tapvpwrvgnd_1
XFILLER_55_677 VPWR VGND VPWR VGND sky130_ef_sc_hd__decap_12
XFILLER_54_154 VGND VGND VPWR VPWR sky130_fd_sc_hd__fill_2
XTAP_TAPCELL_ROW_38_853 VGND VPWR sky130_fd_sc_hd__tapvpwrvgnd_1
XFILLER_131_69 VPWR VGND VPWR VGND sky130_ef_sc_hd__decap_12
X_09596_ _02109_ _02126_ VGND VGND VPWR VPWR _02127_ sky130_fd_sc_hd__xor2_2
XFILLER_82_474 VGND VGND VPWR VPWR sky130_fd_sc_hd__fill_2
X_08547_ net523 net352 net351 net530 VGND VGND VPWR VPWR _01016_ sky130_fd_sc_hd__a22o_1
XFILLER_70_669 VPWR VGND VPWR VGND sky130_ef_sc_hd__decap_12
XFILLER_42_349 VPWR VGND VPWR VGND sky130_ef_sc_hd__decap_12
XFILLER_35_390 VGND VGND VPWR VPWR sky130_fd_sc_hd__fill_2
XFILLER_23_552 VGND VGND VPWR VPWR sky130_fd_sc_hd__fill_2
X_08478_ _00693_ _00856_ _00855_ VGND VGND VPWR VPWR _00951_ sky130_fd_sc_hd__a21boi_1
XTAP_TAPCELL_ROW_118_2011 VGND VPWR sky130_fd_sc_hd__tapvpwrvgnd_1
X_07429_ net466 net661 VGND VGND VPWR VPWR _06659_ sky130_fd_sc_hd__nand2_4
XFILLER_109_613 VGND VGND VPWR VPWR sky130_fd_sc_hd__decap_3
XFILLER_7_729 VPWR VGND VPWR VGND sky130_ef_sc_hd__decap_12
X_10440_ _02863_ _02902_ VGND VGND VPWR VPWR _03044_ sky130_fd_sc_hd__and2_1
XTAP_TAPCELL_ROW_131_2200 VGND VPWR sky130_fd_sc_hd__tapvpwrvgnd_1
X_10371_ net458 net450 net282 net280 VGND VGND VPWR VPWR _02968_ sky130_fd_sc_hd__and4_1
XFILLER_40_77 VGND VGND VPWR VPWR sky130_fd_sc_hd__decap_6
XFILLER_136_498 VGND VGND VPWR VPWR sky130_fd_sc_hd__fill_2
X_13090_ _05892_ _05931_ VGND VGND VPWR VPWR _05933_ sky130_fd_sc_hd__xnor2_2
X_12110_ _04855_ _04856_ _04862_ VGND VGND VPWR VPWR _04863_ sky130_fd_sc_hd__nand3_1
X_12041_ _04779_ _04785_ VGND VGND VPWR VPWR _04787_ sky130_fd_sc_hd__xor2_1
XFILLER_6_3 VPWR VGND VPWR VGND sky130_ef_sc_hd__decap_12
XFILLER_2_456 VGND VGND VPWR VPWR sky130_fd_sc_hd__fill_2
XFILLER_78_736 VPWR VGND VPWR VGND sky130_ef_sc_hd__decap_12
XTAP_TAPCELL_ROW_129_2173 VGND VPWR sky130_fd_sc_hd__tapvpwrvgnd_1
XFILLER_93_706 VGND VGND VPWR VPWR sky130_fd_sc_hd__fill_1
XFILLER_1_27 VPWR VGND VPWR VGND sky130_ef_sc_hd__decap_12
XFILLER_105_81 VGND VGND VPWR VPWR sky130_fd_sc_hd__decap_3
X_12943_ _05769_ _05770_ VGND VGND VPWR VPWR _05772_ sky130_fd_sc_hd__xnor2_1
XFILLER_58_482 VPWR VGND VPWR VGND sky130_ef_sc_hd__decap_12
XFILLER_18_302 VGND VGND VPWR VPWR sky130_fd_sc_hd__decap_6
XFILLER_73_485 VPWR VGND VPWR VGND sky130_ef_sc_hd__decap_12
X_12874_ net285 _00259_ _00261_ VGND VGND VPWR VPWR _05697_ sky130_fd_sc_hd__nand3_1
XFILLER_61_614 VGND VGND VPWR VPWR sky130_fd_sc_hd__fill_2
XFILLER_46_688 VGND VGND VPWR VPWR sky130_fd_sc_hd__fill_2
XFILLER_61_658 VGND VGND VPWR VPWR sky130_fd_sc_hd__decap_8
XTAP_TAPCELL_ROW_16_525 VGND VPWR sky130_fd_sc_hd__tapvpwrvgnd_1
XTAP_TAPCELL_ROW_16_536 VGND VPWR sky130_fd_sc_hd__tapvpwrvgnd_1
X_11825_ _04554_ VGND VGND VPWR VPWR _04555_ sky130_fd_sc_hd__inv_2
XFILLER_60_168 VPWR VGND VPWR VGND sky130_ef_sc_hd__decap_12
X_11756_ _04478_ _04479_ VGND VGND VPWR VPWR _04480_ sky130_fd_sc_hd__or2_1
XFILLER_81_95 VPWR VGND VPWR VGND sky130_ef_sc_hd__decap_12
X_10707_ _03304_ _03333_ _03334_ VGND VGND VPWR VPWR _03335_ sky130_fd_sc_hd__nand3_1
X_13426_ _06036_ _06190_ _06189_ VGND VGND VPWR VPWR _06299_ sky130_fd_sc_hd__a21oi_1
X_11687_ _04404_ _04381_ VGND VGND VPWR VPWR _04405_ sky130_fd_sc_hd__and2b_1
X_10638_ _03256_ _03257_ _03254_ VGND VGND VPWR VPWR _03260_ sky130_fd_sc_hd__a21bo_1
X_13357_ _05316_ _06223_ VGND VGND VPWR VPWR _06224_ sky130_fd_sc_hd__xnor2_1
XFILLER_60_6 VPWR VGND VPWR VGND sky130_ef_sc_hd__decap_12
XTAP_TAPCELL_ROW_58_1135 VGND VPWR sky130_fd_sc_hd__tapvpwrvgnd_1
XFILLER_6_751 VGND VGND VPWR VPWR sky130_fd_sc_hd__decap_4
X_10569_ _03181_ _03182_ _03023_ _03026_ VGND VGND VPWR VPWR _03185_ sky130_fd_sc_hd__o211a_1
XFILLER_127_498 VGND VGND VPWR VPWR sky130_fd_sc_hd__decap_6
X_12308_ _05076_ _05077_ VGND VGND VPWR VPWR _05079_ sky130_fd_sc_hd__xnor2_1
X_13288_ _06146_ _06147_ VGND VGND VPWR VPWR _06150_ sky130_fd_sc_hd__xor2_2
XTAP_TAPCELL_ROW_58_1146 VGND VPWR sky130_fd_sc_hd__tapvpwrvgnd_1
XFILLER_114_148 VGND VGND VPWR VPWR sky130_fd_sc_hd__decap_6
X_12239_ net462 net385 net29 net454 VGND VGND VPWR VPWR _05004_ sky130_fd_sc_hd__a22oi_2
XFILLER_123_671 VGND VGND VPWR VPWR sky130_fd_sc_hd__fill_1
XTAP_TAPCELL_ROW_71_1335 VGND VPWR sky130_fd_sc_hd__tapvpwrvgnd_1
XTAP_TAPCELL_ROW_71_1324 VGND VPWR sky130_fd_sc_hd__tapvpwrvgnd_1
XFILLER_39_3 VPWR VGND VPWR VGND sky130_ef_sc_hd__decap_12
XFILLER_96_533 VGND VGND VPWR VPWR sky130_fd_sc_hd__decap_6
XFILLER_110_365 VGND VGND VPWR VPWR sky130_fd_sc_hd__decap_4
XFILLER_84_739 VGND VGND VPWR VPWR sky130_fd_sc_hd__decap_3
X_07780_ net650 net644 net636 VGND VGND VPWR VPWR _00259_ sky130_fd_sc_hd__or3_4
XFILLER_77_791 VGND VGND VPWR VPWR sky130_fd_sc_hd__fill_1
Xinput4 w00[2] VGND VGND VPWR VPWR net4 sky130_fd_sc_hd__buf_2
XFILLER_37_611 VGND VGND VPWR VPWR sky130_fd_sc_hd__decap_4
X_09450_ _01958_ _01967_ VGND VGND VPWR VPWR _01968_ sky130_fd_sc_hd__xnor2_1
XFILLER_92_761 VGND VGND VPWR VPWR sky130_fd_sc_hd__fill_1
XFILLER_25_817 VGND VGND VPWR VPWR sky130_fd_sc_hd__decap_3
XFILLER_36_121 VPWR VGND VPWR VGND sky130_ef_sc_hd__decap_12
XFILLER_37_655 VGND VGND VPWR VPWR sky130_fd_sc_hd__fill_2
XTAP_TAPCELL_ROW_69_1297 VGND VPWR sky130_fd_sc_hd__tapvpwrvgnd_1
XFILLER_64_474 VGND VGND VPWR VPWR sky130_fd_sc_hd__fill_2
XTAP_TAPCELL_ROW_35_801 VGND VPWR sky130_fd_sc_hd__tapvpwrvgnd_1
XTAP_TAPCELL_ROW_35_812 VGND VPWR sky130_fd_sc_hd__tapvpwrvgnd_1
X_08401_ _00873_ _00874_ VGND VGND VPWR VPWR _00875_ sky130_fd_sc_hd__nand2_1
X_09381_ net574 net49 _06762_ _01723_ VGND VGND VPWR VPWR _01893_ sky130_fd_sc_hd__a22oi_2
XFILLER_51_124 VGND VGND VPWR VPWR sky130_fd_sc_hd__decap_4
XFILLER_51_113 VGND VGND VPWR VPWR sky130_fd_sc_hd__decap_6
XFILLER_24_349 VPWR VGND VPWR VGND sky130_ef_sc_hd__decap_12
X_08332_ _00726_ _00804_ VGND VGND VPWR VPWR _00806_ sky130_fd_sc_hd__xnor2_1
XFILLER_32_360 VGND VGND VPWR VPWR sky130_fd_sc_hd__decap_4
XTAP_TAPCELL_ROW_82_1486 VGND VPWR sky130_fd_sc_hd__tapvpwrvgnd_1
X_08263_ _00625_ _00638_ _00736_ VGND VGND VPWR VPWR _00738_ sky130_fd_sc_hd__or3_1
XFILLER_20_522 VGND VGND VPWR VPWR sky130_fd_sc_hd__fill_2
XFILLER_137_207 VGND VGND VPWR VPWR sky130_fd_sc_hd__decap_3
X_07214_ _05635_ _05646_ VGND VGND VPWR VPWR _05668_ sky130_fd_sc_hd__xnor2_1
XFILLER_118_432 VPWR VGND VPWR VGND sky130_ef_sc_hd__decap_12
XFILLER_118_421 VGND VGND VPWR VPWR sky130_fd_sc_hd__decap_4
X_08194_ _00668_ _00669_ VGND VGND VPWR VPWR _00670_ sky130_fd_sc_hd__or2_1
XPHY_EDGE_ROW_89_Left_228 VGND VGND VPWR VPWR sky130_fd_sc_hd__decap_3
X_07145_ net673 net444 _03161_ _03150_ VGND VGND VPWR VPWR _04915_ sky130_fd_sc_hd__a31o_1
X_07076_ _04156_ VGND VGND VPWR VPWR _04166_ sky130_fd_sc_hd__inv_2
XFILLER_133_479 VGND VGND VPWR VPWR sky130_fd_sc_hd__decap_4
XFILLER_102_811 VGND VGND VPWR VPWR sky130_fd_sc_hd__fill_1
XFILLER_86_29 VPWR VGND VPWR VGND sky130_ef_sc_hd__decap_12
XFILLER_99_393 VGND VGND VPWR VPWR sky130_fd_sc_hd__decap_6
XFILLER_59_279 VGND VGND VPWR VPWR sky130_fd_sc_hd__fill_1
X_07978_ _00174_ _00453_ VGND VGND VPWR VPWR _00455_ sky130_fd_sc_hd__xnor2_1
X_09717_ _02128_ _02137_ _02136_ VGND VGND VPWR VPWR _02259_ sky130_fd_sc_hd__a21o_1
XFILLER_101_376 VPWR VGND VPWR VGND sky130_ef_sc_hd__decap_12
XPHY_EDGE_ROW_98_Left_237 VGND VGND VPWR VPWR sky130_fd_sc_hd__decap_3
XFILLER_74_227 VGND VGND VPWR VPWR sky130_fd_sc_hd__decap_3
X_06929_ _02194_ _02554_ VGND VGND VPWR VPWR _02565_ sky130_fd_sc_hd__nand2b_1
XFILLER_16_806 VGND VGND VPWR VPWR sky130_fd_sc_hd__decap_6
X_09648_ _02070_ _02072_ _02181_ VGND VGND VPWR VPWR _02184_ sky130_fd_sc_hd__and3_1
XFILLER_83_783 VGND VGND VPWR VPWR sky130_fd_sc_hd__fill_1
XFILLER_27_176 VPWR VGND VPWR VGND sky130_ef_sc_hd__decap_12
XTAP_TAPCELL_ROW_124_2092 VGND VPWR sky130_fd_sc_hd__tapvpwrvgnd_1
X_09579_ _01958_ _01967_ _01966_ VGND VGND VPWR VPWR _02109_ sky130_fd_sc_hd__o21ai_2
XFILLER_70_433 VGND VGND VPWR VPWR sky130_fd_sc_hd__decap_8
XFILLER_43_658 VPWR VGND VPWR VGND sky130_ef_sc_hd__decap_12
XFILLER_42_135 VGND VGND VPWR VPWR sky130_fd_sc_hd__decap_4
XFILLER_31_809 VPWR VGND VPWR VGND sky130_ef_sc_hd__decap_12
XFILLER_35_55 VGND VGND VPWR VPWR sky130_fd_sc_hd__fill_1
X_12590_ _05386_ _05387_ VGND VGND VPWR VPWR _05388_ sky130_fd_sc_hd__or2_1
XFILLER_70_455 VGND VGND VPWR VPWR sky130_fd_sc_hd__decap_3
X_11610_ _04317_ _04319_ VGND VGND VPWR VPWR _04321_ sky130_fd_sc_hd__and2_1
XFILLER_35_99 VGND VGND VPWR VPWR sky130_fd_sc_hd__fill_2
XFILLER_23_382 VGND VGND VPWR VPWR sky130_fd_sc_hd__decap_8
XFILLER_23_393 VGND VGND VPWR VPWR sky130_fd_sc_hd__decap_6
X_11541_ _04242_ _04243_ VGND VGND VPWR VPWR _04246_ sky130_fd_sc_hd__xnor2_1
XFILLER_51_43 VPWR VGND VPWR VGND sky130_ef_sc_hd__decap_12
XFILLER_11_544 VGND VGND VPWR VPWR sky130_fd_sc_hd__decap_8
XFILLER_137_741 VPWR VGND VPWR VGND sky130_ef_sc_hd__decap_12
XFILLER_109_432 VPWR VGND VPWR VGND sky130_ef_sc_hd__decap_12
X_11472_ _04045_ _04060_ _04059_ VGND VGND VPWR VPWR _04171_ sky130_fd_sc_hd__o21ai_1
X_13211_ _05920_ _05922_ _06063_ VGND VGND VPWR VPWR _06065_ sky130_fd_sc_hd__a21o_1
XFILLER_7_559 VGND VGND VPWR VPWR sky130_fd_sc_hd__fill_1
X_10423_ _02982_ _03022_ _03024_ VGND VGND VPWR VPWR _03025_ sky130_fd_sc_hd__nor3_1
XFILLER_137_785 VPWR VGND VPWR VGND sky130_ef_sc_hd__decap_12
X_13142_ net284 _00259_ _05849_ _05695_ VGND VGND VPWR VPWR _05990_ sky130_fd_sc_hd__a31o_1
XFILLER_3_721 VGND VGND VPWR VPWR sky130_fd_sc_hd__decap_6
X_10354_ _02947_ _02948_ VGND VGND VPWR VPWR _02949_ sky130_fd_sc_hd__or2_1
XTAP_TAPCELL_ROW_111_1903 VGND VPWR sky130_fd_sc_hd__tapvpwrvgnd_1
XTAP_TAPCELL_ROW_111_1914 VGND VPWR sky130_fd_sc_hd__tapvpwrvgnd_1
XFILLER_105_671 VGND VGND VPWR VPWR sky130_fd_sc_hd__fill_1
X_13073_ _05782_ _05784_ _05781_ VGND VGND VPWR VPWR _05914_ sky130_fd_sc_hd__a21oi_1
X_10285_ net569 net313 _02871_ _02872_ VGND VGND VPWR VPWR _02874_ sky130_fd_sc_hd__a22oi_1
XFILLER_3_765 VPWR VGND VPWR VGND sky130_ef_sc_hd__decap_12
X_12024_ _04766_ _04767_ VGND VGND VPWR VPWR _04768_ sky130_fd_sc_hd__nand2_1
XTAP_TAPCELL_ROW_53_1065 VGND VPWR sky130_fd_sc_hd__tapvpwrvgnd_1
XFILLER_19_633 VGND VGND VPWR VPWR sky130_fd_sc_hd__decap_4
Xfanout590 net591 VGND VGND VPWR VPWR net590 sky130_fd_sc_hd__dlymetal6s2s_1
XFILLER_18_121 VPWR VGND VPWR VGND sky130_ef_sc_hd__decap_12
XTAP_TAPCELL_ROW_109_1876 VGND VPWR sky130_fd_sc_hd__tapvpwrvgnd_1
X_12926_ _05749_ _05752_ VGND VGND VPWR VPWR _05753_ sky130_fd_sc_hd__xnor2_1
XFILLER_74_772 VPWR VGND VPWR VGND sky130_ef_sc_hd__decap_12
XFILLER_61_411 VPWR VGND VPWR VGND sky130_ef_sc_hd__decap_12
XFILLER_18_154 VPWR VGND VPWR VGND sky130_ef_sc_hd__decap_12
XFILLER_19_688 VGND VGND VPWR VPWR sky130_fd_sc_hd__decap_4
X_12857_ _05323_ _05514_ _05517_ VGND VGND VPWR VPWR _05678_ sky130_fd_sc_hd__o21bai_1
XFILLER_18_187 VGND VGND VPWR VPWR sky130_fd_sc_hd__decap_8
XFILLER_33_113 VGND VGND VPWR VPWR sky130_fd_sc_hd__decap_6
XFILLER_34_636 VGND VGND VPWR VPWR sky130_fd_sc_hd__fill_1
XFILLER_92_83 VGND VGND VPWR VPWR sky130_fd_sc_hd__fill_1
X_11808_ _04306_ _04536_ VGND VGND VPWR VPWR _04538_ sky130_fd_sc_hd__xnor2_1
XFILLER_33_146 VGND VGND VPWR VPWR sky130_fd_sc_hd__fill_1
XFILLER_33_157 VGND VGND VPWR VPWR sky130_fd_sc_hd__decap_8
X_12788_ _05430_ _05601_ _05432_ VGND VGND VPWR VPWR _05603_ sky130_fd_sc_hd__o21ba_2
XFILLER_119_218 VGND VGND VPWR VPWR sky130_fd_sc_hd__decap_6
X_11739_ _04461_ _04459_ VGND VGND VPWR VPWR _04462_ sky130_fd_sc_hd__and2b_1
XFILLER_119_229 VGND VGND VPWR VPWR sky130_fd_sc_hd__decap_3
XTAP_TAPCELL_ROW_40_881 VGND VPWR sky130_fd_sc_hd__tapvpwrvgnd_1
X_13409_ _06278_ _06279_ VGND VGND VPWR VPWR _06282_ sky130_fd_sc_hd__and2_1
XFILLER_115_424 VPWR VGND VPWR VGND sky130_ef_sc_hd__decap_12
XFILLER_115_468 VGND VGND VPWR VPWR sky130_fd_sc_hd__fill_1
XFILLER_89_809 VPWR VGND VPWR VGND sky130_ef_sc_hd__decap_12
XFILLER_130_405 VGND VGND VPWR VPWR sky130_fd_sc_hd__fill_1
X_08950_ net524 net346 net344 net531 VGND VGND VPWR VPWR _01423_ sky130_fd_sc_hd__a22o_1
XPHY_EDGE_ROW_135_Right_135 VGND VGND VPWR VPWR sky130_fd_sc_hd__decap_3
X_08881_ _01347_ VGND VGND VPWR VPWR _01348_ sky130_fd_sc_hd__inv_2
XFILLER_96_330 VGND VGND VPWR VPWR sky130_fd_sc_hd__fill_2
X_07901_ _00371_ _00378_ VGND VGND VPWR VPWR _00379_ sky130_fd_sc_hd__xnor2_1
X_07832_ _00308_ _00309_ _00307_ VGND VGND VPWR VPWR _00310_ sky130_fd_sc_hd__nor3b_1
XFILLER_56_205 VGND VGND VPWR VPWR sky130_fd_sc_hd__fill_2
X_09502_ _01860_ _01861_ _01858_ VGND VGND VPWR VPWR _02025_ sky130_fd_sc_hd__o21bai_1
XFILLER_110_195 VGND VGND VPWR VPWR sky130_fd_sc_hd__fill_1
X_07763_ _00224_ _00241_ VGND VGND VPWR VPWR _00242_ sky130_fd_sc_hd__xor2_2
XTAP_TAPCELL_ROW_84_1515 VGND VPWR sky130_fd_sc_hd__tapvpwrvgnd_1
X_07694_ net571 net113 VGND VGND VPWR VPWR _00173_ sky130_fd_sc_hd__and2_1
XFILLER_37_463 VGND VGND VPWR VPWR sky130_fd_sc_hd__decap_6
X_09433_ _01913_ _01947_ VGND VGND VPWR VPWR _01949_ sky130_fd_sc_hd__xnor2_1
XFILLER_64_271 VGND VGND VPWR VPWR sky130_fd_sc_hd__fill_1
XTAP_TAPCELL_ROW_48_992 VGND VPWR sky130_fd_sc_hd__tapvpwrvgnd_1
X_09364_ _01872_ _01873_ VGND VGND VPWR VPWR _01874_ sky130_fd_sc_hd__xnor2_1
XFILLER_52_477 VGND VGND VPWR VPWR sky130_fd_sc_hd__decap_4
XFILLER_13_809 VPWR VGND VPWR VGND sky130_ef_sc_hd__decap_12
XFILLER_25_669 VGND VGND VPWR VPWR sky130_fd_sc_hd__decap_3
X_08315_ _00787_ _00788_ VGND VGND VPWR VPWR _00790_ sky130_fd_sc_hd__and2_1
X_09295_ _01796_ _01797_ _01788_ VGND VGND VPWR VPWR _01799_ sky130_fd_sc_hd__a21o_1
XANTENNA_20 net525 VGND VGND VPWR VPWR sky130_fd_sc_hd__diode_2
XFILLER_20_341 VGND VGND VPWR VPWR sky130_fd_sc_hd__fill_1
X_08246_ _00690_ _00719_ VGND VGND VPWR VPWR _00721_ sky130_fd_sc_hd__xnor2_1
XFILLER_119_774 VGND VGND VPWR VPWR sky130_fd_sc_hd__decap_8
X_08177_ _00643_ _00651_ VGND VGND VPWR VPWR _00653_ sky130_fd_sc_hd__xnor2_1
XFILLER_119_785 VPWR VGND VPWR VGND sky130_ef_sc_hd__decap_12
X_07128_ net683 _02477_ net526 net116 VGND VGND VPWR VPWR _04729_ sky130_fd_sc_hd__and4bb_1
XFILLER_21_57 VGND VGND VPWR VPWR sky130_fd_sc_hd__decap_3
XFILLER_137_57 VPWR VGND VPWR VGND sky130_ef_sc_hd__decap_12
XFILLER_134_755 VGND VGND VPWR VPWR sky130_fd_sc_hd__fill_1
XTAP_TAPCELL_ROW_95_1677 VGND VPWR sky130_fd_sc_hd__tapvpwrvgnd_1
X_07059_ _03937_ _03948_ _03959_ VGND VGND VPWR VPWR _03981_ sky130_fd_sc_hd__or3_1
Xoutput193 net193 VGND VGND VPWR VPWR y1[7] sky130_fd_sc_hd__buf_2
Xoutput182 net182 VGND VGND VPWR VPWR y1[12] sky130_fd_sc_hd__buf_2
X_10070_ _02464_ _02643_ VGND VGND VPWR VPWR _02644_ sky130_fd_sc_hd__nor2_1
XFILLER_133_298 VGND VGND VPWR VPWR sky130_fd_sc_hd__fill_2
XFILLER_121_449 VPWR VGND VPWR VGND sky130_ef_sc_hd__decap_12
XFILLER_121_427 VGND VGND VPWR VPWR sky130_fd_sc_hd__decap_8
XFILLER_102_630 VGND VGND VPWR VPWR sky130_fd_sc_hd__decap_4
Xoutput171 net171 VGND VGND VPWR VPWR y0[2] sky130_fd_sc_hd__buf_2
XPHY_EDGE_ROW_102_Right_102 VGND VGND VPWR VPWR sky130_fd_sc_hd__decap_3
XFILLER_87_352 VGND VGND VPWR VPWR sky130_fd_sc_hd__decap_3
XFILLER_0_757 VPWR VGND VPWR VGND sky130_ef_sc_hd__decap_12
XTAP_TAPCELL_ROW_126_2132 VGND VPWR sky130_fd_sc_hd__tapvpwrvgnd_1
XTAP_TAPCELL_ROW_126_2121 VGND VPWR sky130_fd_sc_hd__tapvpwrvgnd_1
XFILLER_87_385 VGND VGND VPWR VPWR sky130_fd_sc_hd__decap_6
XFILLER_47_205 VGND VGND VPWR VPWR sky130_fd_sc_hd__decap_8
XFILLER_46_65 VPWR VGND VPWR VGND sky130_ef_sc_hd__decap_12
X_10972_ _03622_ _03623_ VGND VGND VPWR VPWR _03625_ sky130_fd_sc_hd__xnor2_1
XFILLER_71_753 VPWR VGND VPWR VGND sky130_ef_sc_hd__decap_12
X_12711_ _05513_ _05518_ VGND VGND VPWR VPWR _05520_ sky130_fd_sc_hd__xnor2_1
X_13691_ clknet_3_3__leaf_clk _00050_ net714 VGND VGND VPWR VPWR net226 sky130_fd_sc_hd__dfrtp_1
X_12642_ _05443_ _05442_ VGND VGND VPWR VPWR _05444_ sky130_fd_sc_hd__nand2b_1
XFILLER_70_241 VGND VGND VPWR VPWR sky130_fd_sc_hd__fill_1
XFILLER_71_797 VGND VGND VPWR VPWR sky130_fd_sc_hd__decap_6
XFILLER_62_53 VPWR VGND VPWR VGND sky130_ef_sc_hd__decap_12
XTAP_TAPCELL_ROW_26_675 VGND VPWR sky130_fd_sc_hd__tapvpwrvgnd_1
X_12573_ _05165_ _05196_ _05195_ VGND VGND VPWR VPWR _05369_ sky130_fd_sc_hd__a21bo_1
XFILLER_62_97 VGND VGND VPWR VPWR sky130_fd_sc_hd__decap_6
XFILLER_8_813 VGND VGND VPWR VPWR sky130_fd_sc_hd__decap_8
XFILLER_129_549 VGND VGND VPWR VPWR sky130_fd_sc_hd__decap_4
XFILLER_7_15 VPWR VGND VPWR VGND sky130_ef_sc_hd__decap_12
X_11524_ _04222_ _04227_ VGND VGND VPWR VPWR _04228_ sky130_fd_sc_hd__and2b_1
XTAP_TAPCELL_ROW_137_2283 VGND VPWR sky130_fd_sc_hd__tapvpwrvgnd_1
X_11455_ _04151_ _04152_ VGND VGND VPWR VPWR _04153_ sky130_fd_sc_hd__nor2_1
XFILLER_7_334 VGND VGND VPWR VPWR sky130_fd_sc_hd__fill_2
XFILLER_11_385 VGND VGND VPWR VPWR sky130_fd_sc_hd__decap_6
X_10406_ _02995_ _03003_ _03002_ VGND VGND VPWR VPWR _03006_ sky130_fd_sc_hd__a21oi_1
XFILLER_124_221 VPWR VGND VPWR VGND sky130_ef_sc_hd__decap_12
X_11386_ _03927_ _04076_ VGND VGND VPWR VPWR _04077_ sky130_fd_sc_hd__xnor2_1
X_13125_ net445 _00231_ _05826_ net379 VGND VGND VPWR VPWR _05971_ sky130_fd_sc_hd__o211ai_4
X_10337_ _02926_ _02929_ VGND VGND VPWR VPWR _02930_ sky130_fd_sc_hd__nand2_1
X_13056_ net548 net422 VGND VGND VPWR VPWR _05895_ sky130_fd_sc_hd__nand2_1
X_10268_ _02853_ _02854_ VGND VGND VPWR VPWR _02856_ sky130_fd_sc_hd__or2_1
XFILLER_78_341 VGND VGND VPWR VPWR sky130_fd_sc_hd__decap_8
X_12007_ _04690_ _04696_ _04748_ VGND VGND VPWR VPWR _04750_ sky130_fd_sc_hd__nand3_1
XFILLER_66_503 VGND VGND VPWR VPWR sky130_fd_sc_hd__decap_8
X_10199_ _02716_ _02736_ _02735_ VGND VGND VPWR VPWR _02784_ sky130_fd_sc_hd__a21oi_1
XFILLER_66_547 VGND VGND VPWR VPWR sky130_fd_sc_hd__fill_2
XFILLER_53_208 VPWR VGND VPWR VGND sky130_ef_sc_hd__decap_12
X_12909_ _05616_ _05618_ _05734_ VGND VGND VPWR VPWR _05735_ sky130_fd_sc_hd__a21oi_2
XFILLER_46_282 VPWR VGND VPWR VGND sky130_ef_sc_hd__decap_12
XTAP_TAPCELL_ROW_66_1256 VGND VPWR sky130_fd_sc_hd__tapvpwrvgnd_1
XTAP_TAPCELL_ROW_45_951 VGND VPWR sky130_fd_sc_hd__tapvpwrvgnd_1
XFILLER_34_455 VPWR VGND VPWR VGND sky130_ef_sc_hd__decap_12
XFILLER_34_477 VPWR VGND VPWR VGND sky130_ef_sc_hd__decap_12
XFILLER_22_639 VGND VGND VPWR VPWR sky130_fd_sc_hd__decap_4
X_09080_ _01547_ _01564_ VGND VGND VPWR VPWR _01565_ sky130_fd_sc_hd__xnor2_1
X_08100_ _00443_ _00575_ VGND VGND VPWR VPWR _00576_ sky130_fd_sc_hd__xnor2_1
Xinput40 w10[6] VGND VGND VPWR VPWR net40 sky130_fd_sc_hd__clkbuf_2
X_08031_ net665 net417 VGND VGND VPWR VPWR _00508_ sky130_fd_sc_hd__nand2_1
Xinput62 w13[4] VGND VGND VPWR VPWR net62 sky130_fd_sc_hd__buf_1
Xinput51 w12[1] VGND VGND VPWR VPWR net51 sky130_fd_sc_hd__dlymetal6s2s_1
XFILLER_128_582 VGND VGND VPWR VPWR sky130_fd_sc_hd__decap_6
XFILLER_116_711 VGND VGND VPWR VPWR sky130_fd_sc_hd__decap_6
Xinput73 w20[7] VGND VGND VPWR VPWR net73 sky130_fd_sc_hd__clkbuf_2
Xinput95 w23[5] VGND VGND VPWR VPWR net95 sky130_fd_sc_hd__clkbuf_1
Xinput84 w22[2] VGND VGND VPWR VPWR net84 sky130_fd_sc_hd__buf_1
X_09982_ _02545_ _02546_ VGND VGND VPWR VPWR _02548_ sky130_fd_sc_hd__xnor2_1
XFILLER_115_276 VGND VGND VPWR VPWR sky130_fd_sc_hd__decap_4
XFILLER_107_27 VPWR VGND VPWR VGND sky130_ef_sc_hd__decap_12
XFILLER_131_758 VPWR VGND VPWR VGND sky130_ef_sc_hd__decap_12
X_08933_ _01367_ _01403_ VGND VGND VPWR VPWR _01404_ sky130_fd_sc_hd__xnor2_1
XFILLER_103_449 VGND VGND VPWR VPWR sky130_fd_sc_hd__decap_4
XFILLER_88_138 VGND VGND VPWR VPWR sky130_fd_sc_hd__fill_2
XFILLER_97_661 VGND VGND VPWR VPWR sky130_fd_sc_hd__fill_1
XFILLER_123_15 VPWR VGND VPWR VGND sky130_ef_sc_hd__decap_12
X_08864_ _01165_ _01177_ _01176_ VGND VGND VPWR VPWR _01330_ sky130_fd_sc_hd__a21bo_1
X_08795_ _01258_ _01260_ VGND VGND VPWR VPWR _01261_ sky130_fd_sc_hd__nand2_1
XFILLER_96_193 VGND VGND VPWR VPWR sky130_fd_sc_hd__decap_3
XFILLER_57_547 VGND VGND VPWR VPWR sky130_fd_sc_hd__decap_6
XFILLER_45_709 VGND VGND VPWR VPWR sky130_fd_sc_hd__fill_2
XTAP_TAPCELL_ROW_4_359 VGND VPWR sky130_fd_sc_hd__tapvpwrvgnd_1
X_07815_ _06741_ _00167_ _00164_ VGND VGND VPWR VPWR _00293_ sky130_fd_sc_hd__a21oi_1
X_07746_ _00089_ _00096_ _00095_ VGND VGND VPWR VPWR _00225_ sky130_fd_sc_hd__a21o_1
XFILLER_25_433 VPWR VGND VPWR VGND sky130_ef_sc_hd__decap_12
X_09416_ _01928_ _01929_ VGND VGND VPWR VPWR _01930_ sky130_fd_sc_hd__nand2b_1
XTAP_TAPCELL_ROW_121_2051 VGND VPWR sky130_fd_sc_hd__tapvpwrvgnd_1
XFILLER_13_606 VGND VGND VPWR VPWR sky130_fd_sc_hd__decap_8
XFILLER_13_617 VPWR VGND VPWR VGND sky130_ef_sc_hd__decap_12
XFILLER_25_455 VGND VGND VPWR VPWR sky130_fd_sc_hd__decap_4
X_07677_ _00154_ _00155_ VGND VGND VPWR VPWR _00156_ sky130_fd_sc_hd__xnor2_1
XFILLER_80_572 VGND VGND VPWR VPWR sky130_fd_sc_hd__fill_2
XFILLER_53_797 VPWR VGND VPWR VGND sky130_ef_sc_hd__decap_12
XFILLER_40_403 VGND VGND VPWR VPWR sky130_fd_sc_hd__decap_4
X_09347_ _01852_ _01854_ _01517_ VGND VGND VPWR VPWR _01856_ sky130_fd_sc_hd__o21ai_1
XFILLER_12_149 VGND VGND VPWR VPWR sky130_fd_sc_hd__fill_1
XTAP_TAPCELL_ROW_23_634 VGND VPWR sky130_fd_sc_hd__tapvpwrvgnd_1
XFILLER_40_458 VPWR VGND VPWR VGND sky130_ef_sc_hd__decap_12
XFILLER_138_335 VGND VGND VPWR VPWR sky130_fd_sc_hd__fill_1
X_09278_ _01744_ _01779_ VGND VGND VPWR VPWR _01781_ sky130_fd_sc_hd__xnor2_1
XTAP_TAPCELL_ROW_97_1706 VGND VPWR sky130_fd_sc_hd__tapvpwrvgnd_1
X_08229_ _00703_ net252 VGND VGND VPWR VPWR _00704_ sky130_fd_sc_hd__nand2b_1
XFILLER_119_593 VGND VGND VPWR VPWR sky130_fd_sc_hd__fill_1
XFILLER_106_210 VPWR VGND VPWR VGND sky130_ef_sc_hd__decap_12
X_11240_ _03878_ _03916_ VGND VGND VPWR VPWR _03918_ sky130_fd_sc_hd__xnor2_1
XFILLER_107_777 VGND VGND VPWR VPWR sky130_fd_sc_hd__decap_6
X_11171_ _03840_ _03841_ VGND VGND VPWR VPWR _03843_ sky130_fd_sc_hd__nand2_1
XFILLER_122_736 VPWR VGND VPWR VGND sky130_ef_sc_hd__decap_12
X_10122_ _02596_ _02600_ _02599_ VGND VGND VPWR VPWR _02700_ sky130_fd_sc_hd__o21ba_1
XFILLER_106_287 VGND VGND VPWR VPWR sky130_fd_sc_hd__decap_4
XFILLER_0_510 VGND VGND VPWR VPWR sky130_fd_sc_hd__decap_4
XFILLER_122_769 VPWR VGND VPWR VGND sky130_ef_sc_hd__decap_12
XFILLER_0_554 VGND VGND VPWR VPWR sky130_fd_sc_hd__fill_2
X_10053_ _02606_ _02624_ VGND VGND VPWR VPWR _02625_ sky130_fd_sc_hd__xnor2_1
XTAP_TAPCELL_ROW_50_1024 VGND VPWR sky130_fd_sc_hd__tapvpwrvgnd_1
XFILLER_75_344 VGND VGND VPWR VPWR sky130_fd_sc_hd__fill_2
XFILLER_75_333 VGND VGND VPWR VPWR sky130_fd_sc_hd__decap_3
XFILLER_48_569 VGND VGND VPWR VPWR sky130_fd_sc_hd__fill_2
XFILLER_75_377 VGND VGND VPWR VPWR sky130_fd_sc_hd__fill_2
XFILLER_63_528 VGND VGND VPWR VPWR sky130_fd_sc_hd__decap_8
XFILLER_29_783 VGND VGND VPWR VPWR sky130_fd_sc_hd__fill_1
XTAP_TAPCELL_ROW_106_1835 VGND VPWR sky130_fd_sc_hd__tapvpwrvgnd_1
XFILLER_16_433 VPWR VGND VPWR VGND sky130_ef_sc_hd__decap_12
X_10955_ _03604_ _03605_ VGND VGND VPWR VPWR _03606_ sky130_fd_sc_hd__xnor2_1
XTAP_TAPCELL_ROW_42_910 VGND VPWR sky130_fd_sc_hd__tapvpwrvgnd_1
X_10886_ _03352_ _03529_ VGND VGND VPWR VPWR _03531_ sky130_fd_sc_hd__nor2_1
X_13674_ clknet_3_2__leaf_clk _00022_ net712 VGND VGND VPWR VPWR net209 sky130_fd_sc_hd__dfrtp_1
XFILLER_16_477 VGND VGND VPWR VPWR sky130_fd_sc_hd__decap_6
X_12625_ _05114_ _05258_ _05259_ _05254_ VGND VGND VPWR VPWR _05425_ sky130_fd_sc_hd__a22oi_2
XFILLER_129_335 VGND VGND VPWR VPWR sky130_fd_sc_hd__fill_1
X_12556_ net648 net8 _05348_ _05349_ VGND VGND VPWR VPWR _05350_ sky130_fd_sc_hd__o2bb2a_1
XFILLER_12_672 VGND VGND VPWR VPWR sky130_fd_sc_hd__decap_6
XTAP_TAPCELL_ROW_61_1186 VGND VPWR sky130_fd_sc_hd__tapvpwrvgnd_1
X_11507_ _04083_ _04096_ _04095_ VGND VGND VPWR VPWR _04209_ sky130_fd_sc_hd__o21a_1
X_12487_ _04817_ _04987_ _05132_ _05136_ VGND VGND VPWR VPWR _05274_ sky130_fd_sc_hd__a31o_1
XFILLER_8_698 VGND VGND VPWR VPWR sky130_fd_sc_hd__fill_2
X_11438_ _04128_ _04133_ VGND VGND VPWR VPWR _04135_ sky130_fd_sc_hd__and2_1
XTAP_TAPCELL_ROW_117_1997 VGND VPWR sky130_fd_sc_hd__tapvpwrvgnd_1
X_11369_ _04056_ _04058_ VGND VGND VPWR VPWR _04059_ sky130_fd_sc_hd__or2_1
XFILLER_112_224 VPWR VGND VPWR VGND sky130_ef_sc_hd__decap_12
X_13108_ _05816_ _05819_ VGND VGND VPWR VPWR _05953_ sky130_fd_sc_hd__nor2_1
XFILLER_3_381 VGND VGND VPWR VPWR sky130_fd_sc_hd__fill_1
XFILLER_94_620 VGND VGND VPWR VPWR sky130_fd_sc_hd__fill_2
X_13039_ _05394_ _05726_ _05725_ VGND VGND VPWR VPWR _05878_ sky130_fd_sc_hd__a21oi_1
XFILLER_21_3 VPWR VGND VPWR VGND sky130_ef_sc_hd__decap_12
XFILLER_39_503 VGND VGND VPWR VPWR sky130_fd_sc_hd__fill_1
XFILLER_39_525 VPWR VGND VPWR VGND sky130_ef_sc_hd__decap_12
XTAP_TAPCELL_ROW_1_307 VGND VPWR sky130_fd_sc_hd__tapvpwrvgnd_1
XFILLER_39_558 VGND VGND VPWR VPWR sky130_fd_sc_hd__fill_2
X_08580_ _01046_ _01047_ VGND VGND VPWR VPWR _01048_ sky130_fd_sc_hd__or2_1
X_07600_ _01344_ net599 _06667_ _06665_ VGND VGND VPWR VPWR _00080_ sky130_fd_sc_hd__a31o_1
XTAP_TAPCELL_ROW_1_318 VGND VPWR sky130_fd_sc_hd__tapvpwrvgnd_1
XFILLER_54_539 VPWR VGND VPWR VGND sky130_ef_sc_hd__decap_12
X_07531_ net683 net504 _06626_ _06625_ VGND VGND VPWR VPWR _06760_ sky130_fd_sc_hd__a31o_1
XFILLER_19_293 VPWR VGND VPWR VGND sky130_ef_sc_hd__decap_12
XFILLER_50_701 VPWR VGND VPWR VGND sky130_ef_sc_hd__decap_12
X_07462_ net533 net600 VGND VGND VPWR VPWR _06692_ sky130_fd_sc_hd__nand2_1
XFILLER_50_723 VGND VGND VPWR VPWR sky130_fd_sc_hd__decap_4
XFILLER_22_414 VGND VGND VPWR VPWR sky130_fd_sc_hd__decap_6
XFILLER_35_797 VPWR VGND VPWR VGND sky130_ef_sc_hd__decap_12
X_09201_ _01694_ _01695_ VGND VGND VPWR VPWR _01696_ sky130_fd_sc_hd__nor2_1
X_07393_ _06138_ _06236_ _06225_ VGND VGND VPWR VPWR _06623_ sky130_fd_sc_hd__a21o_1
XFILLER_22_436 VPWR VGND VPWR VGND sky130_ef_sc_hd__decap_12
X_09132_ net608 net375 net374 net616 VGND VGND VPWR VPWR _01621_ sky130_fd_sc_hd__a22o_1
XFILLER_50_789 VPWR VGND VPWR VGND sky130_ef_sc_hd__decap_12
XFILLER_135_327 VGND VGND VPWR VPWR sky130_fd_sc_hd__decap_4
X_09063_ _01544_ _01545_ VGND VGND VPWR VPWR _01546_ sky130_fd_sc_hd__nand2_1
XFILLER_118_15 VPWR VGND VPWR VGND sky130_ef_sc_hd__decap_12
XTAP_TAPCELL_ROW_79_1447 VGND VPWR sky130_fd_sc_hd__tapvpwrvgnd_1
X_08014_ _00487_ _00490_ VGND VGND VPWR VPWR _00491_ sky130_fd_sc_hd__and2b_1
XFILLER_131_500 VGND VGND VPWR VPWR sky130_fd_sc_hd__decap_4
XFILLER_116_574 VPWR VGND VPWR VGND sky130_ef_sc_hd__decap_12
XTAP_TAPCELL_ROW_92_1636 VGND VPWR sky130_fd_sc_hd__tapvpwrvgnd_1
XTAP_TAPCELL_ROW_9_429 VGND VPWR sky130_fd_sc_hd__tapvpwrvgnd_1
XFILLER_104_725 VPWR VGND VPWR VGND sky130_ef_sc_hd__decap_12
XFILLER_131_555 VGND VGND VPWR VPWR sky130_fd_sc_hd__decap_4
X_09965_ net488 net479 net342 VGND VGND VPWR VPWR _02529_ sky130_fd_sc_hd__o21ai_1
XFILLER_104_769 VPWR VGND VPWR VGND sky130_ef_sc_hd__decap_12
X_08916_ net585 net355 VGND VGND VPWR VPWR _01385_ sky130_fd_sc_hd__nand2_1
X_09896_ _02449_ _02453_ _02450_ _02447_ VGND VGND VPWR VPWR _02454_ sky130_fd_sc_hd__o31a_1
XFILLER_103_279 VGND VGND VPWR VPWR sky130_fd_sc_hd__fill_1
X_08847_ net472 net332 _01163_ VGND VGND VPWR VPWR _01313_ sky130_fd_sc_hd__a21oi_1
XFILLER_94_29 VPWR VGND VPWR VGND sky130_ef_sc_hd__decap_12
XFILLER_69_193 VGND VGND VPWR VPWR sky130_fd_sc_hd__decap_4
XFILLER_57_366 VPWR VGND VPWR VGND sky130_ef_sc_hd__decap_12
XFILLER_45_517 VPWR VGND VPWR VGND sky130_ef_sc_hd__decap_12
XTAP_TAPCELL_ROW_28_704 VGND VPWR sky130_fd_sc_hd__tapvpwrvgnd_1
X_08778_ _01239_ _01244_ VGND VGND VPWR VPWR _00062_ sky130_fd_sc_hd__xor2_1
X_07729_ net672 _06801_ _06802_ _06803_ VGND VGND VPWR VPWR _00208_ sky130_fd_sc_hd__a2bb2o_1
X_10740_ _03369_ _03370_ VGND VGND VPWR VPWR _03371_ sky130_fd_sc_hd__xnor2_1
XFILLER_25_274 VGND VGND VPWR VPWR sky130_fd_sc_hd__decap_6
XFILLER_43_55 VGND VGND VPWR VPWR sky130_fd_sc_hd__fill_1
XFILLER_9_407 VGND VGND VPWR VPWR sky130_fd_sc_hd__decap_3
X_10671_ _03293_ _03294_ _03295_ VGND VGND VPWR VPWR _03296_ sky130_fd_sc_hd__nand3_1
XTAP_TAPCELL_ROW_101_1765 VGND VPWR sky130_fd_sc_hd__tapvpwrvgnd_1
X_12410_ _05187_ _05189_ _05190_ VGND VGND VPWR VPWR _05191_ sky130_fd_sc_hd__nand3_1
XFILLER_41_778 VGND VGND VPWR VPWR sky130_fd_sc_hd__decap_6
X_13390_ _06130_ _06132_ _06129_ VGND VGND VPWR VPWR _06261_ sky130_fd_sc_hd__o21ba_1
XFILLER_138_165 VGND VGND VPWR VPWR sky130_fd_sc_hd__decap_3
XTAP_TAPCELL_ROW_134_2242 VGND VPWR sky130_fd_sc_hd__tapvpwrvgnd_1
X_12341_ net480 net407 net406 net489 VGND VGND VPWR VPWR _05115_ sky130_fd_sc_hd__a22oi_1
XFILLER_5_602 VGND VGND VPWR VPWR sky130_fd_sc_hd__decap_8
XFILLER_119_390 VGND VGND VPWR VPWR sky130_fd_sc_hd__fill_2
X_12272_ _05037_ _05018_ _05039_ VGND VGND VPWR VPWR _05040_ sky130_fd_sc_hd__or3_4
X_11223_ _03743_ net249 _03747_ VGND VGND VPWR VPWR _03899_ sky130_fd_sc_hd__a21o_1
XFILLER_134_360 VGND VGND VPWR VPWR sky130_fd_sc_hd__decap_4
XFILLER_107_585 VPWR VGND VPWR VGND sky130_ef_sc_hd__decap_12
XFILLER_4_27 VGND VGND VPWR VPWR sky130_fd_sc_hd__fill_1
XFILLER_122_566 VGND VGND VPWR VPWR sky130_fd_sc_hd__decap_8
XFILLER_95_406 VGND VGND VPWR VPWR sky130_fd_sc_hd__decap_4
XFILLER_68_41 VPWR VGND VPWR VGND sky130_ef_sc_hd__decap_12
X_11154_ _03822_ _03823_ VGND VGND VPWR VPWR _03824_ sky130_fd_sc_hd__xnor2_1
X_10105_ _02444_ _02571_ _02454_ _02572_ VGND VGND VPWR VPWR _02682_ sky130_fd_sc_hd__o31a_1
XFILLER_68_85 VGND VGND VPWR VPWR sky130_fd_sc_hd__decap_4
X_11085_ _03742_ _03746_ VGND VGND VPWR VPWR _03748_ sky130_fd_sc_hd__xor2_1
X_10036_ _02511_ _02517_ _02516_ VGND VGND VPWR VPWR _02606_ sky130_fd_sc_hd__a21o_1
XFILLER_76_642 VGND VGND VPWR VPWR sky130_fd_sc_hd__fill_2
XFILLER_64_804 VGND VGND VPWR VPWR sky130_fd_sc_hd__decap_8
XFILLER_63_325 VGND VGND VPWR VPWR sky130_fd_sc_hd__decap_8
XFILLER_48_399 VPWR VGND VPWR VGND sky130_ef_sc_hd__decap_12
X_11987_ _04725_ _04726_ VGND VGND VPWR VPWR _04728_ sky130_fd_sc_hd__xnor2_1
XFILLER_16_230 VGND VGND VPWR VPWR sky130_fd_sc_hd__decap_6
XFILLER_90_188 VGND VGND VPWR VPWR sky130_fd_sc_hd__fill_1
XTAP_TAPCELL_ROW_63_1215 VGND VPWR sky130_fd_sc_hd__tapvpwrvgnd_1
X_10938_ _03566_ _03586_ VGND VGND VPWR VPWR _03588_ sky130_fd_sc_hd__nand2b_1
XFILLER_17_797 VPWR VGND VPWR VGND sky130_ef_sc_hd__decap_12
XFILLER_31_211 VGND VGND VPWR VPWR sky130_fd_sc_hd__fill_1
X_13657_ clknet_3_7__leaf_clk _00064_ net718 VGND VGND VPWR VPWR net192 sky130_fd_sc_hd__dfrtp_1
X_10869_ _03452_ _03512_ VGND VGND VPWR VPWR _03513_ sky130_fd_sc_hd__or2_1
X_12608_ net266 net695 _05226_ VGND VGND VPWR VPWR _05407_ sky130_fd_sc_hd__or3_1
X_13588_ _06474_ _06475_ VGND VGND VPWR VPWR _06477_ sky130_fd_sc_hd__nand2b_1
XTAP_TAPCELL_ROW_14_497 VGND VPWR sky130_fd_sc_hd__tapvpwrvgnd_1
X_12539_ _05327_ _05328_ _05329_ VGND VGND VPWR VPWR _05332_ sky130_fd_sc_hd__a21oi_1
XFILLER_133_809 VPWR VGND VPWR VGND sky130_ef_sc_hd__decap_12
XFILLER_129_187 VPWR VGND VPWR VGND sky130_ef_sc_hd__decap_12
XFILLER_125_393 VGND VGND VPWR VPWR sky130_fd_sc_hd__decap_4
Xfanout419 net421 VGND VGND VPWR VPWR net419 sky130_fd_sc_hd__clkbuf_2
Xfanout408 net17 VGND VGND VPWR VPWR net408 sky130_fd_sc_hd__clkbuf_4
XFILLER_98_244 VGND VGND VPWR VPWR sky130_fd_sc_hd__decap_8
XTAP_TAPCELL_ROW_74_1377 VGND VPWR sky130_fd_sc_hd__tapvpwrvgnd_1
XTAP_TAPCELL_ROW_74_1366 VGND VPWR sky130_fd_sc_hd__tapvpwrvgnd_1
X_09750_ _02294_ _02295_ VGND VGND VPWR VPWR _02296_ sky130_fd_sc_hd__or2_1
X_06962_ net114 net494 VGND VGND VPWR VPWR _02920_ sky130_fd_sc_hd__nand2_1
X_09681_ _02219_ _02187_ VGND VGND VPWR VPWR _02220_ sky130_fd_sc_hd__and2b_1
X_08701_ net657 net372 net373 net646 VGND VGND VPWR VPWR _01168_ sky130_fd_sc_hd__a22o_1
XFILLER_67_653 VPWR VGND VPWR VGND sky130_ef_sc_hd__decap_12
XFILLER_39_344 VGND VGND VPWR VPWR sky130_fd_sc_hd__fill_2
X_08632_ net575 net363 _01096_ _01097_ VGND VGND VPWR VPWR _01099_ sky130_fd_sc_hd__o2bb2a_1
X_06893_ _01736_ _02162_ VGND VGND VPWR VPWR _02173_ sky130_fd_sc_hd__xor2_1
XFILLER_82_645 VGND VGND VPWR VPWR sky130_fd_sc_hd__fill_1
XFILLER_81_111 VGND VGND VPWR VPWR sky130_fd_sc_hd__fill_1
XFILLER_67_697 VPWR VGND VPWR VGND sky130_ef_sc_hd__decap_12
X_08563_ net639 net378 VGND VGND VPWR VPWR _01031_ sky130_fd_sc_hd__nand2_1
XFILLER_120_27 VGND VGND VPWR VPWR sky130_fd_sc_hd__fill_1
XFILLER_81_188 VPWR VGND VPWR VGND sky130_ef_sc_hd__decap_12
XFILLER_23_723 VGND VGND VPWR VPWR sky130_fd_sc_hd__decap_4
XFILLER_35_561 VGND VGND VPWR VPWR sky130_fd_sc_hd__decap_6
X_08494_ _00891_ _00894_ _00962_ _00963_ VGND VGND VPWR VPWR _00966_ sky130_fd_sc_hd__a31o_1
X_07514_ _06741_ _06742_ VGND VGND VPWR VPWR _06743_ sky130_fd_sc_hd__or2_1
XFILLER_62_391 VPWR VGND VPWR VGND sky130_ef_sc_hd__decap_12
X_07445_ _06528_ _06674_ VGND VGND VPWR VPWR _06675_ sky130_fd_sc_hd__nor2_1
XFILLER_22_233 VGND VGND VPWR VPWR sky130_fd_sc_hd__decap_3
XTAP_TAPCELL_ROW_33_773 VGND VPWR sky130_fd_sc_hd__tapvpwrvgnd_1
X_07376_ _06604_ _06605_ VGND VGND VPWR VPWR _06606_ sky130_fd_sc_hd__or2_1
XTAP_TAPCELL_ROW_33_784 VGND VPWR sky130_fd_sc_hd__tapvpwrvgnd_1
XFILLER_136_625 VGND VGND VPWR VPWR sky130_fd_sc_hd__fill_1
X_09115_ _01588_ _01600_ _01601_ VGND VGND VPWR VPWR _01602_ sky130_fd_sc_hd__nand3_1
XPHY_EDGE_ROW_70_Left_209 VGND VGND VPWR VPWR sky130_fd_sc_hd__decap_3
XFILLER_13_69 VGND VGND VPWR VPWR sky130_fd_sc_hd__decap_8
XFILLER_135_113 VPWR VGND VPWR VGND sky130_ef_sc_hd__decap_12
X_09046_ _01525_ _01526_ VGND VGND VPWR VPWR _01527_ sky130_fd_sc_hd__xnor2_1
XFILLER_129_69 VPWR VGND VPWR VGND sky130_ef_sc_hd__decap_12
XFILLER_89_211 VGND VGND VPWR VPWR sky130_fd_sc_hd__fill_2
XFILLER_2_638 VGND VGND VPWR VPWR sky130_fd_sc_hd__decap_6
XFILLER_131_330 VGND VGND VPWR VPWR sky130_fd_sc_hd__decap_6
XFILLER_89_233 VGND VGND VPWR VPWR sky130_fd_sc_hd__fill_2
XFILLER_1_137 VGND VGND VPWR VPWR sky130_fd_sc_hd__decap_6
X_09948_ _02261_ _02418_ _02122_ VGND VGND VPWR VPWR _02511_ sky130_fd_sc_hd__o21bai_1
X_09879_ _02323_ _02435_ VGND VGND VPWR VPWR _02436_ sky130_fd_sc_hd__nand2_1
XFILLER_58_653 VGND VGND VPWR VPWR sky130_fd_sc_hd__fill_1
XFILLER_38_77 VGND VGND VPWR VPWR sky130_fd_sc_hd__decap_6
X_12890_ _05488_ _05547_ _05546_ VGND VGND VPWR VPWR _05715_ sky130_fd_sc_hd__o21ba_1
XFILLER_58_697 VGND VGND VPWR VPWR sky130_fd_sc_hd__decap_3
X_11910_ _04545_ _04549_ _04556_ VGND VGND VPWR VPWR _04648_ sky130_fd_sc_hd__a21oi_1
X_11841_ _04561_ _04571_ VGND VGND VPWR VPWR _04573_ sky130_fd_sc_hd__xor2_1
XFILLER_54_65 VPWR VGND VPWR VGND sky130_ef_sc_hd__decap_12
X_11772_ net532 net535 net299 VGND VGND VPWR VPWR _04498_ sky130_fd_sc_hd__mux2_1
XFILLER_14_701 VGND VGND VPWR VPWR sky130_fd_sc_hd__decap_8
XFILLER_26_583 VGND VGND VPWR VPWR sky130_fd_sc_hd__fill_1
X_13511_ _06213_ _06283_ _06281_ VGND VGND VPWR VPWR _06393_ sky130_fd_sc_hd__a21oi_1
XFILLER_60_339 VPWR VGND VPWR VGND sky130_ef_sc_hd__decap_12
XFILLER_13_222 VGND VGND VPWR VPWR sky130_fd_sc_hd__fill_2
X_10723_ _03350_ _03351_ _03196_ _03198_ VGND VGND VPWR VPWR _03353_ sky130_fd_sc_hd__o211ai_1
XPHY_EDGE_ROW_109_Left_248 VGND VGND VPWR VPWR sky130_fd_sc_hd__decap_3
X_13442_ _06315_ _06316_ VGND VGND VPWR VPWR _06317_ sky130_fd_sc_hd__xnor2_1
XFILLER_70_53 VPWR VGND VPWR VGND sky130_ef_sc_hd__decap_12
XFILLER_9_237 VGND VGND VPWR VPWR sky130_fd_sc_hd__decap_4
XFILLER_13_277 VGND VGND VPWR VPWR sky130_fd_sc_hd__decap_3
X_10654_ _03148_ _03275_ VGND VGND VPWR VPWR _03277_ sky130_fd_sc_hd__xnor2_1
X_13373_ _06240_ _06241_ VGND VGND VPWR VPWR _06242_ sky130_fd_sc_hd__and2_1
XTAP_TAPCELL_ROW_11_456 VGND VPWR sky130_fd_sc_hd__tapvpwrvgnd_1
X_10585_ _03198_ _03199_ _03201_ VGND VGND VPWR VPWR _03202_ sky130_fd_sc_hd__nand3_1
X_12324_ _05094_ _05095_ VGND VGND VPWR VPWR _05096_ sky130_fd_sc_hd__xnor2_1
XFILLER_126_157 VGND VGND VPWR VPWR sky130_fd_sc_hd__fill_2
XTAP_TAPCELL_ROW_114_1956 VGND VPWR sky130_fd_sc_hd__tapvpwrvgnd_1
XTAP_TAPCELL_ROW_114_1945 VGND VPWR sky130_fd_sc_hd__tapvpwrvgnd_1
X_12255_ net624 net386 net4 net634 VGND VGND VPWR VPWR _05021_ sky130_fd_sc_hd__a22o_1
XFILLER_107_393 VGND VGND VPWR VPWR sky130_fd_sc_hd__fill_1
X_12186_ net550 net711 VGND VGND VPWR VPWR _04945_ sky130_fd_sc_hd__nand2_1
X_11206_ net560 net552 net299 VGND VGND VPWR VPWR _03880_ sky130_fd_sc_hd__and3_1
XPHY_EDGE_ROW_118_Left_257 VGND VGND VPWR VPWR sky130_fd_sc_hd__decap_3
XFILLER_95_214 VGND VGND VPWR VPWR sky130_fd_sc_hd__decap_8
XFILLER_68_406 VPWR VGND VPWR VGND sky130_ef_sc_hd__decap_12
XFILLER_1_671 VGND VGND VPWR VPWR sky130_fd_sc_hd__fill_1
X_11137_ _03803_ _03804_ VGND VGND VPWR VPWR _03805_ sky130_fd_sc_hd__nand2b_1
XFILLER_95_225 VGND VGND VPWR VPWR sky130_fd_sc_hd__fill_2
XFILLER_0_181 VGND VGND VPWR VPWR sky130_fd_sc_hd__decap_4
XFILLER_64_601 VPWR VGND VPWR VGND sky130_ef_sc_hd__decap_12
XFILLER_49_653 VGND VGND VPWR VPWR sky130_fd_sc_hd__fill_1
XFILLER_48_141 VGND VGND VPWR VPWR sky130_fd_sc_hd__decap_4
X_11068_ _03727_ _03728_ VGND VGND VPWR VPWR _03730_ sky130_fd_sc_hd__nor2_1
X_10019_ _02582_ _02587_ _02585_ VGND VGND VPWR VPWR _02588_ sky130_fd_sc_hd__a21oi_1
XFILLER_64_645 VGND VGND VPWR VPWR sky130_fd_sc_hd__fill_2
XFILLER_49_697 VGND VGND VPWR VPWR sky130_fd_sc_hd__decap_4
XFILLER_49_686 VGND VGND VPWR VPWR sky130_fd_sc_hd__fill_1
XFILLER_48_174 VPWR VGND VPWR VGND sky130_ef_sc_hd__decap_12
XFILLER_17_561 VGND VGND VPWR VPWR sky130_fd_sc_hd__decap_3
XTAP_TAPCELL_ROW_19_578 VGND VPWR sky130_fd_sc_hd__tapvpwrvgnd_1
XPHY_EDGE_ROW_127_Left_266 VGND VGND VPWR VPWR sky130_fd_sc_hd__decap_3
XFILLER_17_594 VPWR VGND VPWR VGND sky130_ef_sc_hd__decap_12
XFILLER_32_531 VGND VGND VPWR VPWR sky130_fd_sc_hd__fill_1
XFILLER_20_704 VGND VGND VPWR VPWR sky130_fd_sc_hd__decap_8
XFILLER_32_564 VGND VGND VPWR VPWR sky130_fd_sc_hd__fill_2
X_07230_ _05810_ _05821_ VGND VGND VPWR VPWR _05843_ sky130_fd_sc_hd__xor2_1
XFILLER_32_586 VGND VGND VPWR VPWR sky130_fd_sc_hd__fill_2
X_07161_ net650 net642 net708 net706 VGND VGND VPWR VPWR _05089_ sky130_fd_sc_hd__and4_1
XTAP_TAPCELL_ROW_30_732 VGND VPWR sky130_fd_sc_hd__tapvpwrvgnd_1
XFILLER_117_102 VGND VGND VPWR VPWR sky130_fd_sc_hd__decap_3
XTAP_TAPCELL_ROW_76_1406 VGND VPWR sky130_fd_sc_hd__tapvpwrvgnd_1
X_07092_ _02586_ _04318_ VGND VGND VPWR VPWR _04340_ sky130_fd_sc_hd__or2_1
XPHY_EDGE_ROW_136_Left_275 VGND VGND VPWR VPWR sky130_fd_sc_hd__decap_3
XFILLER_117_179 VGND VGND VPWR VPWR sky130_fd_sc_hd__fill_2
XFILLER_5_81 VPWR VGND VPWR VGND sky130_ef_sc_hd__decap_12
X_09802_ _02350_ _02351_ VGND VGND VPWR VPWR _02352_ sky130_fd_sc_hd__or2_1
XFILLER_115_27 VPWR VGND VPWR VGND sky130_ef_sc_hd__decap_12
XFILLER_113_374 VGND VGND VPWR VPWR sky130_fd_sc_hd__fill_1
XFILLER_99_575 VPWR VGND VPWR VGND sky130_ef_sc_hd__decap_12
XFILLER_59_406 VPWR VGND VPWR VGND sky130_ef_sc_hd__decap_12
XFILLER_101_558 VGND VGND VPWR VPWR sky130_fd_sc_hd__fill_2
XFILLER_101_547 VGND VGND VPWR VPWR sky130_fd_sc_hd__decap_4
X_07994_ _00365_ _00381_ _00380_ VGND VGND VPWR VPWR _00471_ sky130_fd_sc_hd__a21bo_1
Xfanout249 _03745_ VGND VGND VPWR VPWR net249 sky130_fd_sc_hd__clkbuf_4
X_09733_ _02275_ _02276_ VGND VGND VPWR VPWR _02277_ sky130_fd_sc_hd__xnor2_2
X_06945_ _02717_ _02728_ VGND VGND VPWR VPWR _02739_ sky130_fd_sc_hd__nor2_1
XFILLER_39_141 VPWR VGND VPWR VGND sky130_ef_sc_hd__decap_12
X_09664_ _02042_ _02046_ _02200_ VGND VGND VPWR VPWR _02201_ sky130_fd_sc_hd__o21a_1
XFILLER_131_15 VPWR VGND VPWR VGND sky130_ef_sc_hd__decap_12
XFILLER_95_781 VGND VGND VPWR VPWR sky130_fd_sc_hd__decap_3
X_06876_ _01605_ _01976_ VGND VGND VPWR VPWR _01987_ sky130_fd_sc_hd__and2_1
XFILLER_27_303 VGND VGND VPWR VPWR sky130_fd_sc_hd__fill_1
X_08615_ net524 net348 VGND VGND VPWR VPWR _01082_ sky130_fd_sc_hd__nand2_1
X_09595_ _02110_ _02124_ VGND VGND VPWR VPWR _02126_ sky130_fd_sc_hd__xnor2_2
XTAP_TAPCELL_ROW_87_1557 VGND VPWR sky130_fd_sc_hd__tapvpwrvgnd_1
XFILLER_55_645 VGND VGND VPWR VPWR sky130_fd_sc_hd__fill_1
XTAP_TAPCELL_ROW_38_843 VGND VPWR sky130_fd_sc_hd__tapvpwrvgnd_1
XTAP_TAPCELL_ROW_38_854 VGND VPWR sky130_fd_sc_hd__tapvpwrvgnd_1
XFILLER_55_689 VPWR VGND VPWR VGND sky130_ef_sc_hd__decap_12
X_08546_ _01013_ _01014_ VGND VGND VPWR VPWR _01015_ sky130_fd_sc_hd__nor2_1
X_08477_ _00946_ _00947_ VGND VGND VPWR VPWR _00950_ sky130_fd_sc_hd__xnor2_1
XTAP_TAPCELL_ROW_118_2012 VGND VPWR sky130_fd_sc_hd__tapvpwrvgnd_1
X_07428_ net466 net661 VGND VGND VPWR VPWR _06658_ sky130_fd_sc_hd__and2_4
XFILLER_10_258 VGND VGND VPWR VPWR sky130_fd_sc_hd__decap_6
X_07359_ net591 net688 VGND VGND VPWR VPWR _06589_ sky130_fd_sc_hd__nand2_1
XFILLER_108_113 VPWR VGND VPWR VGND sky130_ef_sc_hd__decap_12
XFILLER_108_102 VGND VGND VPWR VPWR sky130_fd_sc_hd__decap_6
XFILLER_6_218 VGND VGND VPWR VPWR sky130_fd_sc_hd__fill_1
XTAP_TAPCELL_ROW_131_2201 VGND VPWR sky130_fd_sc_hd__tapvpwrvgnd_1
XFILLER_124_617 VGND VGND VPWR VPWR sky130_fd_sc_hd__fill_1
X_10370_ _02962_ _02966_ VGND VGND VPWR VPWR _02967_ sky130_fd_sc_hd__xnor2_1
X_09029_ _01507_ _01506_ _01353_ _01356_ VGND VGND VPWR VPWR _01510_ sky130_fd_sc_hd__a211o_1
XFILLER_124_628 VPWR VGND VPWR VGND sky130_ef_sc_hd__decap_12
XFILLER_123_105 VGND VGND VPWR VPWR sky130_fd_sc_hd__decap_6
X_12040_ _04779_ _04785_ VGND VGND VPWR VPWR _04786_ sky130_fd_sc_hd__and2_1
XFILLER_104_352 VGND VGND VPWR VPWR sky130_fd_sc_hd__decap_6
XFILLER_78_748 VGND VGND VPWR VPWR sky130_fd_sc_hd__decap_3
XFILLER_77_247 VPWR VGND VPWR VGND sky130_ef_sc_hd__decap_12
XFILLER_77_225 VGND VGND VPWR VPWR sky130_fd_sc_hd__decap_4
XTAP_TAPCELL_ROW_129_2174 VGND VPWR sky130_fd_sc_hd__tapvpwrvgnd_1
XTAP_TAPCELL_ROW_129_2163 VGND VPWR sky130_fd_sc_hd__tapvpwrvgnd_1
XFILLER_93_729 VGND VGND VPWR VPWR sky130_fd_sc_hd__decap_6
XFILLER_65_409 VGND VGND VPWR VPWR sky130_fd_sc_hd__decap_8
XFILLER_46_601 VPWR VGND VPWR VGND sky130_ef_sc_hd__decap_12
X_12942_ _05769_ _05770_ VGND VGND VPWR VPWR _05771_ sky130_fd_sc_hd__or2_1
XFILLER_92_217 VGND VGND VPWR VPWR sky130_fd_sc_hd__fill_1
XFILLER_65_31 VPWR VGND VPWR VGND sky130_ef_sc_hd__decap_12
XFILLER_58_494 VPWR VGND VPWR VGND sky130_ef_sc_hd__decap_12
XFILLER_45_111 VGND VGND VPWR VPWR sky130_fd_sc_hd__fill_1
XFILLER_1_39 VPWR VGND VPWR VGND sky130_ef_sc_hd__decap_12
X_12873_ net637 _05528_ VGND VGND VPWR VPWR _05696_ sky130_fd_sc_hd__nand2_1
XFILLER_65_86 VPWR VGND VPWR VGND sky130_ef_sc_hd__decap_12
XFILLER_45_177 VGND VGND VPWR VPWR sky130_fd_sc_hd__fill_2
XFILLER_73_497 VGND VGND VPWR VPWR sky130_fd_sc_hd__decap_6
XTAP_TAPCELL_ROW_16_526 VGND VPWR sky130_fd_sc_hd__tapvpwrvgnd_1
XTAP_TAPCELL_ROW_16_537 VGND VPWR sky130_fd_sc_hd__tapvpwrvgnd_1
X_11824_ _04452_ _04553_ VGND VGND VPWR VPWR _04554_ sky130_fd_sc_hd__xnor2_1
X_11755_ _04476_ _04477_ VGND VGND VPWR VPWR _04479_ sky130_fd_sc_hd__and2b_1
XFILLER_14_586 VGND VGND VPWR VPWR sky130_fd_sc_hd__fill_2
X_10706_ _03331_ _03332_ _03174_ _03176_ VGND VGND VPWR VPWR _03334_ sky130_fd_sc_hd__o211ai_2
XFILLER_127_400 VPWR VGND VPWR VGND sky130_ef_sc_hd__decap_12
X_13425_ _06297_ _06298_ VGND VGND VPWR VPWR _00030_ sky130_fd_sc_hd__xnor2_1
XFILLER_14_90 VPWR VGND VPWR VGND sky130_ef_sc_hd__decap_12
X_11686_ _04390_ _04403_ VGND VGND VPWR VPWR _04404_ sky130_fd_sc_hd__xnor2_1
XFILLER_10_781 VPWR VGND VPWR VGND sky130_ef_sc_hd__decap_12
X_10637_ _03254_ _03256_ _03257_ VGND VGND VPWR VPWR _03258_ sky130_fd_sc_hd__nand3b_1
XFILLER_127_455 VGND VGND VPWR VPWR sky130_fd_sc_hd__fill_1
XPHY_EDGE_ROW_116_Right_116 VGND VGND VPWR VPWR sky130_fd_sc_hd__decap_3
XFILLER_115_617 VPWR VGND VPWR VGND sky130_ef_sc_hd__decap_12
X_13356_ _06221_ _06222_ VGND VGND VPWR VPWR _06223_ sky130_fd_sc_hd__nor2_1
X_10568_ _03023_ _03026_ _03181_ _03182_ VGND VGND VPWR VPWR _03184_ sky130_fd_sc_hd__a211oi_2
XFILLER_127_477 VGND VGND VPWR VPWR sky130_fd_sc_hd__fill_1
XFILLER_114_105 VGND VGND VPWR VPWR sky130_fd_sc_hd__decap_4
XFILLER_108_680 VGND VGND VPWR VPWR sky130_fd_sc_hd__decap_8
X_12307_ net550 net695 VGND VGND VPWR VPWR _05077_ sky130_fd_sc_hd__nand2_1
X_13287_ _06146_ _06147_ VGND VGND VPWR VPWR _06148_ sky130_fd_sc_hd__nor2_1
XTAP_TAPCELL_ROW_58_1147 VGND VPWR sky130_fd_sc_hd__tapvpwrvgnd_1
XTAP_TAPCELL_ROW_58_1136 VGND VPWR sky130_fd_sc_hd__tapvpwrvgnd_1
X_10499_ net485 net298 VGND VGND VPWR VPWR _03108_ sky130_fd_sc_hd__nand2_1
X_12238_ net462 net454 net384 net29 VGND VGND VPWR VPWR _05003_ sky130_fd_sc_hd__and4_1
XTAP_TAPCELL_ROW_71_1325 VGND VPWR sky130_fd_sc_hd__tapvpwrvgnd_1
X_12169_ _04925_ _04927_ VGND VGND VPWR VPWR _04928_ sky130_fd_sc_hd__nand2b_1
XFILLER_77_770 VGND VGND VPWR VPWR sky130_fd_sc_hd__fill_1
Xinput5 w00[3] VGND VGND VPWR VPWR net5 sky130_fd_sc_hd__buf_2
XFILLER_49_461 VPWR VGND VPWR VGND sky130_ef_sc_hd__decap_12
XFILLER_37_634 VGND VGND VPWR VPWR sky130_fd_sc_hd__fill_2
XFILLER_36_133 VGND VGND VPWR VPWR sky130_fd_sc_hd__decap_6
XFILLER_52_615 VPWR VGND VPWR VGND sky130_ef_sc_hd__decap_12
X_08400_ _00871_ _00872_ _00859_ VGND VGND VPWR VPWR _00874_ sky130_fd_sc_hd__o21ai_1
XTAP_TAPCELL_ROW_35_802 VGND VPWR sky130_fd_sc_hd__tapvpwrvgnd_1
XTAP_TAPCELL_ROW_35_813 VGND VPWR sky130_fd_sc_hd__tapvpwrvgnd_1
XFILLER_36_166 VPWR VGND VPWR VGND sky130_ef_sc_hd__decap_12
XFILLER_37_678 VGND VGND VPWR VPWR sky130_fd_sc_hd__decap_4
X_09380_ _01748_ _01750_ _01746_ VGND VGND VPWR VPWR _01892_ sky130_fd_sc_hd__a21o_1
XFILLER_101_18 VPWR VGND VPWR VGND sky130_ef_sc_hd__decap_12
XTAP_TAPCELL_ROW_69_1298 VGND VPWR sky130_fd_sc_hd__tapvpwrvgnd_1
XFILLER_64_497 VGND VGND VPWR VPWR sky130_fd_sc_hd__fill_2
XFILLER_51_136 VPWR VGND VPWR VGND sky130_ef_sc_hd__decap_12
XFILLER_17_391 VGND VGND VPWR VPWR sky130_fd_sc_hd__fill_1
X_08331_ _00726_ _00804_ VGND VGND VPWR VPWR _00805_ sky130_fd_sc_hd__nor2_1
XFILLER_51_169 VGND VGND VPWR VPWR sky130_fd_sc_hd__decap_6
XTAP_TAPCELL_ROW_82_1487 VGND VPWR sky130_fd_sc_hd__tapvpwrvgnd_1
X_08262_ _00625_ _00638_ _00736_ VGND VGND VPWR VPWR _00737_ sky130_fd_sc_hd__o21ai_1
X_07213_ _05646_ _05635_ VGND VGND VPWR VPWR _05657_ sky130_fd_sc_hd__nand2b_1
XFILLER_118_411 VGND VGND VPWR VPWR sky130_fd_sc_hd__decap_8
X_08193_ _00433_ _00548_ _00547_ VGND VGND VPWR VPWR _00669_ sky130_fd_sc_hd__a21oi_2
XFILLER_20_589 VPWR VGND VPWR VGND sky130_ef_sc_hd__decap_12
XFILLER_118_444 VPWR VGND VPWR VGND sky130_ef_sc_hd__decap_12
X_07144_ _04871_ _04882_ _04860_ VGND VGND VPWR VPWR _04904_ sky130_fd_sc_hd__o21ai_1
XFILLER_118_477 VGND VGND VPWR VPWR sky130_fd_sc_hd__decap_8
XFILLER_106_639 VGND VGND VPWR VPWR sky130_fd_sc_hd__fill_1
X_07075_ _02238_ _02347_ net236 _04145_ VGND VGND VPWR VPWR _04156_ sky130_fd_sc_hd__a211o_2
XFILLER_10_15 VPWR VGND VPWR VGND sky130_ef_sc_hd__decap_12
XFILLER_126_15 VPWR VGND VPWR VGND sky130_ef_sc_hd__decap_12
XFILLER_87_512 VGND VGND VPWR VPWR sky130_fd_sc_hd__decap_8
XFILLER_86_19 VGND VGND VPWR VPWR sky130_fd_sc_hd__decap_8
XFILLER_59_225 VGND VGND VPWR VPWR sky130_fd_sc_hd__decap_4
XFILLER_87_567 VGND VGND VPWR VPWR sky130_fd_sc_hd__fill_1
X_07977_ _00453_ _00174_ VGND VGND VPWR VPWR _00454_ sky130_fd_sc_hd__nand2b_1
X_09716_ _02115_ _02123_ _02122_ VGND VGND VPWR VPWR _02258_ sky130_fd_sc_hd__a21o_1
XFILLER_101_388 VGND VGND VPWR VPWR sky130_fd_sc_hd__decap_4
XFILLER_68_781 VPWR VGND VPWR VGND sky130_ef_sc_hd__decap_12
X_06928_ _02532_ _02543_ VGND VGND VPWR VPWR _02554_ sky130_fd_sc_hd__and2_1
XFILLER_19_57 VGND VGND VPWR VPWR sky130_fd_sc_hd__decap_6
XFILLER_28_623 VPWR VGND VPWR VGND sky130_ef_sc_hd__decap_12
XFILLER_83_751 VPWR VGND VPWR VGND sky130_ef_sc_hd__decap_12
XFILLER_55_420 VGND VGND VPWR VPWR sky130_fd_sc_hd__decap_6
XFILLER_28_645 VGND VGND VPWR VPWR sky130_fd_sc_hd__decap_8
X_09647_ _02070_ _02072_ _02181_ VGND VGND VPWR VPWR _02182_ sky130_fd_sc_hd__a21oi_1
X_06859_ _01529_ _01791_ VGND VGND VPWR VPWR _01802_ sky130_fd_sc_hd__or2_1
XFILLER_55_475 VGND VGND VPWR VPWR sky130_fd_sc_hd__fill_1
XTAP_TAPCELL_ROW_124_2093 VGND VPWR sky130_fd_sc_hd__tapvpwrvgnd_1
X_09578_ _02075_ _02106_ VGND VGND VPWR VPWR _02108_ sky130_fd_sc_hd__xor2_2
XFILLER_27_188 VPWR VGND VPWR VGND sky130_ef_sc_hd__decap_12
X_08529_ net471 net657 net377 net341 VGND VGND VPWR VPWR _00999_ sky130_fd_sc_hd__and4_1
XFILLER_30_309 VGND VGND VPWR VPWR sky130_fd_sc_hd__decap_8
XFILLER_11_512 VGND VGND VPWR VPWR sky130_fd_sc_hd__decap_4
XFILLER_11_523 VGND VGND VPWR VPWR sky130_fd_sc_hd__decap_8
X_11540_ _04242_ _04243_ VGND VGND VPWR VPWR _04245_ sky130_fd_sc_hd__nor2_1
XFILLER_136_3 VPWR VGND VPWR VGND sky130_ef_sc_hd__decap_12
XFILLER_50_180 VGND VGND VPWR VPWR sky130_fd_sc_hd__fill_2
XFILLER_11_567 VPWR VGND VPWR VGND sky130_ef_sc_hd__decap_12
XFILLER_51_77 VGND VGND VPWR VPWR sky130_fd_sc_hd__fill_2
XFILLER_51_55 VGND VGND VPWR VPWR sky130_fd_sc_hd__fill_1
X_11471_ _04168_ _04169_ VGND VGND VPWR VPWR _04170_ sky130_fd_sc_hd__and2b_1
XFILLER_137_753 VPWR VGND VPWR VGND sky130_ef_sc_hd__decap_12
XFILLER_136_230 VGND VGND VPWR VPWR sky130_fd_sc_hd__fill_1
XFILLER_109_444 VGND VGND VPWR VPWR sky130_fd_sc_hd__decap_4
X_13210_ _05920_ _05922_ _06063_ VGND VGND VPWR VPWR _06064_ sky130_fd_sc_hd__a21oi_1
X_10422_ _03013_ _03014_ _03021_ VGND VGND VPWR VPWR _03024_ sky130_fd_sc_hd__a21oi_1
XFILLER_137_797 VPWR VGND VPWR VGND sky130_ef_sc_hd__decap_12
X_13141_ _05844_ _05988_ VGND VGND VPWR VPWR _05989_ sky130_fd_sc_hd__xnor2_1
X_10353_ _02890_ _02946_ VGND VGND VPWR VPWR _02948_ sky130_fd_sc_hd__nor2_1
XFILLER_136_296 VGND VGND VPWR VPWR sky130_fd_sc_hd__fill_2
XTAP_TAPCELL_ROW_111_1904 VGND VPWR sky130_fd_sc_hd__tapvpwrvgnd_1
X_13072_ _05785_ _05794_ _05793_ VGND VGND VPWR VPWR _05913_ sky130_fd_sc_hd__a21bo_1
XTAP_TAPCELL_ROW_111_1915 VGND VPWR sky130_fd_sc_hd__tapvpwrvgnd_1
X_12023_ _04757_ _04765_ VGND VGND VPWR VPWR _04767_ sky130_fd_sc_hd__nand2_1
X_10284_ net569 net313 _02871_ _02872_ VGND VGND VPWR VPWR _02873_ sky130_fd_sc_hd__and4_1
XFILLER_3_777 VGND VGND VPWR VPWR sky130_fd_sc_hd__decap_6
XFILLER_104_193 VGND VGND VPWR VPWR sky130_fd_sc_hd__decap_3
XFILLER_76_41 VPWR VGND VPWR VGND sky130_ef_sc_hd__decap_12
XTAP_TAPCELL_ROW_53_1066 VGND VPWR sky130_fd_sc_hd__tapvpwrvgnd_1
XFILLER_78_589 VPWR VGND VPWR VGND sky130_ef_sc_hd__decap_12
Xfanout591 net592 VGND VGND VPWR VPWR net591 sky130_fd_sc_hd__clkbuf_2
Xfanout580 net581 VGND VGND VPWR VPWR net580 sky130_fd_sc_hd__buf_2
XFILLER_93_559 VGND VGND VPWR VPWR sky130_fd_sc_hd__fill_1
XFILLER_65_239 VGND VGND VPWR VPWR sky130_fd_sc_hd__fill_1
XFILLER_18_133 VGND VGND VPWR VPWR sky130_fd_sc_hd__fill_1
XTAP_TAPCELL_ROW_109_1877 VGND VPWR sky130_fd_sc_hd__tapvpwrvgnd_1
X_12925_ _05750_ _05751_ VGND VGND VPWR VPWR _05752_ sky130_fd_sc_hd__nor2_1
XFILLER_74_784 VGND VGND VPWR VPWR sky130_fd_sc_hd__fill_2
XFILLER_46_475 VGND VGND VPWR VPWR sky130_fd_sc_hd__fill_1
XFILLER_18_166 VGND VGND VPWR VPWR sky130_fd_sc_hd__decap_4
X_12856_ _05660_ _05676_ VGND VGND VPWR VPWR _05677_ sky130_fd_sc_hd__xor2_1
XFILLER_61_445 VGND VGND VPWR VPWR sky130_fd_sc_hd__decap_3
XFILLER_61_423 VGND VGND VPWR VPWR sky130_fd_sc_hd__decap_8
XFILLER_61_467 VPWR VGND VPWR VGND sky130_ef_sc_hd__decap_12
X_11807_ _04533_ _04534_ VGND VGND VPWR VPWR _04536_ sky130_fd_sc_hd__xor2_1
X_12787_ net572 net409 VGND VGND VPWR VPWR _05601_ sky130_fd_sc_hd__and2_1
X_11738_ _04364_ _04375_ _04363_ VGND VGND VPWR VPWR _04461_ sky130_fd_sc_hd__o21a_1
X_11669_ net257 net288 VGND VGND VPWR VPWR _04386_ sky130_fd_sc_hd__nor2_1
X_13408_ _06278_ _06279_ VGND VGND VPWR VPWR _06281_ sky130_fd_sc_hd__nor2_1
XTAP_TAPCELL_ROW_40_882 VGND VPWR sky130_fd_sc_hd__tapvpwrvgnd_1
X_13339_ _06059_ _06062_ _06204_ VGND VGND VPWR VPWR _06205_ sky130_fd_sc_hd__a21oi_1
XFILLER_103_609 VGND VGND VPWR VPWR sky130_fd_sc_hd__decap_6
XFILLER_88_309 VGND VGND VPWR VPWR sky130_fd_sc_hd__decap_8
X_08880_ _01210_ _01212_ _01345_ _01346_ VGND VGND VPWR VPWR _01347_ sky130_fd_sc_hd__o211a_4
X_07900_ _00372_ _00376_ VGND VGND VPWR VPWR _00378_ sky130_fd_sc_hd__xnor2_1
XFILLER_111_664 VGND VGND VPWR VPWR sky130_fd_sc_hd__decap_4
XFILLER_110_141 VPWR VGND VPWR VGND sky130_ef_sc_hd__decap_12
X_07831_ net693 net535 net264 net697 VGND VGND VPWR VPWR _00309_ sky130_fd_sc_hd__o2bb2a_1
XFILLER_96_397 VPWR VGND VPWR VGND sky130_ef_sc_hd__decap_12
XFILLER_57_729 VPWR VGND VPWR VGND sky130_ef_sc_hd__decap_12
X_09501_ _02022_ _02023_ VGND VGND VPWR VPWR _02024_ sky130_fd_sc_hd__nand2_1
X_07762_ _00225_ _00239_ VGND VGND VPWR VPWR _00241_ sky130_fd_sc_hd__xnor2_1
XFILLER_37_431 VPWR VGND VPWR VGND sky130_ef_sc_hd__decap_12
XTAP_TAPCELL_ROW_84_1516 VGND VPWR sky130_fd_sc_hd__tapvpwrvgnd_1
XFILLER_64_261 VGND VGND VPWR VPWR sky130_fd_sc_hd__fill_1
XFILLER_52_401 VPWR VGND VPWR VGND sky130_ef_sc_hd__decap_12
X_07693_ _06785_ _06787_ _06784_ VGND VGND VPWR VPWR _00172_ sky130_fd_sc_hd__a21o_1
X_09432_ _01913_ _01947_ VGND VGND VPWR VPWR _01948_ sky130_fd_sc_hd__and2b_1
XTAP_TAPCELL_ROW_48_993 VGND VPWR sky130_fd_sc_hd__tapvpwrvgnd_1
XFILLER_24_103 VGND VGND VPWR VPWR sky130_fd_sc_hd__decap_8
XFILLER_37_497 VGND VGND VPWR VPWR sky130_fd_sc_hd__fill_1
X_09363_ net550 net360 VGND VGND VPWR VPWR _01873_ sky130_fd_sc_hd__nand2_1
XFILLER_80_754 VGND VGND VPWR VPWR sky130_fd_sc_hd__fill_2
XFILLER_52_456 VPWR VGND VPWR VGND sky130_ef_sc_hd__decap_12
XFILLER_12_309 VGND VGND VPWR VPWR sky130_fd_sc_hd__decap_4
X_08314_ _00787_ _00788_ VGND VGND VPWR VPWR _00789_ sky130_fd_sc_hd__nor2_1
X_09294_ _01788_ _01796_ _01797_ VGND VGND VPWR VPWR _01798_ sky130_fd_sc_hd__nand3_1
XANTENNA_10 net112 VGND VGND VPWR VPWR sky130_fd_sc_hd__diode_2
XANTENNA_21 net552 VGND VGND VPWR VPWR sky130_fd_sc_hd__diode_2
X_08245_ _00690_ _00719_ VGND VGND VPWR VPWR _00720_ sky130_fd_sc_hd__and2b_1
XFILLER_119_753 VGND VGND VPWR VPWR sky130_fd_sc_hd__decap_4
X_08176_ _00651_ _00643_ VGND VGND VPWR VPWR _00652_ sky130_fd_sc_hd__nand2b_1
XFILLER_134_701 VGND VGND VPWR VPWR sky130_fd_sc_hd__fill_2
XFILLER_119_797 VGND VGND VPWR VPWR sky130_fd_sc_hd__fill_1
XFILLER_106_403 VPWR VGND VPWR VGND sky130_ef_sc_hd__decap_12
X_07127_ _03019_ _04707_ _04697_ VGND VGND VPWR VPWR _04718_ sky130_fd_sc_hd__a21oi_1
XFILLER_21_69 VPWR VGND VPWR VGND sky130_ef_sc_hd__decap_12
XFILLER_137_69 VPWR VGND VPWR VGND sky130_ef_sc_hd__decap_12
XTAP_TAPCELL_ROW_95_1678 VGND VPWR sky130_fd_sc_hd__tapvpwrvgnd_1
X_07058_ _03937_ _03948_ _03959_ VGND VGND VPWR VPWR _03970_ sky130_fd_sc_hd__nor3_1
Xoutput194 net194 VGND VGND VPWR VPWR y1[8] sky130_fd_sc_hd__buf_2
Xoutput183 net183 VGND VGND VPWR VPWR y1[13] sky130_fd_sc_hd__buf_2
XFILLER_114_491 VGND VGND VPWR VPWR sky130_fd_sc_hd__decap_6
XFILLER_88_821 VGND VGND VPWR VPWR sky130_fd_sc_hd__decap_3
Xoutput172 net172 VGND VGND VPWR VPWR y0[3] sky130_fd_sc_hd__buf_2
XFILLER_0_769 VPWR VGND VPWR VGND sky130_ef_sc_hd__decap_12
XTAP_TAPCELL_ROW_126_2122 VGND VPWR sky130_fd_sc_hd__tapvpwrvgnd_1
XFILLER_75_537 VGND VGND VPWR VPWR sky130_fd_sc_hd__fill_2
XTAP_TAPCELL_ROW_126_2133 VGND VPWR sky130_fd_sc_hd__tapvpwrvgnd_1
XFILLER_55_261 VGND VGND VPWR VPWR sky130_fd_sc_hd__fill_2
XFILLER_46_77 VGND VGND VPWR VPWR sky130_fd_sc_hd__decap_6
X_10971_ _03623_ _03622_ VGND VGND VPWR VPWR _03624_ sky130_fd_sc_hd__and2b_1
XFILLER_28_475 VGND VGND VPWR VPWR sky130_fd_sc_hd__fill_1
XFILLER_71_721 VGND VGND VPWR VPWR sky130_fd_sc_hd__decap_6
X_12710_ _05513_ _05518_ VGND VGND VPWR VPWR _05519_ sky130_fd_sc_hd__and2b_1
X_13690_ clknet_3_3__leaf_clk _00049_ net714 VGND VGND VPWR VPWR net225 sky130_fd_sc_hd__dfrtp_1
XFILLER_16_637 VGND VGND VPWR VPWR sky130_fd_sc_hd__decap_6
X_12641_ _05098_ _05262_ _05261_ VGND VGND VPWR VPWR _05443_ sky130_fd_sc_hd__o21a_1
XFILLER_71_765 VPWR VGND VPWR VGND sky130_ef_sc_hd__decap_12
XFILLER_70_253 VGND VGND VPWR VPWR sky130_fd_sc_hd__decap_8
XFILLER_43_445 VGND VGND VPWR VPWR sky130_fd_sc_hd__decap_3
XFILLER_15_169 VPWR VGND VPWR VGND sky130_ef_sc_hd__decap_12
XFILLER_102_83 VGND VGND VPWR VPWR sky130_fd_sc_hd__fill_1
XFILLER_12_810 VGND VGND VPWR VPWR sky130_fd_sc_hd__fill_2
XTAP_TAPCELL_ROW_26_676 VGND VPWR sky130_fd_sc_hd__tapvpwrvgnd_1
X_12572_ _05337_ _05366_ VGND VGND VPWR VPWR _05368_ sky130_fd_sc_hd__xnor2_1
XFILLER_62_65 VGND VGND VPWR VPWR sky130_fd_sc_hd__decap_4
XFILLER_23_191 VPWR VGND VPWR VGND sky130_ef_sc_hd__decap_12
XFILLER_7_27 VPWR VGND VPWR VGND sky130_ef_sc_hd__decap_12
X_11523_ _03617_ _04225_ VGND VGND VPWR VPWR _04227_ sky130_fd_sc_hd__xnor2_1
XTAP_TAPCELL_ROW_137_2284 VGND VPWR sky130_fd_sc_hd__tapvpwrvgnd_1
XFILLER_109_230 VGND VGND VPWR VPWR sky130_fd_sc_hd__fill_2
X_11454_ _03918_ _04005_ _04004_ VGND VGND VPWR VPWR _04152_ sky130_fd_sc_hd__a21boi_1
X_10405_ net632 net328 VGND VGND VPWR VPWR _03005_ sky130_fd_sc_hd__nand2_1
XFILLER_125_745 VGND VGND VPWR VPWR sky130_fd_sc_hd__fill_1
X_11385_ net492 net287 VGND VGND VPWR VPWR _04076_ sky130_fd_sc_hd__nand2_1
XFILLER_98_618 VGND VGND VPWR VPWR sky130_fd_sc_hd__fill_1
X_13124_ _05833_ _05841_ _05840_ VGND VGND VPWR VPWR _05970_ sky130_fd_sc_hd__a21o_1
XFILLER_3_541 VPWR VGND VPWR VGND sky130_ef_sc_hd__decap_12
X_10336_ _02876_ _02928_ VGND VGND VPWR VPWR _02929_ sky130_fd_sc_hd__nor2_1
XFILLER_105_480 VGND VGND VPWR VPWR sky130_fd_sc_hd__fill_1
X_13055_ _05740_ net408 _00436_ VGND VGND VPWR VPWR _05894_ sky130_fd_sc_hd__and3b_1
X_10267_ _02797_ _02811_ _02814_ VGND VGND VPWR VPWR _02854_ sky130_fd_sc_hd__a21oi_1
X_12006_ _04690_ _04696_ _04748_ VGND VGND VPWR VPWR _04749_ sky130_fd_sc_hd__a21oi_1
X_10198_ _02764_ _02781_ VGND VGND VPWR VPWR _02783_ sky130_fd_sc_hd__xnor2_1
XFILLER_94_813 VGND VGND VPWR VPWR sky130_fd_sc_hd__decap_6
XFILLER_93_301 VGND VGND VPWR VPWR sky130_fd_sc_hd__fill_2
XFILLER_39_729 VPWR VGND VPWR VGND sky130_ef_sc_hd__decap_12
XFILLER_93_345 VGND VGND VPWR VPWR sky130_fd_sc_hd__decap_8
XTAP_TAPCELL_ROW_6_390 VGND VPWR sky130_fd_sc_hd__tapvpwrvgnd_1
XFILLER_19_464 VGND VGND VPWR VPWR sky130_fd_sc_hd__fill_1
X_12908_ _05407_ _05595_ _05594_ VGND VGND VPWR VPWR _05734_ sky130_fd_sc_hd__o21a_1
XFILLER_74_581 VGND VGND VPWR VPWR sky130_fd_sc_hd__decap_6
XFILLER_46_294 VGND VGND VPWR VPWR sky130_fd_sc_hd__decap_6
XTAP_TAPCELL_ROW_66_1257 VGND VPWR sky130_fd_sc_hd__tapvpwrvgnd_1
XTAP_TAPCELL_ROW_45_952 VGND VPWR sky130_fd_sc_hd__tapvpwrvgnd_1
XFILLER_34_467 VGND VGND VPWR VPWR sky130_fd_sc_hd__decap_8
X_12839_ _05620_ _05658_ VGND VGND VPWR VPWR _05659_ sky130_fd_sc_hd__xor2_1
XFILLER_62_787 VPWR VGND VPWR VGND sky130_ef_sc_hd__decap_12
XFILLER_21_106 VGND VGND VPWR VPWR sky130_fd_sc_hd__decap_6
XFILLER_21_117 VGND VGND VPWR VPWR sky130_fd_sc_hd__fill_1
XFILLER_34_489 VGND VGND VPWR VPWR sky130_fd_sc_hd__fill_1
Xinput30 w03[4] VGND VGND VPWR VPWR net30 sky130_fd_sc_hd__clkbuf_2
X_08030_ _00505_ _00506_ VGND VGND VPWR VPWR _00507_ sky130_fd_sc_hd__nor2_1
XFILLER_30_684 VGND VGND VPWR VPWR sky130_fd_sc_hd__fill_2
Xinput52 w12[2] VGND VGND VPWR VPWR net52 sky130_fd_sc_hd__buf_1
Xinput63 w13[5] VGND VGND VPWR VPWR net63 sky130_fd_sc_hd__buf_1
Xinput41 w10[7] VGND VGND VPWR VPWR net41 sky130_fd_sc_hd__clkbuf_2
XFILLER_128_594 VPWR VGND VPWR VGND sky130_ef_sc_hd__decap_12
XFILLER_116_734 VGND VGND VPWR VPWR sky130_fd_sc_hd__decap_8
Xinput96 w23[6] VGND VGND VPWR VPWR net96 sky130_fd_sc_hd__dlymetal6s2s_1
Xinput85 w22[3] VGND VGND VPWR VPWR net85 sky130_fd_sc_hd__buf_1
Xinput74 w21[0] VGND VGND VPWR VPWR net74 sky130_fd_sc_hd__clkbuf_2
X_09981_ _02545_ _02546_ VGND VGND VPWR VPWR _02547_ sky130_fd_sc_hd__nor2_1
XFILLER_107_39 VPWR VGND VPWR VGND sky130_ef_sc_hd__decap_12
XFILLER_88_106 VGND VGND VPWR VPWR sky130_fd_sc_hd__decap_8
X_08932_ _01383_ _01402_ VGND VGND VPWR VPWR _01403_ sky130_fd_sc_hd__xor2_1
XFILLER_130_269 VGND VGND VPWR VPWR sky130_fd_sc_hd__fill_1
X_08863_ _01327_ _01326_ _01319_ VGND VGND VPWR VPWR _01329_ sky130_fd_sc_hd__a21o_1
XTAP_TAPCELL_ROW_90_1597 VGND VPWR sky130_fd_sc_hd__tapvpwrvgnd_1
X_08794_ _01096_ _01098_ VGND VGND VPWR VPWR _01260_ sky130_fd_sc_hd__or2_1
XFILLER_123_27 VPWR VGND VPWR VGND sky130_ef_sc_hd__decap_12
X_07814_ _06738_ _00148_ _00147_ VGND VGND VPWR VPWR _00292_ sky130_fd_sc_hd__a21o_1
XFILLER_38_740 VGND VGND VPWR VPWR sky130_fd_sc_hd__fill_1
XFILLER_72_507 VGND VGND VPWR VPWR sky130_fd_sc_hd__decap_3
X_07745_ _00081_ _00083_ VGND VGND VPWR VPWR _00224_ sky130_fd_sc_hd__nand2_1
XFILLER_53_710 VPWR VGND VPWR VGND sky130_ef_sc_hd__decap_12
XFILLER_37_261 VGND VGND VPWR VPWR sky130_fd_sc_hd__fill_1
X_09415_ _01924_ _01926_ _01927_ VGND VGND VPWR VPWR _01929_ sky130_fd_sc_hd__a21o_1
XTAP_TAPCELL_ROW_121_2052 VGND VPWR sky130_fd_sc_hd__tapvpwrvgnd_1
XFILLER_53_765 VPWR VGND VPWR VGND sky130_ef_sc_hd__decap_12
XFILLER_25_445 VGND VGND VPWR VPWR sky130_fd_sc_hd__decap_3
X_07676_ net693 net547 VGND VGND VPWR VPWR _00155_ sky130_fd_sc_hd__nand2_1
XFILLER_13_629 VGND VGND VPWR VPWR sky130_fd_sc_hd__decap_8
X_09346_ _01517_ _01852_ _01854_ VGND VGND VPWR VPWR _01855_ sky130_fd_sc_hd__or3_1
XTAP_TAPCELL_ROW_23_635 VGND VPWR sky130_fd_sc_hd__tapvpwrvgnd_1
X_09277_ _01745_ _01777_ VGND VGND VPWR VPWR _01779_ sky130_fd_sc_hd__xnor2_1
XTAP_TAPCELL_ROW_97_1707 VGND VPWR sky130_fd_sc_hd__tapvpwrvgnd_1
XFILLER_21_673 VGND VGND VPWR VPWR sky130_fd_sc_hd__decap_6
X_08228_ _00600_ _00602_ _00599_ VGND VGND VPWR VPWR _00703_ sky130_fd_sc_hd__a21oi_1
XFILLER_21_695 VPWR VGND VPWR VGND sky130_ef_sc_hd__decap_12
XFILLER_32_79 VGND VGND VPWR VPWR sky130_fd_sc_hd__decap_4
XFILLER_119_561 VPWR VGND VPWR VGND sky130_ef_sc_hd__decap_12
XFILLER_134_531 VGND VGND VPWR VPWR sky130_fd_sc_hd__fill_1
XFILLER_106_233 VGND VGND VPWR VPWR sky130_fd_sc_hd__decap_4
XFILLER_106_222 VGND VGND VPWR VPWR sky130_fd_sc_hd__decap_4
X_08159_ _00629_ _00633_ VGND VGND VPWR VPWR _00635_ sky130_fd_sc_hd__xnor2_1
X_11170_ _03840_ _03841_ VGND VGND VPWR VPWR _03842_ sky130_fd_sc_hd__nor2_1
XFILLER_122_748 VGND VGND VPWR VPWR sky130_fd_sc_hd__decap_8
XFILLER_121_225 VPWR VGND VPWR VGND sky130_ef_sc_hd__decap_12
X_10121_ _02620_ _02622_ VGND VGND VPWR VPWR _02699_ sky130_fd_sc_hd__nand2_1
X_10052_ _02622_ _02623_ VGND VGND VPWR VPWR _02624_ sky130_fd_sc_hd__nand2_1
XFILLER_130_781 VPWR VGND VPWR VGND sky130_ef_sc_hd__decap_12
XFILLER_121_269 VGND VGND VPWR VPWR sky130_fd_sc_hd__fill_1
XFILLER_94_109 VPWR VGND VPWR VGND sky130_ef_sc_hd__decap_12
XFILLER_88_695 VGND VGND VPWR VPWR sky130_fd_sc_hd__decap_4
XFILLER_88_673 VPWR VGND VPWR VGND sky130_ef_sc_hd__decap_12
XFILLER_76_813 VGND VGND VPWR VPWR sky130_fd_sc_hd__decap_6
XTAP_TAPCELL_ROW_50_1025 VGND VPWR sky130_fd_sc_hd__tapvpwrvgnd_1
XFILLER_75_323 VGND VGND VPWR VPWR sky130_fd_sc_hd__fill_1
XTAP_TAPCELL_ROW_106_1836 VGND VPWR sky130_fd_sc_hd__tapvpwrvgnd_1
XFILLER_44_721 VGND VGND VPWR VPWR sky130_fd_sc_hd__fill_2
XFILLER_16_412 VGND VGND VPWR VPWR sky130_fd_sc_hd__decap_8
XFILLER_16_445 VGND VGND VPWR VPWR sky130_fd_sc_hd__decap_8
X_10954_ net492 net291 VGND VGND VPWR VPWR _03605_ sky130_fd_sc_hd__nand2_1
XFILLER_73_97 VPWR VGND VPWR VGND sky130_ef_sc_hd__decap_12
XFILLER_43_286 VPWR VGND VPWR VGND sky130_ef_sc_hd__decap_12
XTAP_TAPCELL_ROW_42_911 VGND VPWR sky130_fd_sc_hd__tapvpwrvgnd_1
X_10885_ _03352_ _03529_ VGND VGND VPWR VPWR _03530_ sky130_fd_sc_hd__and2_1
X_13673_ clknet_3_2__leaf_clk _00021_ net712 VGND VGND VPWR VPWR net208 sky130_fd_sc_hd__dfrtp_1
X_12624_ _05404_ _05423_ VGND VGND VPWR VPWR _05424_ sky130_fd_sc_hd__xnor2_1
X_12555_ net652 net412 net285 VGND VGND VPWR VPWR _05349_ sky130_fd_sc_hd__and3_1
XFILLER_129_358 VPWR VGND VPWR VGND sky130_ef_sc_hd__decap_12
XTAP_TAPCELL_ROW_61_1187 VGND VPWR sky130_fd_sc_hd__tapvpwrvgnd_1
X_11506_ _04171_ _04206_ VGND VGND VPWR VPWR _04208_ sky130_fd_sc_hd__xnor2_1
XFILLER_7_110 VGND VGND VPWR VPWR sky130_fd_sc_hd__fill_2
X_12486_ _05224_ _05271_ VGND VGND VPWR VPWR _05273_ sky130_fd_sc_hd__xnor2_1
XFILLER_7_165 VGND VGND VPWR VPWR sky130_fd_sc_hd__decap_3
XFILLER_137_391 VGND VGND VPWR VPWR sky130_fd_sc_hd__fill_1
X_11437_ _03457_ _04131_ VGND VGND VPWR VPWR _04133_ sky130_fd_sc_hd__xnor2_1
XTAP_TAPCELL_ROW_117_1998 VGND VPWR sky130_fd_sc_hd__tapvpwrvgnd_1
X_11368_ _03899_ _03908_ _03907_ VGND VGND VPWR VPWR _04058_ sky130_fd_sc_hd__a21oi_1
XFILLER_113_726 VGND VGND VPWR VPWR sky130_fd_sc_hd__fill_2
XFILLER_98_448 VGND VGND VPWR VPWR sky130_fd_sc_hd__decap_4
XFILLER_98_83 VGND VGND VPWR VPWR sky130_fd_sc_hd__fill_1
X_13107_ net522 net394 _05801_ _05800_ net412 VGND VGND VPWR VPWR _05951_ sky130_fd_sc_hd__a32o_1
X_10319_ _02908_ _02910_ net569 net310 VGND VGND VPWR VPWR _02911_ sky130_fd_sc_hd__and4bb_1
XFILLER_112_236 VGND VGND VPWR VPWR sky130_fd_sc_hd__fill_1
XFILLER_98_459 VPWR VGND VPWR VGND sky130_ef_sc_hd__decap_12
X_11299_ net627 net618 net316 net314 VGND VGND VPWR VPWR _03983_ sky130_fd_sc_hd__and4_1
X_13038_ _05732_ _05875_ VGND VGND VPWR VPWR _05877_ sky130_fd_sc_hd__xnor2_1
XFILLER_93_120 VGND VGND VPWR VPWR sky130_fd_sc_hd__fill_1
XFILLER_14_3 VPWR VGND VPWR VGND sky130_ef_sc_hd__decap_12
XFILLER_39_537 VGND VGND VPWR VPWR sky130_fd_sc_hd__decap_4
XFILLER_81_304 VPWR VGND VPWR VGND sky130_ef_sc_hd__decap_12
XTAP_TAPCELL_ROW_1_308 VGND VPWR sky130_fd_sc_hd__tapvpwrvgnd_1
XTAP_TAPCELL_ROW_1_319 VGND VPWR sky130_fd_sc_hd__tapvpwrvgnd_1
XFILLER_93_175 VGND VGND VPWR VPWR sky130_fd_sc_hd__fill_1
X_07530_ _06628_ _06637_ _06636_ VGND VGND VPWR VPWR _06759_ sky130_fd_sc_hd__a21bo_1
XFILLER_19_261 VPWR VGND VPWR VGND sky130_ef_sc_hd__decap_12
XFILLER_34_231 VPWR VGND VPWR VGND sky130_ef_sc_hd__decap_12
X_07461_ _06689_ _06690_ VGND VGND VPWR VPWR _06691_ sky130_fd_sc_hd__nor2_1
XFILLER_50_735 VGND VGND VPWR VPWR sky130_fd_sc_hd__fill_1
XFILLER_50_713 VGND VGND VPWR VPWR sky130_fd_sc_hd__decap_4
XFILLER_34_253 VGND VGND VPWR VPWR sky130_fd_sc_hd__fill_2
X_09200_ _01524_ _01526_ _01523_ VGND VGND VPWR VPWR _01695_ sky130_fd_sc_hd__a21oi_1
XFILLER_50_757 VGND VGND VPWR VPWR sky130_fd_sc_hd__fill_2
X_07392_ _06576_ _06620_ VGND VGND VPWR VPWR _06622_ sky130_fd_sc_hd__xnor2_1
XFILLER_22_448 VGND VGND VPWR VPWR sky130_fd_sc_hd__fill_2
X_09131_ net616 net608 net375 net374 VGND VGND VPWR VPWR _01620_ sky130_fd_sc_hd__nand4_1
X_09062_ _01375_ _01379_ _01543_ VGND VGND VPWR VPWR _01545_ sky130_fd_sc_hd__nand3_1
XTAP_TAPCELL_ROW_79_1448 VGND VPWR sky130_fd_sc_hd__tapvpwrvgnd_1
XFILLER_118_27 VGND VGND VPWR VPWR sky130_fd_sc_hd__fill_1
X_08013_ _06804_ _00489_ VGND VGND VPWR VPWR _00490_ sky130_fd_sc_hd__xnor2_1
XTAP_TAPCELL_ROW_92_1637 VGND VPWR sky130_fd_sc_hd__tapvpwrvgnd_1
XTAP_TAPCELL_ROW_92_1626 VGND VPWR sky130_fd_sc_hd__tapvpwrvgnd_1
XFILLER_116_586 VGND VGND VPWR VPWR sky130_fd_sc_hd__fill_2
XFILLER_104_737 VPWR VGND VPWR VGND sky130_ef_sc_hd__decap_12
XFILLER_1_308 VGND VGND VPWR VPWR sky130_fd_sc_hd__decap_3
XFILLER_134_15 VPWR VGND VPWR VGND sky130_ef_sc_hd__decap_12
X_09964_ net488 net479 net342 VGND VGND VPWR VPWR _02528_ sky130_fd_sc_hd__and3_1
X_09895_ _02452_ VGND VGND VPWR VPWR _02453_ sky130_fd_sc_hd__inv_2
X_08915_ net489 net352 _01281_ _01280_ VGND VGND VPWR VPWR _01384_ sky130_fd_sc_hd__a31o_1
XFILLER_112_781 VPWR VGND VPWR VGND sky130_ef_sc_hd__decap_12
XFILLER_58_813 VGND VGND VPWR VPWR sky130_fd_sc_hd__decap_8
X_08846_ net472 net332 _01163_ VGND VGND VPWR VPWR _01312_ sky130_fd_sc_hd__and3_1
XFILLER_57_345 VGND VGND VPWR VPWR sky130_fd_sc_hd__fill_2
XFILLER_57_323 VGND VGND VPWR VPWR sky130_fd_sc_hd__fill_1
XFILLER_85_665 VGND VGND VPWR VPWR sky130_fd_sc_hd__decap_6
XFILLER_84_164 VGND VGND VPWR VPWR sky130_fd_sc_hd__fill_1
XFILLER_57_378 VPWR VGND VPWR VGND sky130_ef_sc_hd__decap_12
XTAP_TAPCELL_ROW_28_705 VGND VPWR sky130_fd_sc_hd__tapvpwrvgnd_1
X_08777_ net231 _01242_ _01241_ VGND VGND VPWR VPWR _01244_ sky130_fd_sc_hd__a21o_1
XFILLER_84_197 VGND VGND VPWR VPWR sky130_fd_sc_hd__decap_3
XFILLER_45_529 VPWR VGND VPWR VGND sky130_ef_sc_hd__decap_12
XFILLER_27_57 VGND VGND VPWR VPWR sky130_fd_sc_hd__decap_4
XFILLER_27_68 VPWR VGND VPWR VGND sky130_ef_sc_hd__decap_12
X_07728_ _00196_ _00206_ VGND VGND VPWR VPWR _00207_ sky130_fd_sc_hd__xor2_1
XFILLER_25_220 VGND VGND VPWR VPWR sky130_fd_sc_hd__decap_4
XFILLER_26_754 VGND VGND VPWR VPWR sky130_fd_sc_hd__fill_2
X_07659_ _06724_ _00137_ _00138_ VGND VGND VPWR VPWR _00139_ sky130_fd_sc_hd__and3_1
XFILLER_40_201 VGND VGND VPWR VPWR sky130_fd_sc_hd__fill_1
X_10670_ _03137_ _03140_ _03138_ VGND VGND VPWR VPWR _03295_ sky130_fd_sc_hd__o21bai_1
XFILLER_40_223 VGND VGND VPWR VPWR sky130_fd_sc_hd__decap_8
X_09329_ _01804_ _01834_ _01836_ VGND VGND VPWR VPWR _01837_ sky130_fd_sc_hd__nand3_1
XTAP_TAPCELL_ROW_101_1766 VGND VPWR sky130_fd_sc_hd__tapvpwrvgnd_1
XFILLER_40_267 VGND VGND VPWR VPWR sky130_fd_sc_hd__decap_8
XFILLER_40_278 VGND VGND VPWR VPWR sky130_fd_sc_hd__fill_1
XTAP_TAPCELL_ROW_134_2243 VGND VPWR sky130_fd_sc_hd__tapvpwrvgnd_1
X_12340_ net489 net480 net407 net406 VGND VGND VPWR VPWR _05114_ sky130_fd_sc_hd__and4_1
XFILLER_126_328 VGND VGND VPWR VPWR sky130_fd_sc_hd__decap_4
X_12271_ _05033_ _05034_ _05036_ VGND VGND VPWR VPWR _05039_ sky130_fd_sc_hd__a21oi_1
XFILLER_107_553 VGND VGND VPWR VPWR sky130_fd_sc_hd__decap_6
X_11222_ _03731_ _03897_ VGND VGND VPWR VPWR _03898_ sky130_fd_sc_hd__xnor2_1
XFILLER_107_597 VGND VGND VPWR VPWR sky130_fd_sc_hd__decap_4
XFILLER_68_53 VPWR VGND VPWR VGND sky130_ef_sc_hd__decap_12
X_11153_ net323 net599 VGND VGND VPWR VPWR _03823_ sky130_fd_sc_hd__and2b_1
X_10104_ _02679_ _02680_ VGND VGND VPWR VPWR _02681_ sky130_fd_sc_hd__nor2_1
XFILLER_48_301 VGND VGND VPWR VPWR sky130_fd_sc_hd__decap_6
X_11084_ _03742_ _03746_ VGND VGND VPWR VPWR _03747_ sky130_fd_sc_hd__and2b_1
X_10035_ _02602_ _02603_ VGND VGND VPWR VPWR _02605_ sky130_fd_sc_hd__xor2_1
XFILLER_0_385 VGND VGND VPWR VPWR sky130_fd_sc_hd__decap_3
XFILLER_91_613 VGND VGND VPWR VPWR sky130_fd_sc_hd__decap_3
XFILLER_84_41 VPWR VGND VPWR VGND sky130_ef_sc_hd__decap_12
XFILLER_63_304 VPWR VGND VPWR VGND sky130_ef_sc_hd__decap_12
XFILLER_76_698 VGND VGND VPWR VPWR sky130_fd_sc_hd__fill_2
X_11986_ net523 net402 VGND VGND VPWR VPWR _04727_ sky130_fd_sc_hd__nand2_1
XFILLER_84_85 VGND VGND VPWR VPWR sky130_fd_sc_hd__decap_8
XTAP_TAPCELL_ROW_63_1216 VGND VPWR sky130_fd_sc_hd__tapvpwrvgnd_1
X_10937_ _03583_ _03584_ VGND VGND VPWR VPWR _03586_ sky130_fd_sc_hd__xnor2_1
XFILLER_16_253 VPWR VGND VPWR VGND sky130_ef_sc_hd__decap_12
X_13656_ clknet_3_7__leaf_clk _00063_ net717 VGND VGND VPWR VPWR net191 sky130_fd_sc_hd__dfrtp_1
XFILLER_31_223 VGND VGND VPWR VPWR sky130_fd_sc_hd__fill_1
XFILLER_32_757 VPWR VGND VPWR VGND sky130_ef_sc_hd__decap_12
X_12607_ net266 net695 _05226_ VGND VGND VPWR VPWR _05405_ sky130_fd_sc_hd__nor3_1
X_10868_ _03508_ _03509_ VGND VGND VPWR VPWR _03512_ sky130_fd_sc_hd__xor2_1
XFILLER_129_111 VGND VGND VPWR VPWR sky130_fd_sc_hd__fill_1
X_13587_ _06303_ _06395_ _06394_ VGND VGND VPWR VPWR _06475_ sky130_fd_sc_hd__a21o_1
XTAP_TAPCELL_ROW_14_498 VGND VPWR sky130_fd_sc_hd__tapvpwrvgnd_1
X_10799_ net443 net435 net277 net93 VGND VGND VPWR VPWR _03436_ sky130_fd_sc_hd__nand4_1
XFILLER_31_289 VGND VGND VPWR VPWR sky130_fd_sc_hd__decap_3
XFILLER_129_177 VGND VGND VPWR VPWR sky130_fd_sc_hd__decap_3
X_12538_ _05327_ _05328_ _05329_ VGND VGND VPWR VPWR _05331_ sky130_fd_sc_hd__and3_1
XFILLER_129_199 VGND VGND VPWR VPWR sky130_fd_sc_hd__fill_2
X_12469_ net480 net406 _04972_ VGND VGND VPWR VPWR _05255_ sky130_fd_sc_hd__and3_1
XFILLER_132_309 VGND VGND VPWR VPWR sky130_fd_sc_hd__decap_3
XFILLER_113_512 VPWR VGND VPWR VGND sky130_ef_sc_hd__decap_12
XFILLER_99_735 VGND VGND VPWR VPWR sky130_fd_sc_hd__fill_1
Xfanout409 net17 VGND VGND VPWR VPWR net409 sky130_fd_sc_hd__buf_1
XTAP_TAPCELL_ROW_74_1378 VGND VPWR sky130_fd_sc_hd__tapvpwrvgnd_1
XTAP_TAPCELL_ROW_74_1367 VGND VPWR sky130_fd_sc_hd__tapvpwrvgnd_1
XFILLER_58_109 VPWR VGND VPWR VGND sky130_ef_sc_hd__decap_12
X_06961_ _02866_ _02898_ VGND VGND VPWR VPWR _02909_ sky130_fd_sc_hd__xnor2_1
X_09680_ _02204_ _02218_ VGND VGND VPWR VPWR _02219_ sky130_fd_sc_hd__xnor2_1
X_08700_ net657 net646 net372 net373 VGND VGND VPWR VPWR _01167_ sky130_fd_sc_hd__nand4_1
XFILLER_100_228 VGND VGND VPWR VPWR sky130_fd_sc_hd__decap_4
X_08631_ _01096_ _01097_ net575 net363 VGND VGND VPWR VPWR _01098_ sky130_fd_sc_hd__and4bb_1
XFILLER_104_29 VPWR VGND VPWR VGND sky130_ef_sc_hd__decap_12
XFILLER_94_462 VGND VGND VPWR VPWR sky130_fd_sc_hd__fill_1
XFILLER_67_665 VGND VGND VPWR VPWR sky130_fd_sc_hd__decap_6
X_06892_ _02129_ _02151_ VGND VGND VPWR VPWR _02162_ sky130_fd_sc_hd__nand2_1
XFILLER_39_356 VPWR VGND VPWR VGND sky130_ef_sc_hd__decap_12
X_08562_ _01003_ _01030_ VGND VGND VPWR VPWR _00010_ sky130_fd_sc_hd__xor2_1
XFILLER_81_156 VGND VGND VPWR VPWR sky130_fd_sc_hd__fill_2
XFILLER_81_134 VGND VGND VPWR VPWR sky130_fd_sc_hd__fill_1
XFILLER_66_197 VGND VGND VPWR VPWR sky130_fd_sc_hd__fill_2
X_08493_ _00964_ _00965_ VGND VGND VPWR VPWR _00046_ sky130_fd_sc_hd__xnor2_1
X_07513_ net700 net538 net264 net702 VGND VGND VPWR VPWR _06742_ sky130_fd_sc_hd__o2bb2a_1
XFILLER_90_690 VGND VGND VPWR VPWR sky130_fd_sc_hd__decap_8
X_07444_ _06663_ _06673_ VGND VGND VPWR VPWR _06674_ sky130_fd_sc_hd__xor2_1
XFILLER_13_15 VPWR VGND VPWR VGND sky130_ef_sc_hd__decap_12
XFILLER_129_15 VPWR VGND VPWR VGND sky130_ef_sc_hd__decap_12
X_07375_ net686 net685 net499 net486 VGND VGND VPWR VPWR _06605_ sky130_fd_sc_hd__and4_1
XFILLER_22_278 VPWR VGND VPWR VGND sky130_ef_sc_hd__decap_12
XTAP_TAPCELL_ROW_33_774 VGND VPWR sky130_fd_sc_hd__tapvpwrvgnd_1
X_09114_ _01597_ _01598_ _01599_ VGND VGND VPWR VPWR _01601_ sky130_fd_sc_hd__a21o_1
XFILLER_135_125 VPWR VGND VPWR VGND sky130_ef_sc_hd__decap_12
X_09045_ net265 net366 VGND VGND VPWR VPWR _01526_ sky130_fd_sc_hd__nor2_1
XFILLER_89_19 VPWR VGND VPWR VGND sky130_ef_sc_hd__decap_12
XFILLER_135_169 VGND VGND VPWR VPWR sky130_fd_sc_hd__decap_8
XFILLER_132_821 VGND VGND VPWR VPWR sky130_fd_sc_hd__decap_3
XFILLER_1_105 VGND VGND VPWR VPWR sky130_fd_sc_hd__decap_6
X_09947_ _02506_ _02507_ VGND VGND VPWR VPWR _02509_ sky130_fd_sc_hd__xor2_1
XFILLER_104_589 VGND VGND VPWR VPWR sky130_fd_sc_hd__fill_1
XFILLER_89_289 VGND VGND VPWR VPWR sky130_fd_sc_hd__fill_1
X_09878_ _02432_ _02433_ VGND VGND VPWR VPWR _02435_ sky130_fd_sc_hd__and2_1
XFILLER_85_440 VGND VGND VPWR VPWR sky130_fd_sc_hd__decap_3
XFILLER_58_676 VGND VGND VPWR VPWR sky130_fd_sc_hd__fill_1
X_08829_ _01293_ _01294_ VGND VGND VPWR VPWR _01295_ sky130_fd_sc_hd__or2_1
XFILLER_72_112 VGND VGND VPWR VPWR sky130_fd_sc_hd__fill_2
XFILLER_45_304 VPWR VGND VPWR VGND sky130_ef_sc_hd__decap_12
XFILLER_45_348 VPWR VGND VPWR VGND sky130_ef_sc_hd__decap_12
XFILLER_45_337 VGND VGND VPWR VPWR sky130_fd_sc_hd__fill_2
X_11840_ _04561_ _04571_ VGND VGND VPWR VPWR _04572_ sky130_fd_sc_hd__nand2b_1
XFILLER_60_307 VGND VGND VPWR VPWR sky130_fd_sc_hd__fill_1
X_11771_ _04405_ _04408_ VGND VGND VPWR VPWR _04497_ sky130_fd_sc_hd__nor2_1
X_13510_ _06358_ _06390_ VGND VGND VPWR VPWR _06392_ sky130_fd_sc_hd__xor2_1
XFILLER_53_370 VPWR VGND VPWR VGND sky130_ef_sc_hd__decap_12
XFILLER_14_757 VPWR VGND VPWR VGND sky130_ef_sc_hd__decap_12
X_10722_ _03196_ _03198_ _03351_ _03350_ VGND VGND VPWR VPWR _03352_ sky130_fd_sc_hd__a211o_1
XFILLER_110_83 VGND VGND VPWR VPWR sky130_fd_sc_hd__fill_1
X_13441_ _06218_ _06229_ _06215_ VGND VGND VPWR VPWR _06316_ sky130_fd_sc_hd__a21oi_1
X_10653_ _03148_ _03275_ VGND VGND VPWR VPWR _03276_ sky130_fd_sc_hd__and2b_1
XFILLER_127_615 VGND VGND VPWR VPWR sky130_fd_sc_hd__fill_1
X_13372_ _06119_ _06121_ _06239_ VGND VGND VPWR VPWR _06241_ sky130_fd_sc_hd__or3_1
XFILLER_70_65 VGND VGND VPWR VPWR sky130_fd_sc_hd__decap_6
X_10584_ _03061_ _03065_ _03067_ _03060_ VGND VGND VPWR VPWR _03201_ sky130_fd_sc_hd__a31o_1
X_12323_ net572 net577 VGND VGND VPWR VPWR _05095_ sky130_fd_sc_hd__nand2_1
XTAP_TAPCELL_ROW_11_457 VGND VPWR sky130_fd_sc_hd__tapvpwrvgnd_1
XFILLER_119_81 VPWR VGND VPWR VGND sky130_ef_sc_hd__decap_12
XTAP_TAPCELL_ROW_114_1957 VGND VPWR sky130_fd_sc_hd__tapvpwrvgnd_1
XTAP_TAPCELL_ROW_114_1946 VGND VPWR sky130_fd_sc_hd__tapvpwrvgnd_1
X_12254_ net634 net624 net386 net4 VGND VGND VPWR VPWR _05020_ sky130_fd_sc_hd__and4_1
X_12185_ _04942_ _04943_ VGND VGND VPWR VPWR _04944_ sky130_fd_sc_hd__nor2_1
XFILLER_79_74 VPWR VGND VPWR VGND sky130_ef_sc_hd__decap_12
X_11205_ _03763_ _03799_ _03798_ VGND VGND VPWR VPWR _03879_ sky130_fd_sc_hd__a21oi_1
XFILLER_96_738 VGND VGND VPWR VPWR sky130_fd_sc_hd__fill_1
XFILLER_68_418 VGND VGND VPWR VPWR sky130_fd_sc_hd__fill_2
XFILLER_1_650 VGND VGND VPWR VPWR sky130_fd_sc_hd__fill_1
X_11136_ net424 net276 net275 net433 VGND VGND VPWR VPWR _03804_ sky130_fd_sc_hd__a22o_1
XFILLER_95_51 VGND VGND VPWR VPWR sky130_fd_sc_hd__decap_4
XFILLER_76_440 VPWR VGND VPWR VGND sky130_ef_sc_hd__decap_12
XFILLER_48_120 VGND VGND VPWR VPWR sky130_fd_sc_hd__fill_1
X_11067_ _03725_ _03726_ VGND VGND VPWR VPWR _03728_ sky130_fd_sc_hd__nor2_1
X_10018_ _01611_ _02584_ _02583_ VGND VGND VPWR VPWR _02587_ sky130_fd_sc_hd__a21o_1
XFILLER_64_613 VGND VGND VPWR VPWR sky130_fd_sc_hd__decap_3
XFILLER_48_186 VGND VGND VPWR VPWR sky130_fd_sc_hd__decap_6
XFILLER_52_819 VGND VGND VPWR VPWR sky130_fd_sc_hd__fill_1
XFILLER_48_197 VGND VGND VPWR VPWR sky130_fd_sc_hd__fill_1
XFILLER_63_167 VGND VGND VPWR VPWR sky130_fd_sc_hd__fill_1
XFILLER_17_573 VGND VGND VPWR VPWR sky130_fd_sc_hd__decap_3
XTAP_TAPCELL_ROW_19_568 VGND VPWR sky130_fd_sc_hd__tapvpwrvgnd_1
XTAP_TAPCELL_ROW_19_579 VGND VPWR sky130_fd_sc_hd__tapvpwrvgnd_1
X_11969_ _04672_ _04708_ VGND VGND VPWR VPWR _04709_ sky130_fd_sc_hd__and2_1
XFILLER_20_716 VGND VGND VPWR VPWR sky130_fd_sc_hd__fill_1
X_13639_ clknet_3_6__leaf_clk _00035_ net716 VGND VGND VPWR VPWR net174 sky130_fd_sc_hd__dfrtp_1
X_07160_ net638 net709 VGND VGND VPWR VPWR _05078_ sky130_fd_sc_hd__nand2_1
XTAP_TAPCELL_ROW_30_733 VGND VPWR sky130_fd_sc_hd__tapvpwrvgnd_1
XTAP_TAPCELL_ROW_76_1407 VGND VPWR sky130_fd_sc_hd__tapvpwrvgnd_1
XFILLER_9_783 VGND VGND VPWR VPWR sky130_fd_sc_hd__fill_1
X_07091_ _02586_ _04318_ VGND VGND VPWR VPWR _04329_ sky130_fd_sc_hd__nand2_1
XFILLER_132_139 VGND VGND VPWR VPWR sky130_fd_sc_hd__fill_1
X_09801_ _02206_ _02213_ _02212_ VGND VGND VPWR VPWR _02351_ sky130_fd_sc_hd__a21oi_1
XFILLER_99_587 VGND VGND VPWR VPWR sky130_fd_sc_hd__decap_4
XFILLER_87_727 VGND VGND VPWR VPWR sky130_fd_sc_hd__fill_1
XFILLER_59_418 VGND VGND VPWR VPWR sky130_fd_sc_hd__decap_6
XFILLER_5_93 VPWR VGND VPWR VGND sky130_ef_sc_hd__decap_12
XFILLER_115_39 VPWR VGND VPWR VGND sky130_ef_sc_hd__decap_12
X_09732_ net614 net368 VGND VGND VPWR VPWR _02276_ sky130_fd_sc_hd__nand2_1
X_07993_ _00349_ _00360_ _00359_ VGND VGND VPWR VPWR _00470_ sky130_fd_sc_hd__o21a_1
XFILLER_28_805 VGND VGND VPWR VPWR sky130_fd_sc_hd__decap_6
X_06944_ net699 net570 _02695_ _02706_ VGND VGND VPWR VPWR _02728_ sky130_fd_sc_hd__o2bb2a_1
X_09663_ _02193_ _02198_ VGND VGND VPWR VPWR _02200_ sky130_fd_sc_hd__xnor2_1
X_06875_ _01932_ _01965_ VGND VGND VPWR VPWR _01976_ sky130_fd_sc_hd__xnor2_1
XFILLER_54_101 VPWR VGND VPWR VGND sky130_ef_sc_hd__decap_12
XFILLER_39_153 VPWR VGND VPWR VGND sky130_ef_sc_hd__decap_12
XFILLER_131_27 VPWR VGND VPWR VGND sky130_ef_sc_hd__decap_12
X_08614_ net530 net348 VGND VGND VPWR VPWR _01081_ sky130_fd_sc_hd__nand2_1
X_09594_ _02124_ _02110_ VGND VGND VPWR VPWR _02125_ sky130_fd_sc_hd__and2b_1
XTAP_TAPCELL_ROW_87_1558 VGND VPWR sky130_fd_sc_hd__tapvpwrvgnd_1
XFILLER_82_421 VGND VGND VPWR VPWR sky130_fd_sc_hd__fill_1
XTAP_TAPCELL_ROW_38_844 VGND VPWR sky130_fd_sc_hd__tapvpwrvgnd_1
XTAP_TAPCELL_ROW_38_855 VGND VPWR sky130_fd_sc_hd__tapvpwrvgnd_1
X_08545_ net463 net341 _01012_ VGND VGND VPWR VPWR _01014_ sky130_fd_sc_hd__a21oi_1
XFILLER_42_307 VGND VGND VPWR VPWR sky130_fd_sc_hd__fill_1
X_08476_ _00946_ _00947_ VGND VGND VPWR VPWR _00949_ sky130_fd_sc_hd__nand2_1
XTAP_TAPCELL_ROW_118_2013 VGND VPWR sky130_fd_sc_hd__tapvpwrvgnd_1
X_07427_ _06443_ _06465_ VGND VGND VPWR VPWR _06657_ sky130_fd_sc_hd__nand2_1
XFILLER_10_215 VGND VGND VPWR VPWR sky130_fd_sc_hd__decap_4
XFILLER_10_248 VGND VGND VPWR VPWR sky130_fd_sc_hd__decap_4
X_07358_ net114 net153 VGND VGND VPWR VPWR _06588_ sky130_fd_sc_hd__and2b_1
XTAP_TAPCELL_ROW_131_2202 VGND VPWR sky130_fd_sc_hd__tapvpwrvgnd_1
X_07289_ _04991_ _06465_ _06476_ VGND VGND VPWR VPWR _06486_ sky130_fd_sc_hd__and3_1
X_09028_ _01353_ _01356_ _01506_ _01507_ VGND VGND VPWR VPWR _01509_ sky130_fd_sc_hd__o211ai_2
XFILLER_105_821 VGND VGND VPWR VPWR sky130_fd_sc_hd__decap_3
XFILLER_116_191 VGND VGND VPWR VPWR sky130_fd_sc_hd__decap_4
XFILLER_104_320 VPWR VGND VPWR VGND sky130_ef_sc_hd__decap_12
XFILLER_132_662 VPWR VGND VPWR VGND sky130_ef_sc_hd__decap_12
XFILLER_120_813 VGND VGND VPWR VPWR sky130_fd_sc_hd__decap_8
XFILLER_49_55 VGND VGND VPWR VPWR sky130_fd_sc_hd__fill_1
XTAP_TAPCELL_ROW_129_2175 VGND VPWR sky130_fd_sc_hd__tapvpwrvgnd_1
XTAP_TAPCELL_ROW_129_2164 VGND VPWR sky130_fd_sc_hd__tapvpwrvgnd_1
X_12941_ _05597_ _05608_ _05607_ VGND VGND VPWR VPWR _05770_ sky130_fd_sc_hd__a21oi_1
XFILLER_46_613 VPWR VGND VPWR VGND sky130_ef_sc_hd__decap_12
X_12872_ net637 _05528_ VGND VGND VPWR VPWR _05695_ sky130_fd_sc_hd__and2_1
XFILLER_65_43 VPWR VGND VPWR VGND sky130_ef_sc_hd__decap_12
XFILLER_18_359 VGND VGND VPWR VPWR sky130_fd_sc_hd__decap_4
XFILLER_65_98 VPWR VGND VPWR VGND sky130_ef_sc_hd__decap_12
XFILLER_61_605 VGND VGND VPWR VPWR sky130_fd_sc_hd__fill_2
X_11823_ _04551_ _04552_ VGND VGND VPWR VPWR _04553_ sky130_fd_sc_hd__nor2_1
XTAP_TAPCELL_ROW_16_527 VGND VPWR sky130_fd_sc_hd__tapvpwrvgnd_1
XTAP_TAPCELL_ROW_16_538 VGND VPWR sky130_fd_sc_hd__tapvpwrvgnd_1
X_11754_ _04477_ _04476_ VGND VGND VPWR VPWR _04478_ sky130_fd_sc_hd__and2b_1
X_11685_ _04400_ _04401_ VGND VGND VPWR VPWR _04403_ sky130_fd_sc_hd__xor2_1
X_10705_ _03174_ _03176_ _03331_ _03332_ VGND VGND VPWR VPWR _03333_ sky130_fd_sc_hd__a211o_1
X_13424_ _06163_ _06174_ VGND VGND VPWR VPWR _06298_ sky130_fd_sc_hd__nor2_1
X_10636_ net511 net292 net294 net503 VGND VGND VPWR VPWR _03257_ sky130_fd_sc_hd__a22o_1
XFILLER_127_412 VGND VGND VPWR VPWR sky130_fd_sc_hd__decap_8
X_13355_ net303 net284 net606 net601 VGND VGND VPWR VPWR _06222_ sky130_fd_sc_hd__and4b_1
XFILLER_10_793 VPWR VGND VPWR VGND sky130_ef_sc_hd__decap_12
X_10567_ _03179_ _03180_ _03151_ VGND VGND VPWR VPWR _03182_ sky130_fd_sc_hd__o21a_1
XFILLER_115_629 VPWR VGND VPWR VGND sky130_ef_sc_hd__decap_12
XFILLER_114_117 VPWR VGND VPWR VGND sky130_ef_sc_hd__decap_12
X_12306_ _05074_ _05075_ VGND VGND VPWR VPWR _05076_ sky130_fd_sc_hd__nor2_1
X_13286_ _05968_ _06012_ _06011_ VGND VGND VPWR VPWR _06147_ sky130_fd_sc_hd__a21oi_2
XTAP_TAPCELL_ROW_58_1137 VGND VPWR sky130_fd_sc_hd__tapvpwrvgnd_1
X_10498_ _02896_ _02952_ _02955_ _02949_ VGND VGND VPWR VPWR _03107_ sky130_fd_sc_hd__o22ai_1
X_12237_ net446 net390 VGND VGND VPWR VPWR _05001_ sky130_fd_sc_hd__nand2_1
XFILLER_123_673 VGND VGND VPWR VPWR sky130_fd_sc_hd__decap_6
XTAP_TAPCELL_ROW_71_1326 VGND VPWR sky130_fd_sc_hd__tapvpwrvgnd_1
XFILLER_69_727 VGND VGND VPWR VPWR sky130_fd_sc_hd__fill_1
XFILLER_110_323 VGND VGND VPWR VPWR sky130_fd_sc_hd__decap_8
X_12168_ _04916_ _04918_ _04920_ _04924_ VGND VGND VPWR VPWR _04927_ sky130_fd_sc_hd__o211ai_1
X_12099_ _04848_ _04850_ VGND VGND VPWR VPWR _04851_ sky130_fd_sc_hd__nor2_1
XFILLER_1_491 VGND VGND VPWR VPWR sky130_fd_sc_hd__fill_2
X_11119_ net279 _03427_ VGND VGND VPWR VPWR _03786_ sky130_fd_sc_hd__nor2_1
Xinput6 w00[4] VGND VGND VPWR VPWR net6 sky130_fd_sc_hd__buf_2
XFILLER_49_473 VGND VGND VPWR VPWR sky130_fd_sc_hd__fill_1
XFILLER_76_292 VPWR VGND VPWR VGND sky130_ef_sc_hd__decap_12
XFILLER_64_432 VGND VGND VPWR VPWR sky130_fd_sc_hd__fill_1
XFILLER_24_307 VGND VGND VPWR VPWR sky130_fd_sc_hd__fill_1
XTAP_TAPCELL_ROW_35_803 VGND VPWR sky130_fd_sc_hd__tapvpwrvgnd_1
XFILLER_36_178 VPWR VGND VPWR VGND sky130_ef_sc_hd__decap_12
XFILLER_91_273 VGND VGND VPWR VPWR sky130_fd_sc_hd__fill_2
XTAP_TAPCELL_ROW_69_1299 VGND VPWR sky130_fd_sc_hd__tapvpwrvgnd_1
X_08330_ _06658_ _00802_ VGND VGND VPWR VPWR _00804_ sky130_fd_sc_hd__nor2_1
XFILLER_51_148 VPWR VGND VPWR VGND sky130_ef_sc_hd__decap_12
XTAP_TAPCELL_ROW_82_1488 VGND VPWR sky130_fd_sc_hd__tapvpwrvgnd_1
X_08261_ _00724_ _00734_ VGND VGND VPWR VPWR _00736_ sky130_fd_sc_hd__xor2_1
XFILLER_60_682 VGND VGND VPWR VPWR sky130_fd_sc_hd__decap_4
XFILLER_20_513 VGND VGND VPWR VPWR sky130_fd_sc_hd__fill_2
X_07212_ _04286_ _04307_ _04275_ VGND VGND VPWR VPWR _05646_ sky130_fd_sc_hd__o21ba_1
X_08192_ _00559_ _00667_ VGND VGND VPWR VPWR _00668_ sky130_fd_sc_hd__xnor2_2
XFILLER_118_456 VGND VGND VPWR VPWR sky130_fd_sc_hd__decap_4
X_07143_ _04860_ _04871_ _04882_ VGND VGND VPWR VPWR _04893_ sky130_fd_sc_hd__or3_1
X_07074_ _04057_ _04090_ _04079_ VGND VGND VPWR VPWR _04145_ sky130_fd_sc_hd__o21ba_1
XFILLER_10_27 VGND VGND VPWR VPWR sky130_fd_sc_hd__fill_1
XFILLER_126_27 VGND VGND VPWR VPWR sky130_fd_sc_hd__fill_1
XFILLER_120_109 VPWR VGND VPWR VGND sky130_ef_sc_hd__decap_12
XFILLER_114_673 VGND VGND VPWR VPWR sky130_fd_sc_hd__fill_2
XFILLER_114_651 VGND VGND VPWR VPWR sky130_fd_sc_hd__fill_1
XFILLER_102_813 VGND VGND VPWR VPWR sky130_fd_sc_hd__decap_8
XFILLER_99_351 VGND VGND VPWR VPWR sky130_fd_sc_hd__decap_4
XFILLER_101_334 VGND VGND VPWR VPWR sky130_fd_sc_hd__fill_2
XFILLER_87_557 VGND VGND VPWR VPWR sky130_fd_sc_hd__decap_3
X_07976_ _00337_ _00340_ VGND VGND VPWR VPWR _00453_ sky130_fd_sc_hd__nor2_1
X_09715_ _02224_ _02256_ VGND VGND VPWR VPWR _02257_ sky130_fd_sc_hd__xor2_2
XFILLER_68_793 VPWR VGND VPWR VGND sky130_ef_sc_hd__decap_12
X_06927_ _02456_ _02521_ VGND VGND VPWR VPWR _02543_ sky130_fd_sc_hd__nand2_1
XFILLER_19_69 VPWR VGND VPWR VGND sky130_ef_sc_hd__decap_12
X_09646_ net244 _02047_ _02049_ _02051_ VGND VGND VPWR VPWR _02181_ sky130_fd_sc_hd__o31a_1
XFILLER_67_281 VGND VGND VPWR VPWR sky130_fd_sc_hd__decap_8
XFILLER_28_635 VGND VGND VPWR VPWR sky130_fd_sc_hd__decap_8
XFILLER_83_763 VGND VGND VPWR VPWR sky130_fd_sc_hd__decap_8
XFILLER_70_402 VPWR VGND VPWR VGND sky130_ef_sc_hd__decap_12
X_06858_ _01769_ _01780_ VGND VGND VPWR VPWR _01791_ sky130_fd_sc_hd__nand2_1
XFILLER_16_819 VGND VGND VPWR VPWR sky130_fd_sc_hd__fill_1
XFILLER_28_679 VGND VGND VPWR VPWR sky130_fd_sc_hd__decap_6
XTAP_TAPCELL_ROW_124_2094 VGND VPWR sky130_fd_sc_hd__tapvpwrvgnd_1
X_09577_ _02076_ _02104_ VGND VGND VPWR VPWR _02106_ sky130_fd_sc_hd__xnor2_1
XFILLER_82_273 VPWR VGND VPWR VGND sky130_ef_sc_hd__decap_12
XFILLER_43_638 VGND VGND VPWR VPWR sky130_fd_sc_hd__fill_1
XFILLER_35_57 VPWR VGND VPWR VGND sky130_ef_sc_hd__decap_12
X_08528_ _00997_ VGND VGND VPWR VPWR _00998_ sky130_fd_sc_hd__inv_2
XFILLER_51_671 VGND VGND VPWR VPWR sky130_fd_sc_hd__fill_1
X_08459_ _00928_ _00931_ VGND VGND VPWR VPWR _00932_ sky130_fd_sc_hd__and2b_1
Xclkbuf_3_3__f_clk clknet_0_clk VGND VGND VPWR VPWR clknet_3_3__leaf_clk sky130_fd_sc_hd__clkbuf_16
XPHY_EDGE_ROW_14_Right_14 VGND VGND VPWR VPWR sky130_fd_sc_hd__decap_3
XFILLER_129_3 VPWR VGND VPWR VGND sky130_ef_sc_hd__decap_12
X_11470_ _04063_ _04065_ _04167_ VGND VGND VPWR VPWR _04169_ sky130_fd_sc_hd__or3b_1
XFILLER_11_579 VPWR VGND VPWR VGND sky130_ef_sc_hd__decap_12
XFILLER_137_765 VPWR VGND VPWR VGND sky130_ef_sc_hd__decap_12
X_10421_ _03022_ VGND VGND VPWR VPWR _03023_ sky130_fd_sc_hd__inv_2
XFILLER_136_253 VPWR VGND VPWR VGND sky130_ef_sc_hd__decap_12
XFILLER_124_404 VGND VGND VPWR VPWR sky130_fd_sc_hd__decap_4
XFILLER_109_489 VGND VGND VPWR VPWR sky130_fd_sc_hd__decap_8
X_13140_ _05986_ _05987_ VGND VGND VPWR VPWR _05988_ sky130_fd_sc_hd__xnor2_1
X_10352_ _02890_ _02946_ VGND VGND VPWR VPWR _02947_ sky130_fd_sc_hd__and2_1
X_13071_ _05761_ _05764_ _05763_ VGND VGND VPWR VPWR _05912_ sky130_fd_sc_hd__o21ai_1
XFILLER_2_222 VGND VGND VPWR VPWR sky130_fd_sc_hd__fill_1
XTAP_TAPCELL_ROW_111_1905 VGND VPWR sky130_fd_sc_hd__tapvpwrvgnd_1
XFILLER_105_673 VPWR VGND VPWR VGND sky130_ef_sc_hd__decap_12
X_12022_ _04757_ _04765_ VGND VGND VPWR VPWR _04766_ sky130_fd_sc_hd__or2_1
X_10283_ net580 net311 net310 net589 VGND VGND VPWR VPWR _02872_ sky130_fd_sc_hd__a22o_1
XFILLER_2_288 VGND VGND VPWR VPWR sky130_fd_sc_hd__fill_2
XPHY_EDGE_ROW_23_Right_23 VGND VGND VPWR VPWR sky130_fd_sc_hd__decap_3
XTAP_TAPCELL_ROW_53_1067 VGND VPWR sky130_fd_sc_hd__tapvpwrvgnd_1
XFILLER_76_53 VGND VGND VPWR VPWR sky130_fd_sc_hd__decap_8
Xfanout592 net597 VGND VGND VPWR VPWR net592 sky130_fd_sc_hd__buf_2
Xfanout570 net571 VGND VGND VPWR VPWR net570 sky130_fd_sc_hd__dlymetal6s2s_1
Xfanout581 net582 VGND VGND VPWR VPWR net581 sky130_fd_sc_hd__buf_2
X_12924_ net539 net578 net659 net265 VGND VGND VPWR VPWR _05751_ sky130_fd_sc_hd__o2bb2a_1
XFILLER_18_112 VGND VGND VPWR VPWR sky130_fd_sc_hd__decap_4
XTAP_TAPCELL_ROW_109_1878 VGND VPWR sky130_fd_sc_hd__tapvpwrvgnd_1
XFILLER_73_240 VGND VGND VPWR VPWR sky130_fd_sc_hd__fill_1
XFILLER_92_41 VPWR VGND VPWR VGND sky130_ef_sc_hd__decap_12
X_12855_ _05661_ _05674_ VGND VGND VPWR VPWR _05676_ sky130_fd_sc_hd__xor2_1
XFILLER_33_126 VGND VGND VPWR VPWR sky130_fd_sc_hd__fill_1
XFILLER_92_85 VPWR VGND VPWR VGND sky130_ef_sc_hd__decap_12
X_12786_ _05455_ _05457_ _05454_ VGND VGND VPWR VPWR _05600_ sky130_fd_sc_hd__a21o_1
XFILLER_61_479 VPWR VGND VPWR VGND sky130_ef_sc_hd__decap_12
X_11806_ _04533_ _04534_ VGND VGND VPWR VPWR _04535_ sky130_fd_sc_hd__nor2_1
XPHY_EDGE_ROW_32_Right_32 VGND VGND VPWR VPWR sky130_fd_sc_hd__decap_3
X_11737_ _04451_ _04458_ VGND VGND VPWR VPWR _04459_ sky130_fd_sc_hd__xnor2_1
XFILLER_30_811 VGND VGND VPWR VPWR sky130_fd_sc_hd__fill_1
X_11668_ _04382_ _04383_ VGND VGND VPWR VPWR _04385_ sky130_fd_sc_hd__nor2_1
XTAP_TAPCELL_ROW_40_872 VGND VPWR sky130_fd_sc_hd__tapvpwrvgnd_1
X_13407_ _06139_ _06140_ _06142_ _06144_ VGND VGND VPWR VPWR _06279_ sky130_fd_sc_hd__o31a_1
X_11599_ _04306_ _04308_ VGND VGND VPWR VPWR _04309_ sky130_fd_sc_hd__and2b_1
X_10619_ _02947_ _03096_ _02919_ VGND VGND VPWR VPWR _03239_ sky130_fd_sc_hd__o21a_1
XTAP_TAPCELL_ROW_40_883 VGND VPWR sky130_fd_sc_hd__tapvpwrvgnd_1
X_13338_ _06193_ _06201_ VGND VGND VPWR VPWR _06204_ sky130_fd_sc_hd__xor2_1
XFILLER_102_109 VGND VGND VPWR VPWR sky130_fd_sc_hd__decap_8
X_13269_ net437 net428 net379 VGND VGND VPWR VPWR _06129_ sky130_fd_sc_hd__and3_1
XFILLER_44_3 VPWR VGND VPWR VGND sky130_ef_sc_hd__decap_12
XPHY_EDGE_ROW_41_Right_41 VGND VGND VPWR VPWR sky130_fd_sc_hd__decap_3
XFILLER_111_610 VGND VGND VPWR VPWR sky130_fd_sc_hd__fill_1
XFILLER_110_131 VGND VGND VPWR VPWR sky130_fd_sc_hd__decap_8
X_07830_ net697 net538 net532 net693 VGND VGND VPWR VPWR _00308_ sky130_fd_sc_hd__and4b_2
XFILLER_110_153 VPWR VGND VPWR VGND sky130_ef_sc_hd__decap_12
XFILLER_96_387 VGND VGND VPWR VPWR sky130_fd_sc_hd__decap_3
X_07761_ _00239_ _00225_ VGND VGND VPWR VPWR _00240_ sky130_fd_sc_hd__and2b_1
XFILLER_56_229 VGND VGND VPWR VPWR sky130_fd_sc_hd__decap_3
X_09500_ _01853_ _01855_ _02021_ VGND VGND VPWR VPWR _02023_ sky130_fd_sc_hd__a21o_1
XFILLER_110_197 VGND VGND VPWR VPWR sky130_fd_sc_hd__fill_2
XFILLER_49_281 VPWR VGND VPWR VGND sky130_ef_sc_hd__decap_12
XFILLER_2_83 VGND VGND VPWR VPWR sky130_fd_sc_hd__fill_1
XFILLER_37_443 VGND VGND VPWR VPWR sky130_fd_sc_hd__decap_4
XFILLER_112_29 VPWR VGND VPWR VGND sky130_ef_sc_hd__decap_12
XFILLER_112_18 VGND VGND VPWR VPWR sky130_fd_sc_hd__decap_8
XTAP_TAPCELL_ROW_84_1517 VGND VPWR sky130_fd_sc_hd__tapvpwrvgnd_1
XFILLER_65_785 VPWR VGND VPWR VGND sky130_ef_sc_hd__decap_12
XFILLER_64_251 VGND VGND VPWR VPWR sky130_fd_sc_hd__fill_1
X_07692_ net690 _06765_ _06761_ VGND VGND VPWR VPWR _00171_ sky130_fd_sc_hd__a21oi_1
X_09431_ _01931_ _01946_ VGND VGND VPWR VPWR _01947_ sky130_fd_sc_hd__xnor2_1
XFILLER_52_413 VGND VGND VPWR VPWR sky130_fd_sc_hd__decap_6
XPHY_EDGE_ROW_50_Right_50 VGND VGND VPWR VPWR sky130_fd_sc_hd__decap_3
XTAP_TAPCELL_ROW_48_994 VGND VPWR sky130_fd_sc_hd__tapvpwrvgnd_1
X_09362_ _01870_ _01871_ VGND VGND VPWR VPWR _01872_ sky130_fd_sc_hd__nor2_1
XFILLER_52_468 VGND VGND VPWR VPWR sky130_fd_sc_hd__decap_8
XFILLER_52_446 VGND VGND VPWR VPWR sky130_fd_sc_hd__decap_3
X_08313_ _00559_ _00667_ _00666_ VGND VGND VPWR VPWR _00788_ sky130_fd_sc_hd__a21oi_1
XFILLER_21_822 VGND VGND VPWR VPWR sky130_fd_sc_hd__fill_2
X_09293_ _01793_ _01794_ _01795_ VGND VGND VPWR VPWR _01797_ sky130_fd_sc_hd__a21o_1
XANTENNA_22 net448 VGND VGND VPWR VPWR sky130_fd_sc_hd__diode_2
XFILLER_20_321 VGND VGND VPWR VPWR sky130_fd_sc_hd__decap_4
XANTENNA_11 net112 VGND VGND VPWR VPWR sky130_fd_sc_hd__diode_2
X_08244_ _00691_ _00717_ VGND VGND VPWR VPWR _00719_ sky130_fd_sc_hd__xnor2_1
XFILLER_119_743 VGND VGND VPWR VPWR sky130_fd_sc_hd__decap_3
XFILLER_118_231 VGND VGND VPWR VPWR sky130_fd_sc_hd__fill_2
X_08175_ _00504_ _00650_ VGND VGND VPWR VPWR _00651_ sky130_fd_sc_hd__xor2_1
XFILLER_21_15 VPWR VGND VPWR VGND sky130_ef_sc_hd__decap_12
XFILLER_137_15 VPWR VGND VPWR VGND sky130_ef_sc_hd__decap_12
XFILLER_134_713 VPWR VGND VPWR VGND sky130_ef_sc_hd__decap_12
XFILLER_118_253 VPWR VGND VPWR VGND sky130_ef_sc_hd__decap_12
XFILLER_106_415 VGND VGND VPWR VPWR sky130_fd_sc_hd__decap_4
X_07126_ net526 net681 VGND VGND VPWR VPWR _04707_ sky130_fd_sc_hd__nand2_1
XFILLER_134_757 VPWR VGND VPWR VGND sky130_ef_sc_hd__decap_12
XFILLER_133_223 VGND VGND VPWR VPWR sky130_fd_sc_hd__fill_1
XTAP_TAPCELL_ROW_95_1679 VGND VPWR sky130_fd_sc_hd__tapvpwrvgnd_1
XFILLER_133_245 VGND VGND VPWR VPWR sky130_fd_sc_hd__fill_1
X_07057_ _03850_ _03926_ _03915_ VGND VGND VPWR VPWR _03959_ sky130_fd_sc_hd__a21oi_1
Xoutput195 net195 VGND VGND VPWR VPWR y1[9] sky130_fd_sc_hd__buf_2
Xoutput184 net184 VGND VGND VPWR VPWR y1[14] sky130_fd_sc_hd__buf_2
XFILLER_87_321 VGND VGND VPWR VPWR sky130_fd_sc_hd__fill_1
Xoutput162 net162 VGND VGND VPWR VPWR y0[0] sky130_fd_sc_hd__buf_2
Xoutput173 net173 VGND VGND VPWR VPWR y0[4] sky130_fd_sc_hd__buf_2
XFILLER_0_737 VGND VGND VPWR VPWR sky130_fd_sc_hd__fill_1
XTAP_TAPCELL_ROW_126_2123 VGND VPWR sky130_fd_sc_hd__tapvpwrvgnd_1
XFILLER_87_376 VGND VGND VPWR VPWR sky130_fd_sc_hd__fill_2
X_07959_ net563 net559 VGND VGND VPWR VPWR _00436_ sky130_fd_sc_hd__or2_4
XFILLER_47_229 VGND VGND VPWR VPWR sky130_fd_sc_hd__fill_1
XFILLER_28_410 VGND VGND VPWR VPWR sky130_fd_sc_hd__fill_1
XFILLER_28_421 VPWR VGND VPWR VGND sky130_ef_sc_hd__decap_12
XFILLER_56_785 VGND VGND VPWR VPWR sky130_fd_sc_hd__fill_1
XFILLER_56_763 VGND VGND VPWR VPWR sky130_fd_sc_hd__fill_1
X_10970_ _03267_ _03441_ _03440_ VGND VGND VPWR VPWR _03623_ sky130_fd_sc_hd__o21ba_1
X_09629_ _02073_ _02163_ VGND VGND VPWR VPWR _02164_ sky130_fd_sc_hd__xnor2_1
XFILLER_43_413 VGND VGND VPWR VPWR sky130_fd_sc_hd__decap_6
XFILLER_15_104 VGND VGND VPWR VPWR sky130_fd_sc_hd__decap_8
X_12640_ _05425_ _05441_ VGND VGND VPWR VPWR _05442_ sky130_fd_sc_hd__xor2_1
XFILLER_71_777 VGND VGND VPWR VPWR sky130_fd_sc_hd__decap_6
XTAP_TAPCELL_ROW_26_677 VGND VPWR sky130_fd_sc_hd__tapvpwrvgnd_1
X_12571_ _05337_ _05366_ VGND VGND VPWR VPWR _05367_ sky130_fd_sc_hd__and2_1
XFILLER_62_77 VGND VGND VPWR VPWR sky130_fd_sc_hd__decap_6
XFILLER_11_332 VGND VGND VPWR VPWR sky130_fd_sc_hd__decap_4
XFILLER_23_181 VGND VGND VPWR VPWR sky130_fd_sc_hd__decap_6
XFILLER_7_314 VPWR VGND VPWR VGND sky130_ef_sc_hd__decap_12
X_11522_ net521 net286 _04225_ VGND VGND VPWR VPWR _04226_ sky130_fd_sc_hd__and3_1
XTAP_TAPCELL_ROW_137_2285 VGND VPWR sky130_fd_sc_hd__tapvpwrvgnd_1
X_11453_ _04066_ _04150_ VGND VGND VPWR VPWR _04151_ sky130_fd_sc_hd__xnor2_1
XFILLER_7_39 VPWR VGND VPWR VGND sky130_ef_sc_hd__decap_12
Xwire234 _03192_ VGND VGND VPWR VPWR net234 sky130_fd_sc_hd__clkbuf_1
XFILLER_125_713 VGND VGND VPWR VPWR sky130_fd_sc_hd__decap_3
XFILLER_125_702 VGND VGND VPWR VPWR sky130_fd_sc_hd__fill_1
XPHY_EDGE_ROW_12_Left_151 VGND VGND VPWR VPWR sky130_fd_sc_hd__decap_3
X_10404_ _02995_ _03002_ _03003_ VGND VGND VPWR VPWR _03004_ sky130_fd_sc_hd__and3_1
X_13123_ _05822_ _05827_ _05826_ VGND VGND VPWR VPWR _05969_ sky130_fd_sc_hd__o21ai_2
X_11384_ _04072_ _04073_ VGND VGND VPWR VPWR _04075_ sky130_fd_sc_hd__xnor2_1
X_10335_ _02923_ _02927_ VGND VGND VPWR VPWR _02928_ sky130_fd_sc_hd__or2_1
XFILLER_3_553 VGND VGND VPWR VPWR sky130_fd_sc_hd__decap_6
XFILLER_11_81 VPWR VGND VPWR VGND sky130_ef_sc_hd__decap_12
XFILLER_127_81 VPWR VGND VPWR VGND sky130_ef_sc_hd__decap_12
X_13054_ _05779_ _05812_ _05811_ VGND VGND VPWR VPWR _05893_ sky130_fd_sc_hd__a21oi_1
X_10266_ _02849_ _02852_ VGND VGND VPWR VPWR _02853_ sky130_fd_sc_hd__xnor2_1
X_12005_ _04746_ _04747_ VGND VGND VPWR VPWR _04748_ sky130_fd_sc_hd__or2_1
X_10197_ _02774_ _02780_ VGND VGND VPWR VPWR _02781_ sky130_fd_sc_hd__xnor2_1
XFILLER_78_365 VPWR VGND VPWR VGND sky130_ef_sc_hd__decap_12
XTAP_TAPCELL_ROW_6_380 VGND VPWR sky130_fd_sc_hd__tapvpwrvgnd_1
XTAP_TAPCELL_ROW_6_391 VGND VPWR sky130_fd_sc_hd__tapvpwrvgnd_1
XFILLER_19_410 VPWR VGND VPWR VGND sky130_ef_sc_hd__decap_12
XPHY_EDGE_ROW_21_Left_160 VGND VGND VPWR VPWR sky130_fd_sc_hd__decap_3
XFILLER_46_251 VGND VGND VPWR VPWR sky130_fd_sc_hd__fill_1
X_12907_ _05402_ _05574_ _05573_ VGND VGND VPWR VPWR _05732_ sky130_fd_sc_hd__a21o_1
XFILLER_47_785 VPWR VGND VPWR VGND sky130_ef_sc_hd__decap_12
XFILLER_19_487 VGND VGND VPWR VPWR sky130_fd_sc_hd__decap_6
X_12838_ _05621_ _05655_ VGND VGND VPWR VPWR _05658_ sky130_fd_sc_hd__xnor2_1
XTAP_TAPCELL_ROW_66_1258 VGND VPWR sky130_fd_sc_hd__tapvpwrvgnd_1
XFILLER_62_755 VGND VGND VPWR VPWR sky130_fd_sc_hd__fill_1
XTAP_TAPCELL_ROW_45_953 VGND VPWR sky130_fd_sc_hd__tapvpwrvgnd_1
XFILLER_62_799 VPWR VGND VPWR VGND sky130_ef_sc_hd__decap_12
X_12769_ net548 net578 VGND VGND VPWR VPWR _05582_ sky130_fd_sc_hd__nand2_1
Xinput20 w02[2] VGND VGND VPWR VPWR net20 sky130_fd_sc_hd__buf_1
Xinput31 w03[5] VGND VGND VPWR VPWR net31 sky130_fd_sc_hd__clkbuf_4
Xinput42 w11[0] VGND VGND VPWR VPWR net42 sky130_fd_sc_hd__dlymetal6s2s_1
Xinput53 w12[3] VGND VGND VPWR VPWR net53 sky130_fd_sc_hd__clkbuf_2
Xinput64 w13[6] VGND VGND VPWR VPWR net64 sky130_fd_sc_hd__clkbuf_2
XFILLER_116_757 VPWR VGND VPWR VGND sky130_ef_sc_hd__decap_12
XFILLER_115_223 VGND VGND VPWR VPWR sky130_fd_sc_hd__fill_1
Xinput97 w23[7] VGND VGND VPWR VPWR net97 sky130_fd_sc_hd__buf_1
Xinput86 w22[4] VGND VGND VPWR VPWR net86 sky130_fd_sc_hd__buf_1
Xinput75 w21[1] VGND VGND VPWR VPWR net75 sky130_fd_sc_hd__clkbuf_1
X_09980_ _02371_ _02378_ _02377_ VGND VGND VPWR VPWR _02546_ sky130_fd_sc_hd__a21oi_1
X_08931_ _01400_ _01401_ VGND VGND VPWR VPWR _01402_ sky130_fd_sc_hd__or2_1
XFILLER_115_289 VGND VGND VPWR VPWR sky130_fd_sc_hd__fill_1
XFILLER_130_248 VGND VGND VPWR VPWR sky130_fd_sc_hd__decap_4
X_08862_ _01319_ _01326_ _01327_ VGND VGND VPWR VPWR _01328_ sky130_fd_sc_hd__nand3_2
XFILLER_85_803 VGND VGND VPWR VPWR sky130_fd_sc_hd__fill_1
XTAP_TAPCELL_ROW_90_1598 VGND VPWR sky130_fd_sc_hd__tapvpwrvgnd_1
X_07813_ _00290_ _00291_ VGND VGND VPWR VPWR _00053_ sky130_fd_sc_hd__xor2_1
X_08793_ _01096_ _01098_ VGND VGND VPWR VPWR _01259_ sky130_fd_sc_hd__nor2_1
XFILLER_123_39 VPWR VGND VPWR VGND sky130_ef_sc_hd__decap_12
X_07744_ _00190_ _00222_ VGND VGND VPWR VPWR _00223_ sky130_fd_sc_hd__xor2_2
XFILLER_53_722 VGND VGND VPWR VPWR sky130_fd_sc_hd__decap_6
XFILLER_16_15 VPWR VGND VPWR VGND sky130_ef_sc_hd__decap_12
X_07675_ _00152_ _00153_ VGND VGND VPWR VPWR _00154_ sky130_fd_sc_hd__nor2_1
X_09414_ _01924_ _01926_ _01927_ VGND VGND VPWR VPWR _01928_ sky130_fd_sc_hd__and3_1
XTAP_TAPCELL_ROW_121_2053 VGND VPWR sky130_fd_sc_hd__tapvpwrvgnd_1
XFILLER_80_541 VGND VGND VPWR VPWR sky130_fd_sc_hd__fill_1
XFILLER_53_777 VGND VGND VPWR VPWR sky130_fd_sc_hd__decap_6
XFILLER_25_468 VGND VGND VPWR VPWR sky130_fd_sc_hd__decap_3
X_09345_ _01850_ _01851_ _01676_ _01678_ VGND VGND VPWR VPWR _01854_ sky130_fd_sc_hd__a211oi_1
XTAP_TAPCELL_ROW_23_636 VGND VPWR sky130_fd_sc_hd__tapvpwrvgnd_1
XFILLER_138_315 VGND VGND VPWR VPWR sky130_fd_sc_hd__decap_3
X_09276_ _01777_ _01745_ VGND VGND VPWR VPWR _01778_ sky130_fd_sc_hd__and2b_1
XFILLER_21_641 VPWR VGND VPWR VGND sky130_ef_sc_hd__decap_12
XFILLER_138_337 VPWR VGND VPWR VGND sky130_ef_sc_hd__decap_12
XTAP_TAPCELL_ROW_97_1708 VGND VPWR sky130_fd_sc_hd__tapvpwrvgnd_1
X_08227_ _00482_ _00604_ VGND VGND VPWR VPWR _00702_ sky130_fd_sc_hd__nand2_1
XFILLER_119_573 VPWR VGND VPWR VGND sky130_ef_sc_hd__decap_12
XFILLER_107_724 VGND VGND VPWR VPWR sky130_fd_sc_hd__decap_4
X_08158_ _00629_ _00633_ VGND VGND VPWR VPWR _00634_ sky130_fd_sc_hd__nand2b_1
XFILLER_134_565 VGND VGND VPWR VPWR sky130_fd_sc_hd__fill_2
X_07109_ _04264_ _04515_ VGND VGND VPWR VPWR _04526_ sky130_fd_sc_hd__nor2_1
X_08089_ net545 net688 _00437_ VGND VGND VPWR VPWR _00565_ sky130_fd_sc_hd__a21oi_1
X_10120_ _02694_ _02696_ VGND VGND VPWR VPWR _02698_ sky130_fd_sc_hd__xnor2_1
XFILLER_106_267 VGND VGND VPWR VPWR sky130_fd_sc_hd__decap_8
XFILLER_121_237 VPWR VGND VPWR VGND sky130_ef_sc_hd__decap_12
X_10051_ _02609_ _02621_ VGND VGND VPWR VPWR _02623_ sky130_fd_sc_hd__or2_1
XFILLER_88_685 VGND VGND VPWR VPWR sky130_fd_sc_hd__decap_4
XTAP_TAPCELL_ROW_50_1026 VGND VPWR sky130_fd_sc_hd__tapvpwrvgnd_1
XFILLER_0_589 VGND VGND VPWR VPWR sky130_fd_sc_hd__fill_2
XFILLER_130_793 VPWR VGND VPWR VGND sky130_ef_sc_hd__decap_12
XFILLER_57_55 VGND VGND VPWR VPWR sky130_fd_sc_hd__fill_1
XFILLER_29_741 VPWR VGND VPWR VGND sky130_ef_sc_hd__decap_12
XTAP_TAPCELL_ROW_106_1837 VGND VPWR sky130_fd_sc_hd__tapvpwrvgnd_1
XFILLER_90_327 VPWR VGND VPWR VGND sky130_ef_sc_hd__decap_12
XFILLER_56_582 VGND VGND VPWR VPWR sky130_fd_sc_hd__fill_1
X_10953_ _03602_ _03603_ VGND VGND VPWR VPWR _03604_ sky130_fd_sc_hd__and2b_1
XFILLER_29_785 VPWR VGND VPWR VGND sky130_ef_sc_hd__decap_12
XTAP_TAPCELL_ROW_42_912 VGND VPWR sky130_fd_sc_hd__tapvpwrvgnd_1
XTAP_TAPCELL_ROW_42_901 VGND VPWR sky130_fd_sc_hd__tapvpwrvgnd_1
X_10884_ _03525_ _03526_ VGND VGND VPWR VPWR _03529_ sky130_fd_sc_hd__xnor2_1
X_13672_ clknet_3_2__leaf_clk _00020_ net712 VGND VGND VPWR VPWR net207 sky130_fd_sc_hd__dfrtp_1
X_12623_ _05420_ _05421_ VGND VGND VPWR VPWR _05423_ sky130_fd_sc_hd__xor2_1
XFILLER_43_298 VGND VGND VPWR VPWR sky130_fd_sc_hd__decap_3
XFILLER_12_630 VGND VGND VPWR VPWR sky130_fd_sc_hd__fill_1
XFILLER_31_438 VGND VGND VPWR VPWR sky130_fd_sc_hd__decap_8
XFILLER_31_449 VGND VGND VPWR VPWR sky130_fd_sc_hd__decap_8
XFILLER_129_315 VGND VGND VPWR VPWR sky130_fd_sc_hd__decap_6
X_12554_ net652 net285 net412 VGND VGND VPWR VPWR _05348_ sky130_fd_sc_hd__a21oi_1
XTAP_TAPCELL_ROW_61_1188 VGND VPWR sky130_fd_sc_hd__tapvpwrvgnd_1
XTAP_TAPCELL_ROW_61_1177 VGND VPWR sky130_fd_sc_hd__tapvpwrvgnd_1
XFILLER_8_645 VGND VGND VPWR VPWR sky130_fd_sc_hd__decap_4
X_11505_ _04206_ _04171_ VGND VGND VPWR VPWR _04207_ sky130_fd_sc_hd__and2b_1
XFILLER_11_162 VGND VGND VPWR VPWR sky130_fd_sc_hd__decap_6
XFILLER_11_173 VGND VGND VPWR VPWR sky130_fd_sc_hd__fill_1
X_12485_ _05224_ _05271_ VGND VGND VPWR VPWR _05272_ sky130_fd_sc_hd__nand2_1
XFILLER_125_532 VGND VGND VPWR VPWR sky130_fd_sc_hd__fill_1
X_11436_ _03455_ _04131_ VGND VGND VPWR VPWR _04132_ sky130_fd_sc_hd__nand2_1
XTAP_TAPCELL_ROW_117_1999 VGND VPWR sky130_fd_sc_hd__tapvpwrvgnd_1
X_11367_ _04047_ _04055_ VGND VGND VPWR VPWR _04056_ sky130_fd_sc_hd__xnor2_1
X_13106_ _05948_ _05949_ VGND VGND VPWR VPWR _05950_ sky130_fd_sc_hd__or2_1
X_10318_ net588 net306 net308 net579 VGND VGND VPWR VPWR _02910_ sky130_fd_sc_hd__a22oi_1
X_13037_ _05872_ _05873_ VGND VGND VPWR VPWR _05875_ sky130_fd_sc_hd__xor2_1
XFILLER_79_641 VPWR VGND VPWR VGND sky130_ef_sc_hd__decap_12
X_11298_ net314 _00259_ _03836_ VGND VGND VPWR VPWR _03982_ sky130_fd_sc_hd__nand3_2
XFILLER_121_771 VGND VGND VPWR VPWR sky130_fd_sc_hd__fill_1
X_10249_ _02803_ _02832_ VGND VGND VPWR VPWR _02836_ sky130_fd_sc_hd__nand2_1
XFILLER_39_505 VGND VGND VPWR VPWR sky130_fd_sc_hd__decap_8
XFILLER_93_143 VPWR VGND VPWR VGND sky130_ef_sc_hd__decap_12
XTAP_TAPCELL_ROW_1_309 VGND VPWR sky130_fd_sc_hd__tapvpwrvgnd_1
XFILLER_94_699 VGND VGND VPWR VPWR sky130_fd_sc_hd__fill_1
XFILLER_81_316 VPWR VGND VPWR VGND sky130_ef_sc_hd__decap_12
XFILLER_19_273 VGND VGND VPWR VPWR sky130_fd_sc_hd__decap_3
XFILLER_34_243 VGND VGND VPWR VPWR sky130_fd_sc_hd__decap_6
X_07460_ _06687_ _06688_ net644 net104 VGND VGND VPWR VPWR _06690_ sky130_fd_sc_hd__and4bb_1
XFILLER_62_574 VGND VGND VPWR VPWR sky130_fd_sc_hd__decap_4
X_07391_ _06576_ _06620_ VGND VGND VPWR VPWR _06621_ sky130_fd_sc_hd__nand2_1
X_09130_ net616 net608 net375 net374 VGND VGND VPWR VPWR _01619_ sky130_fd_sc_hd__and4_1
X_09061_ _01375_ _01379_ _01543_ VGND VGND VPWR VPWR _01544_ sky130_fd_sc_hd__a21o_1
XFILLER_135_318 VGND VGND VPWR VPWR sky130_fd_sc_hd__decap_6
XTAP_TAPCELL_ROW_79_1449 VGND VPWR sky130_fd_sc_hd__tapvpwrvgnd_1
XTAP_TAPCELL_ROW_79_1438 VGND VPWR sky130_fd_sc_hd__tapvpwrvgnd_1
X_08012_ _06633_ _00488_ VGND VGND VPWR VPWR _00489_ sky130_fd_sc_hd__xnor2_1
XFILLER_128_370 VGND VGND VPWR VPWR sky130_fd_sc_hd__fill_2
XTAP_TAPCELL_ROW_92_1627 VGND VPWR sky130_fd_sc_hd__tapvpwrvgnd_1
XFILLER_89_405 VPWR VGND VPWR VGND sky130_ef_sc_hd__decap_12
X_09963_ _02411_ _02421_ _02420_ VGND VGND VPWR VPWR _02527_ sky130_fd_sc_hd__a21oi_1
XTAP_TAPCELL_ROW_92_1638 VGND VPWR sky130_fd_sc_hd__tapvpwrvgnd_1
XPHY_EDGE_ROW_4_Right_4 VGND VGND VPWR VPWR sky130_fd_sc_hd__decap_3
X_08914_ _01381_ _01382_ VGND VGND VPWR VPWR _01383_ sky130_fd_sc_hd__or2_1
XFILLER_104_749 VGND VGND VPWR VPWR sky130_fd_sc_hd__decap_6
XFILLER_103_237 VGND VGND VPWR VPWR sky130_fd_sc_hd__fill_1
XFILLER_89_449 VPWR VGND VPWR VGND sky130_ef_sc_hd__decap_12
X_09894_ _02180_ _02317_ _02451_ VGND VGND VPWR VPWR _02452_ sky130_fd_sc_hd__o21ai_1
XFILLER_134_27 VGND VGND VPWR VPWR sky130_fd_sc_hd__fill_1
XFILLER_103_259 VGND VGND VPWR VPWR sky130_fd_sc_hd__fill_1
XFILLER_112_793 VPWR VGND VPWR VGND sky130_ef_sc_hd__decap_12
X_08845_ _01309_ _01310_ VGND VGND VPWR VPWR _01311_ sky130_fd_sc_hd__nand2_1
XFILLER_111_281 VGND VGND VPWR VPWR sky130_fd_sc_hd__decap_4
X_08776_ _01241_ _01242_ VGND VGND VPWR VPWR _01243_ sky130_fd_sc_hd__and2b_1
XTAP_TAPCELL_ROW_28_706 VGND VPWR sky130_fd_sc_hd__tapvpwrvgnd_1
XFILLER_72_305 VGND VGND VPWR VPWR sky130_fd_sc_hd__decap_3
X_07727_ _00204_ _00205_ VGND VGND VPWR VPWR _00206_ sky130_fd_sc_hd__nand2b_1
XFILLER_38_571 VPWR VGND VPWR VGND sky130_ef_sc_hd__decap_12
XFILLER_72_349 VGND VGND VPWR VPWR sky130_fd_sc_hd__fill_1
X_07658_ _00135_ _00136_ _06574_ VGND VGND VPWR VPWR _00138_ sky130_fd_sc_hd__o21ai_1
XFILLER_25_243 VGND VGND VPWR VPWR sky130_fd_sc_hd__fill_1
X_07589_ _06526_ _06684_ _06683_ VGND VGND VPWR VPWR _00069_ sky130_fd_sc_hd__a21o_1
XFILLER_13_438 VGND VGND VPWR VPWR sky130_fd_sc_hd__decap_8
XFILLER_13_449 VPWR VGND VPWR VGND sky130_ef_sc_hd__decap_12
XFILLER_40_213 VGND VGND VPWR VPWR sky130_fd_sc_hd__fill_1
X_09328_ _01832_ _01833_ _01654_ _01656_ VGND VGND VPWR VPWR _01836_ sky130_fd_sc_hd__a211o_1
XTAP_TAPCELL_ROW_101_1767 VGND VPWR sky130_fd_sc_hd__tapvpwrvgnd_1
XFILLER_43_57 VPWR VGND VPWR VGND sky130_ef_sc_hd__decap_12
XFILLER_126_307 VGND VGND VPWR VPWR sky130_fd_sc_hd__fill_1
X_09259_ _01759_ _01757_ VGND VGND VPWR VPWR _01760_ sky130_fd_sc_hd__and2b_1
XTAP_TAPCELL_ROW_134_2244 VGND VPWR sky130_fd_sc_hd__tapvpwrvgnd_1
X_12270_ _05033_ _05034_ _05036_ VGND VGND VPWR VPWR _05038_ sky130_fd_sc_hd__nand3_1
X_11221_ _03894_ _03895_ VGND VGND VPWR VPWR _03897_ sky130_fd_sc_hd__xnor2_1
XFILLER_122_502 VGND VGND VPWR VPWR sky130_fd_sc_hd__decap_4
XTAP_TAPCELL_ROW_8_420 VGND VPWR sky130_fd_sc_hd__tapvpwrvgnd_1
XFILLER_4_29 VPWR VGND VPWR VGND sky130_ef_sc_hd__decap_12
X_11152_ net602 net322 VGND VGND VPWR VPWR _03822_ sky130_fd_sc_hd__nand2_1
X_10103_ _02677_ _02678_ VGND VGND VPWR VPWR _02680_ sky130_fd_sc_hd__and2_1
XFILLER_108_83 VGND VGND VPWR VPWR sky130_fd_sc_hd__fill_1
XFILLER_1_821 VGND VGND VPWR VPWR sky130_fd_sc_hd__decap_3
XFILLER_122_579 VGND VGND VPWR VPWR sky130_fd_sc_hd__fill_2
XFILLER_110_708 VGND VGND VPWR VPWR sky130_fd_sc_hd__decap_4
XFILLER_76_611 VGND VGND VPWR VPWR sky130_fd_sc_hd__decap_8
XFILLER_68_65 VPWR VGND VPWR VGND sky130_ef_sc_hd__decap_12
X_11083_ _03743_ net249 VGND VGND VPWR VPWR _03746_ sky130_fd_sc_hd__xor2_1
X_10034_ _02602_ _02603_ VGND VGND VPWR VPWR _02604_ sky130_fd_sc_hd__nand2b_1
XFILLER_75_110 VGND VGND VPWR VPWR sky130_fd_sc_hd__fill_2
XFILLER_48_313 VGND VGND VPWR VPWR sky130_fd_sc_hd__fill_1
XFILLER_48_346 VPWR VGND VPWR VGND sky130_ef_sc_hd__decap_12
XFILLER_84_53 VPWR VGND VPWR VGND sky130_ef_sc_hd__decap_12
XFILLER_76_688 VGND VGND VPWR VPWR sky130_fd_sc_hd__decap_6
XFILLER_75_176 VPWR VGND VPWR VGND sky130_ef_sc_hd__decap_12
XFILLER_63_316 VGND VGND VPWR VPWR sky130_fd_sc_hd__decap_3
XFILLER_17_700 VGND VGND VPWR VPWR sky130_fd_sc_hd__decap_3
XFILLER_29_582 VGND VGND VPWR VPWR sky130_fd_sc_hd__fill_2
X_11985_ net523 net406 _04664_ VGND VGND VPWR VPWR _04726_ sky130_fd_sc_hd__and3_1
XFILLER_44_530 VGND VGND VPWR VPWR sky130_fd_sc_hd__fill_2
XFILLER_90_168 VGND VGND VPWR VPWR sky130_fd_sc_hd__fill_2
XTAP_TAPCELL_ROW_63_1217 VGND VPWR sky130_fd_sc_hd__tapvpwrvgnd_1
XTAP_TAPCELL_ROW_63_1206 VGND VPWR sky130_fd_sc_hd__tapvpwrvgnd_1
X_10936_ _03584_ _03583_ VGND VGND VPWR VPWR _03585_ sky130_fd_sc_hd__nand2b_1
XFILLER_16_265 VGND VGND VPWR VPWR sky130_fd_sc_hd__decap_8
XFILLER_17_766 VPWR VGND VPWR VGND sky130_ef_sc_hd__decap_12
X_13655_ clknet_3_7__leaf_clk _00062_ net717 VGND VGND VPWR VPWR net190 sky130_fd_sc_hd__dfrtp_1
XFILLER_71_393 VGND VGND VPWR VPWR sky130_fd_sc_hd__fill_1
X_10867_ _03508_ _03509_ VGND VGND VPWR VPWR _03510_ sky130_fd_sc_hd__nand2b_1
X_12606_ _05402_ _05403_ VGND VGND VPWR VPWR _05404_ sky130_fd_sc_hd__or2_1
XFILLER_32_769 VPWR VGND VPWR VGND sky130_ef_sc_hd__decap_12
X_13586_ _06468_ _06473_ VGND VGND VPWR VPWR _06474_ sky130_fd_sc_hd__xnor2_1
XFILLER_12_460 VGND VGND VPWR VPWR sky130_fd_sc_hd__fill_1
X_10798_ net416 net283 _03285_ _03284_ VGND VGND VPWR VPWR _03435_ sky130_fd_sc_hd__a31o_1
XFILLER_31_279 VGND VGND VPWR VPWR sky130_fd_sc_hd__fill_1
XFILLER_129_167 VGND VGND VPWR VPWR sky130_fd_sc_hd__fill_1
X_12537_ _05150_ _05153_ _05152_ VGND VGND VPWR VPWR _05329_ sky130_fd_sc_hd__o21bai_1
XFILLER_8_453 VGND VGND VPWR VPWR sky130_fd_sc_hd__fill_2
XTAP_TAPCELL_ROW_14_499 VGND VPWR sky130_fd_sc_hd__tapvpwrvgnd_1
XFILLER_33_90 VGND VGND VPWR VPWR sky130_fd_sc_hd__decap_3
X_12468_ net572 net577 _05093_ _05092_ VGND VGND VPWR VPWR _05254_ sky130_fd_sc_hd__a31o_1
XFILLER_8_475 VGND VGND VPWR VPWR sky130_fd_sc_hd__fill_1
X_11419_ _04104_ _04113_ VGND VGND VPWR VPWR _04114_ sky130_fd_sc_hd__nand2_1
XFILLER_113_524 VGND VGND VPWR VPWR sky130_fd_sc_hd__decap_4
X_12399_ net639 net6 VGND VGND VPWR VPWR _05179_ sky130_fd_sc_hd__nand2_1
XFILLER_113_557 VGND VGND VPWR VPWR sky130_fd_sc_hd__decap_3
XTAP_TAPCELL_ROW_74_1379 VGND VPWR sky130_fd_sc_hd__tapvpwrvgnd_1
XTAP_TAPCELL_ROW_74_1368 VGND VPWR sky130_fd_sc_hd__tapvpwrvgnd_1
X_06960_ net106 net562 _02887_ VGND VGND VPWR VPWR _02898_ sky130_fd_sc_hd__and3_1
XFILLER_3_191 VPWR VGND VPWR VGND sky130_ef_sc_hd__decap_12
X_06891_ _01703_ _02140_ VGND VGND VPWR VPWR _02151_ sky130_fd_sc_hd__or2_1
XFILLER_39_324 VPWR VGND VPWR VGND sky130_ef_sc_hd__decap_12
X_08630_ net595 net359 net362 net585 VGND VGND VPWR VPWR _01097_ sky130_fd_sc_hd__a22oi_1
XFILLER_104_19 VGND VGND VPWR VPWR sky130_fd_sc_hd__decap_8
XFILLER_39_368 VPWR VGND VPWR VGND sky130_ef_sc_hd__decap_12
XFILLER_66_165 VGND VGND VPWR VPWR sky130_fd_sc_hd__decap_4
X_08561_ _01028_ _01029_ VGND VGND VPWR VPWR _01030_ sky130_fd_sc_hd__nand2_1
XFILLER_35_541 VPWR VGND VPWR VGND sky130_ef_sc_hd__decap_12
XFILLER_120_29 VPWR VGND VPWR VGND sky130_ef_sc_hd__decap_12
X_08492_ _00891_ _00894_ VGND VGND VPWR VPWR _00965_ sky130_fd_sc_hd__nand2_1
X_07512_ net702 net700 net538 net532 VGND VGND VPWR VPWR _06741_ sky130_fd_sc_hd__and4b_1
X_07443_ _06671_ _06672_ VGND VGND VPWR VPWR _06673_ sky130_fd_sc_hd__nand2_1
XFILLER_50_533 VPWR VGND VPWR VGND sky130_ef_sc_hd__decap_12
XFILLER_23_769 VPWR VGND VPWR VGND sky130_ef_sc_hd__decap_12
X_09113_ _01597_ _01598_ _01599_ VGND VGND VPWR VPWR _01600_ sky130_fd_sc_hd__nand3_1
X_07374_ net685 net494 net486 net686 VGND VGND VPWR VPWR _06604_ sky130_fd_sc_hd__a22oi_1
XFILLER_10_419 VGND VGND VPWR VPWR sky130_fd_sc_hd__fill_1
XFILLER_13_27 VPWR VGND VPWR VGND sky130_ef_sc_hd__decap_12
XTAP_TAPCELL_ROW_33_775 VGND VPWR sky130_fd_sc_hd__tapvpwrvgnd_1
XFILLER_129_27 VPWR VGND VPWR VGND sky130_ef_sc_hd__decap_12
X_09044_ _01372_ _01522_ _01524_ VGND VGND VPWR VPWR _01525_ sky130_fd_sc_hd__o21ai_1
XFILLER_135_137 VPWR VGND VPWR VGND sky130_ef_sc_hd__decap_12
XFILLER_132_811 VGND VGND VPWR VPWR sky130_fd_sc_hd__fill_1
X_09946_ _02506_ _02507_ VGND VGND VPWR VPWR _02508_ sky130_fd_sc_hd__and2_1
XFILLER_89_279 VGND VGND VPWR VPWR sky130_fd_sc_hd__fill_1
X_09877_ _02305_ _02307_ _02431_ VGND VGND VPWR VPWR _02433_ sky130_fd_sc_hd__nand3_1
XFILLER_100_752 VGND VGND VPWR VPWR sky130_fd_sc_hd__decap_4
XFILLER_85_452 VPWR VGND VPWR VGND sky130_ef_sc_hd__decap_12
XFILLER_57_121 VGND VGND VPWR VPWR sky130_fd_sc_hd__fill_2
X_08828_ _01272_ _01292_ VGND VGND VPWR VPWR _01294_ sky130_fd_sc_hd__and2b_1
XPHY_EDGE_ROW_79_Right_79 VGND VGND VPWR VPWR sky130_fd_sc_hd__decap_3
XFILLER_73_614 VGND VGND VPWR VPWR sky130_fd_sc_hd__fill_2
XFILLER_57_154 VGND VGND VPWR VPWR sky130_fd_sc_hd__fill_1
XFILLER_45_316 VPWR VGND VPWR VGND sky130_ef_sc_hd__decap_12
X_08759_ _01222_ _01223_ _01125_ VGND VGND VPWR VPWR _01226_ sky130_fd_sc_hd__a21oi_1
XFILLER_61_809 VGND VGND VPWR VPWR sky130_fd_sc_hd__decap_8
X_11770_ _04323_ _04338_ _04337_ VGND VGND VPWR VPWR _04496_ sky130_fd_sc_hd__o21ai_1
XFILLER_53_393 VPWR VGND VPWR VGND sky130_ef_sc_hd__decap_12
XFILLER_53_382 VGND VGND VPWR VPWR sky130_fd_sc_hd__decap_8
XFILLER_41_522 VPWR VGND VPWR VGND sky130_ef_sc_hd__decap_12
XFILLER_13_202 VGND VGND VPWR VPWR sky130_fd_sc_hd__decap_6
XFILLER_14_747 VGND VGND VPWR VPWR sky130_fd_sc_hd__decap_8
X_10721_ _03349_ _03346_ _03101_ _03104_ VGND VGND VPWR VPWR _03351_ sky130_fd_sc_hd__a211oi_2
XFILLER_26_596 VPWR VGND VPWR VGND sky130_ef_sc_hd__decap_12
X_13440_ _06218_ _06313_ VGND VGND VPWR VPWR _06315_ sky130_fd_sc_hd__xnor2_1
XFILLER_9_206 VGND VGND VPWR VPWR sky130_fd_sc_hd__decap_8
XFILLER_14_769 VGND VGND VPWR VPWR sky130_fd_sc_hd__fill_2
XFILLER_41_577 VGND VGND VPWR VPWR sky130_fd_sc_hd__fill_1
X_10652_ _03265_ _03273_ VGND VGND VPWR VPWR _03275_ sky130_fd_sc_hd__xor2_1
X_13371_ _06119_ _06121_ _06239_ VGND VGND VPWR VPWR _06240_ sky130_fd_sc_hd__o21ai_1
XFILLER_70_77 VGND VGND VPWR VPWR sky130_fd_sc_hd__decap_6
X_10583_ _03198_ _03199_ VGND VGND VPWR VPWR _03200_ sky130_fd_sc_hd__and2_1
XFILLER_127_649 VGND VGND VPWR VPWR sky130_fd_sc_hd__decap_8
XFILLER_127_638 VGND VGND VPWR VPWR sky130_fd_sc_hd__decap_6
X_12322_ _05092_ _05093_ VGND VGND VPWR VPWR _05094_ sky130_fd_sc_hd__and2b_1
XPHY_EDGE_ROW_88_Right_88 VGND VGND VPWR VPWR sky130_fd_sc_hd__decap_3
XFILLER_5_401 VGND VGND VPWR VPWR sky130_fd_sc_hd__decap_4
XTAP_TAPCELL_ROW_11_458 VGND VPWR sky130_fd_sc_hd__tapvpwrvgnd_1
X_12253_ net615 net404 VGND VGND VPWR VPWR _05019_ sky130_fd_sc_hd__nand2_1
XFILLER_135_682 VPWR VGND VPWR VGND sky130_ef_sc_hd__decap_12
XFILLER_119_93 VPWR VGND VPWR VGND sky130_ef_sc_hd__decap_12
XTAP_TAPCELL_ROW_114_1947 VGND VPWR sky130_fd_sc_hd__tapvpwrvgnd_1
XFILLER_107_373 VGND VGND VPWR VPWR sky130_fd_sc_hd__fill_1
XFILLER_79_53 VGND VGND VPWR VPWR sky130_fd_sc_hd__decap_3
X_11204_ _03738_ _03755_ _03754_ VGND VGND VPWR VPWR _03878_ sky130_fd_sc_hd__o21a_1
XTAP_TAPCELL_ROW_114_1958 VGND VPWR sky130_fd_sc_hd__tapvpwrvgnd_1
X_12184_ net556 net696 net680 net565 VGND VGND VPWR VPWR _04943_ sky130_fd_sc_hd__a22oi_1
XFILLER_79_86 VGND VGND VPWR VPWR sky130_fd_sc_hd__decap_6
XFILLER_110_516 VPWR VGND VPWR VGND sky130_ef_sc_hd__decap_12
XFILLER_96_717 VGND VGND VPWR VPWR sky130_fd_sc_hd__fill_2
X_11135_ net433 net424 net276 net274 VGND VGND VPWR VPWR _03803_ sky130_fd_sc_hd__and4_1
XFILLER_135_81 VPWR VGND VPWR VGND sky130_ef_sc_hd__decap_12
XFILLER_122_376 VGND VGND VPWR VPWR sky130_fd_sc_hd__fill_1
XFILLER_95_238 VGND VGND VPWR VPWR sky130_fd_sc_hd__decap_8
XFILLER_49_611 VGND VGND VPWR VPWR sky130_fd_sc_hd__fill_2
X_11066_ _03725_ _03726_ VGND VGND VPWR VPWR _03727_ sky130_fd_sc_hd__and2_1
X_10017_ _02496_ _02582_ VGND VGND VPWR VPWR _02585_ sky130_fd_sc_hd__nor2_1
XPHY_EDGE_ROW_97_Right_97 VGND VGND VPWR VPWR sky130_fd_sc_hd__decap_3
XFILLER_76_452 VPWR VGND VPWR VGND sky130_ef_sc_hd__decap_12
XFILLER_63_113 VPWR VGND VPWR VGND sky130_ef_sc_hd__decap_12
XFILLER_52_809 VGND VGND VPWR VPWR sky130_fd_sc_hd__decap_3
XTAP_TAPCELL_ROW_19_569 VGND VPWR sky130_fd_sc_hd__tapvpwrvgnd_1
X_11968_ _04703_ _04706_ VGND VGND VPWR VPWR _04708_ sky130_fd_sc_hd__xnor2_1
X_10919_ _03251_ _03396_ _03398_ _03393_ VGND VGND VPWR VPWR _03567_ sky130_fd_sc_hd__o2bb2a_1
X_11899_ _04453_ _04553_ _04551_ VGND VGND VPWR VPWR _04636_ sky130_fd_sc_hd__a21oi_1
X_13638_ clknet_3_6__leaf_clk _00034_ net716 VGND VGND VPWR VPWR net173 sky130_fd_sc_hd__dfrtp_1
XPHY_EDGE_ROW_4_Left_143 VGND VGND VPWR VPWR sky130_fd_sc_hd__decap_3
XFILLER_118_616 VGND VGND VPWR VPWR sky130_fd_sc_hd__fill_1
X_13569_ _06375_ _06379_ _06455_ VGND VGND VPWR VPWR _06456_ sky130_fd_sc_hd__o21a_1
XTAP_TAPCELL_ROW_30_734 VGND VPWR sky130_fd_sc_hd__tapvpwrvgnd_1
X_07090_ _04297_ _04307_ VGND VGND VPWR VPWR _04318_ sky130_fd_sc_hd__xnor2_1
XTAP_TAPCELL_ROW_76_1408 VGND VPWR sky130_fd_sc_hd__tapvpwrvgnd_1
XFILLER_114_811 VGND VGND VPWR VPWR sky130_fd_sc_hd__fill_1
XFILLER_113_321 VPWR VGND VPWR VGND sky130_ef_sc_hd__decap_12
X_09800_ _02341_ _02349_ VGND VGND VPWR VPWR _02350_ sky130_fd_sc_hd__xnor2_1
XFILLER_113_354 VPWR VGND VPWR VGND sky130_ef_sc_hd__decap_12
XFILLER_101_505 VGND VGND VPWR VPWR sky130_fd_sc_hd__decap_3
X_07992_ _00434_ _00467_ VGND VGND VPWR VPWR _00469_ sky130_fd_sc_hd__xnor2_2
X_09731_ _02273_ _02274_ VGND VGND VPWR VPWR _02275_ sky130_fd_sc_hd__and2b_1
X_06943_ _02695_ _02706_ net699 net570 VGND VGND VPWR VPWR _02717_ sky130_fd_sc_hd__and4bb_1
XFILLER_39_132 VGND VGND VPWR VPWR sky130_fd_sc_hd__fill_2
X_09662_ _02193_ _02195_ _02197_ VGND VGND VPWR VPWR _02199_ sky130_fd_sc_hd__or3_1
XFILLER_94_271 VPWR VGND VPWR VGND sky130_ef_sc_hd__decap_12
XFILLER_82_400 VGND VGND VPWR VPWR sky130_fd_sc_hd__fill_2
X_06874_ _01943_ _01954_ VGND VGND VPWR VPWR _01965_ sky130_fd_sc_hd__and2b_1
XFILLER_27_316 VGND VGND VPWR VPWR sky130_fd_sc_hd__fill_1
XFILLER_131_39 VPWR VGND VPWR VGND sky130_ef_sc_hd__decap_12
X_08613_ _01077_ _01079_ VGND VGND VPWR VPWR _01080_ sky130_fd_sc_hd__or2_1
X_09593_ _02115_ _02123_ VGND VGND VPWR VPWR _02124_ sky130_fd_sc_hd__xnor2_1
XTAP_TAPCELL_ROW_87_1559 VGND VPWR sky130_fd_sc_hd__tapvpwrvgnd_1
XFILLER_54_113 VPWR VGND VPWR VGND sky130_ef_sc_hd__decap_12
XFILLER_43_809 VPWR VGND VPWR VGND sky130_ef_sc_hd__decap_12
XTAP_TAPCELL_ROW_38_845 VGND VPWR sky130_fd_sc_hd__tapvpwrvgnd_1
XTAP_TAPCELL_ROW_38_856 VGND VPWR sky130_fd_sc_hd__tapvpwrvgnd_1
X_08544_ net463 net341 _01012_ VGND VGND VPWR VPWR _01013_ sky130_fd_sc_hd__and3_1
XFILLER_82_477 VPWR VGND VPWR VGND sky130_ef_sc_hd__decap_12
XFILLER_82_455 VGND VGND VPWR VPWR sky130_fd_sc_hd__fill_1
XFILLER_54_179 VGND VGND VPWR VPWR sky130_fd_sc_hd__fill_1
XFILLER_24_15 VPWR VGND VPWR VGND sky130_ef_sc_hd__decap_12
XFILLER_35_393 VGND VGND VPWR VPWR sky130_fd_sc_hd__decap_3
X_08475_ _00946_ _00947_ VGND VGND VPWR VPWR _00948_ sky130_fd_sc_hd__nor2_1
XTAP_TAPCELL_ROW_118_2003 VGND VPWR sky130_fd_sc_hd__tapvpwrvgnd_1
XPHY_EDGE_ROW_59_Left_198 VGND VGND VPWR VPWR sky130_fd_sc_hd__decap_3
X_07426_ _06623_ _06655_ VGND VGND VPWR VPWR _06656_ sky130_fd_sc_hd__xnor2_1
XFILLER_23_577 VPWR VGND VPWR VGND sky130_ef_sc_hd__decap_12
XTAP_TAPCELL_ROW_118_2014 VGND VPWR sky130_fd_sc_hd__tapvpwrvgnd_1
X_07357_ _05580_ _06586_ VGND VGND VPWR VPWR _06587_ sky130_fd_sc_hd__xnor2_1
XFILLER_136_413 VGND VGND VPWR VPWR sky130_fd_sc_hd__decap_6
XFILLER_136_468 VGND VGND VPWR VPWR sky130_fd_sc_hd__fill_1
XTAP_TAPCELL_ROW_131_2203 VGND VPWR sky130_fd_sc_hd__tapvpwrvgnd_1
X_09027_ _01505_ _01504_ _01267_ _01270_ VGND VGND VPWR VPWR _01507_ sky130_fd_sc_hd__a211o_1
X_07288_ _06443_ _06454_ _06356_ VGND VGND VPWR VPWR _06476_ sky130_fd_sc_hd__a21o_1
XFILLER_132_641 VGND VGND VPWR VPWR sky130_fd_sc_hd__decap_3
XFILLER_104_332 VGND VGND VPWR VPWR sky130_fd_sc_hd__decap_6
XFILLER_132_674 VPWR VGND VPWR VGND sky130_ef_sc_hd__decap_12
XFILLER_132_652 VGND VGND VPWR VPWR sky130_fd_sc_hd__fill_1
XPHY_EDGE_ROW_130_Right_130 VGND VGND VPWR VPWR sky130_fd_sc_hd__decap_3
XTAP_TAPCELL_ROW_129_2176 VGND VPWR sky130_fd_sc_hd__tapvpwrvgnd_1
X_09929_ _02489_ _02461_ VGND VGND VPWR VPWR _02490_ sky130_fd_sc_hd__and2b_1
XTAP_TAPCELL_ROW_129_2165 VGND VPWR sky130_fd_sc_hd__tapvpwrvgnd_1
XFILLER_105_51 VGND VGND VPWR VPWR sky130_fd_sc_hd__decap_4
X_12940_ _05759_ _05768_ VGND VGND VPWR VPWR _05769_ sky130_fd_sc_hd__xnor2_1
XFILLER_86_772 VGND VGND VPWR VPWR sky130_fd_sc_hd__fill_1
XFILLER_58_463 VPWR VGND VPWR VGND sky130_ef_sc_hd__decap_12
XFILLER_46_625 VGND VGND VPWR VPWR sky130_fd_sc_hd__decap_6
X_12871_ _05692_ _05693_ VGND VGND VPWR VPWR _05694_ sky130_fd_sc_hd__nor2_1
XFILLER_65_55 VGND VGND VPWR VPWR sky130_fd_sc_hd__fill_1
XFILLER_45_113 VGND VGND VPWR VPWR sky130_fd_sc_hd__fill_1
XFILLER_61_617 VGND VGND VPWR VPWR sky130_fd_sc_hd__decap_6
XFILLER_45_146 VPWR VGND VPWR VGND sky130_ef_sc_hd__decap_12
X_11822_ _04369_ _04441_ _04444_ VGND VGND VPWR VPWR _04552_ sky130_fd_sc_hd__nor3_1
XTAP_TAPCELL_ROW_16_528 VGND VPWR sky130_fd_sc_hd__tapvpwrvgnd_1
XFILLER_26_382 VGND VGND VPWR VPWR sky130_fd_sc_hd__decap_4
XFILLER_121_94 VGND VGND VPWR VPWR sky130_fd_sc_hd__decap_6
XFILLER_60_138 VGND VGND VPWR VPWR sky130_fd_sc_hd__fill_2
XFILLER_60_149 VGND VGND VPWR VPWR sky130_fd_sc_hd__decap_3
XFILLER_14_533 VPWR VGND VPWR VGND sky130_ef_sc_hd__decap_12
X_11753_ _03617_ _04392_ _04393_ VGND VGND VPWR VPWR _04477_ sky130_fd_sc_hd__o21ba_1
X_11684_ _04400_ _04401_ VGND VGND VPWR VPWR _04402_ sky130_fd_sc_hd__nor2_1
X_10704_ _03329_ _03330_ _03310_ VGND VGND VPWR VPWR _03332_ sky130_fd_sc_hd__a21oi_1
X_13423_ _06294_ _06295_ VGND VGND VPWR VPWR _06297_ sky130_fd_sc_hd__nor2_1
XFILLER_14_81 VGND VGND VPWR VPWR sky130_fd_sc_hd__decap_3
X_10635_ net511 net503 net292 net294 VGND VGND VPWR VPWR _03256_ sky130_fd_sc_hd__nand4_1
X_13354_ net606 net284 net303 net262 VGND VGND VPWR VPWR _06221_ sky130_fd_sc_hd__o2bb2a_1
X_12305_ net556 net679 net660 net566 VGND VGND VPWR VPWR _05075_ sky130_fd_sc_hd__a22oi_1
X_10566_ _03151_ _03179_ _03180_ VGND VGND VPWR VPWR _03181_ sky130_fd_sc_hd__nor3_4
X_13285_ _06144_ _06145_ VGND VGND VPWR VPWR _06146_ sky130_fd_sc_hd__nand2_1
XTAP_TAPCELL_ROW_58_1138 VGND VPWR sky130_fd_sc_hd__tapvpwrvgnd_1
X_10497_ _02930_ _02933_ _03103_ VGND VGND VPWR VPWR _03105_ sky130_fd_sc_hd__and3_1
XFILLER_114_129 VGND VGND VPWR VPWR sky130_fd_sc_hd__decap_4
X_12236_ _04998_ _04999_ VGND VGND VPWR VPWR _05000_ sky130_fd_sc_hd__nor2_1
X_12167_ _04920_ _04924_ _04916_ _04918_ VGND VGND VPWR VPWR _04925_ sky130_fd_sc_hd__a211oi_2
XTAP_TAPCELL_ROW_71_1327 VGND VPWR sky130_fd_sc_hd__tapvpwrvgnd_1
X_11118_ net279 net411 VGND VGND VPWR VPWR _03785_ sky130_fd_sc_hd__and2b_1
XFILLER_96_569 VGND VGND VPWR VPWR sky130_fd_sc_hd__fill_2
XFILLER_84_709 VGND VGND VPWR VPWR sky130_fd_sc_hd__fill_2
X_12098_ net624 net404 net387 net634 VGND VGND VPWR VPWR _04850_ sky130_fd_sc_hd__a22oi_1
XFILLER_49_441 VGND VGND VPWR VPWR sky130_fd_sc_hd__decap_6
XFILLER_110_379 VGND VGND VPWR VPWR sky130_fd_sc_hd__fill_1
Xinput7 w00[5] VGND VGND VPWR VPWR net7 sky130_fd_sc_hd__clkbuf_2
X_11049_ _03530_ _03532_ _03531_ VGND VGND VPWR VPWR _03710_ sky130_fd_sc_hd__o21ba_1
XFILLER_64_477 VPWR VGND VPWR VGND sky130_ef_sc_hd__decap_12
XFILLER_25_809 VGND VGND VPWR VPWR sky130_fd_sc_hd__decap_8
XTAP_TAPCELL_ROW_35_804 VGND VPWR sky130_fd_sc_hd__tapvpwrvgnd_1
XTAP_TAPCELL_ROW_82_1489 VGND VPWR sky130_fd_sc_hd__tapvpwrvgnd_1
X_08260_ _00724_ _00734_ VGND VGND VPWR VPWR _00735_ sky130_fd_sc_hd__or2_1
XFILLER_60_661 VPWR VGND VPWR VGND sky130_ef_sc_hd__decap_12
X_08191_ _00664_ _00665_ VGND VGND VPWR VPWR _00667_ sky130_fd_sc_hd__xor2_2
XFILLER_32_396 VPWR VGND VPWR VGND sky130_ef_sc_hd__decap_12
X_07211_ _05613_ _05624_ VGND VGND VPWR VPWR _05635_ sky130_fd_sc_hd__xnor2_1
X_07142_ net459 net668 net125 net451 VGND VGND VPWR VPWR _04882_ sky130_fd_sc_hd__a22oi_2
XFILLER_133_416 VGND VGND VPWR VPWR sky130_fd_sc_hd__decap_4
XFILLER_106_608 VPWR VGND VPWR VGND sky130_ef_sc_hd__decap_12
X_07073_ _04112_ _04123_ VGND VGND VPWR VPWR _04134_ sky130_fd_sc_hd__nor2_1
XFILLER_133_449 VGND VGND VPWR VPWR sky130_fd_sc_hd__decap_6
XFILLER_114_641 VGND VGND VPWR VPWR sky130_fd_sc_hd__decap_3
XFILLER_113_151 VGND VGND VPWR VPWR sky130_fd_sc_hd__fill_2
XFILLER_101_313 VGND VGND VPWR VPWR sky130_fd_sc_hd__fill_1
X_07975_ _00341_ _00348_ _00347_ VGND VGND VPWR VPWR _00452_ sky130_fd_sc_hd__a21oi_1
XFILLER_19_15 VPWR VGND VPWR VGND sky130_ef_sc_hd__decap_12
X_09714_ _02225_ _02254_ VGND VGND VPWR VPWR _02256_ sky130_fd_sc_hd__xnor2_1
XFILLER_74_219 VGND VGND VPWR VPWR sky130_fd_sc_hd__decap_8
X_06926_ _02456_ _02521_ VGND VGND VPWR VPWR _02532_ sky130_fd_sc_hd__or2_1
X_09645_ _02026_ _02171_ _02170_ VGND VGND VPWR VPWR _02180_ sky130_fd_sc_hd__a21o_1
X_06857_ _01692_ _01758_ VGND VGND VPWR VPWR _01780_ sky130_fd_sc_hd__or2_1
XFILLER_27_113 VGND VGND VPWR VPWR sky130_fd_sc_hd__fill_1
XTAP_TAPCELL_ROW_124_2095 VGND VPWR sky130_fd_sc_hd__tapvpwrvgnd_1
X_09576_ _02076_ _02104_ VGND VGND VPWR VPWR _02105_ sky130_fd_sc_hd__and2b_1
XFILLER_82_285 VPWR VGND VPWR VGND sky130_ef_sc_hd__decap_12
XFILLER_70_414 VGND VGND VPWR VPWR sky130_fd_sc_hd__fill_1
XPHY_EDGE_ROW_67_Left_206 VGND VGND VPWR VPWR sky130_fd_sc_hd__decap_3
XFILLER_36_691 VGND VGND VPWR VPWR sky130_fd_sc_hd__decap_8
X_08527_ net657 net377 net341 net471 VGND VGND VPWR VPWR _00997_ sky130_fd_sc_hd__a22o_1
XFILLER_35_69 VPWR VGND VPWR VGND sky130_ef_sc_hd__decap_12
X_08458_ net251 _00930_ VGND VGND VPWR VPWR _00931_ sky130_fd_sc_hd__xor2_1
X_07409_ _06628_ _06638_ VGND VGND VPWR VPWR _06639_ sky130_fd_sc_hd__xnor2_1
XFILLER_51_57 VPWR VGND VPWR VGND sky130_ef_sc_hd__decap_12
X_08389_ net252 _00755_ _00757_ VGND VGND VPWR VPWR _00863_ sky130_fd_sc_hd__or3_1
X_10420_ _03013_ _03014_ _03021_ VGND VGND VPWR VPWR _03022_ sky130_fd_sc_hd__and3_1
XTAP_TAPCELL_ROW_21_597 VGND VPWR sky130_fd_sc_hd__tapvpwrvgnd_1
XFILLER_137_777 VGND VGND VPWR VPWR sky130_fd_sc_hd__decap_6
XFILLER_136_265 VGND VGND VPWR VPWR sky130_fd_sc_hd__decap_3
X_10351_ _02943_ _02945_ VGND VGND VPWR VPWR _02946_ sky130_fd_sc_hd__xor2_1
X_13070_ _05750_ _05910_ VGND VGND VPWR VPWR _05911_ sky130_fd_sc_hd__xnor2_2
XPHY_EDGE_ROW_76_Left_215 VGND VGND VPWR VPWR sky130_fd_sc_hd__decap_3
X_10282_ _02870_ VGND VGND VPWR VPWR _02871_ sky130_fd_sc_hd__inv_2
XTAP_TAPCELL_ROW_111_1906 VGND VPWR sky130_fd_sc_hd__tapvpwrvgnd_1
X_12021_ _04762_ _04764_ VGND VGND VPWR VPWR _04765_ sky130_fd_sc_hd__xnor2_1
XFILLER_4_3 VPWR VGND VPWR VGND sky130_ef_sc_hd__decap_12
XFILLER_132_471 VGND VGND VPWR VPWR sky130_fd_sc_hd__decap_4
XFILLER_105_685 VPWR VGND VPWR VGND sky130_ef_sc_hd__decap_12
XFILLER_104_173 VGND VGND VPWR VPWR sky130_fd_sc_hd__fill_1
XFILLER_120_655 VGND VGND VPWR VPWR sky130_fd_sc_hd__fill_1
XFILLER_116_83 VGND VGND VPWR VPWR sky130_fd_sc_hd__fill_1
XTAP_TAPCELL_ROW_53_1068 VGND VPWR sky130_fd_sc_hd__tapvpwrvgnd_1
Xfanout560 net563 VGND VGND VPWR VPWR net560 sky130_fd_sc_hd__clkbuf_4
XFILLER_120_699 VGND VGND VPWR VPWR sky130_fd_sc_hd__fill_1
Xfanout593 net597 VGND VGND VPWR VPWR net593 sky130_fd_sc_hd__clkbuf_4
XFILLER_76_76 VGND VGND VPWR VPWR sky130_fd_sc_hd__fill_1
Xfanout582 net587 VGND VGND VPWR VPWR net582 sky130_fd_sc_hd__clkbuf_2
Xfanout571 net576 VGND VGND VPWR VPWR net571 sky130_fd_sc_hd__buf_2
X_12923_ net659 net578 net533 net539 VGND VGND VPWR VPWR _05750_ sky130_fd_sc_hd__and4b_2
XTAP_TAPCELL_ROW_109_1879 VGND VPWR sky130_fd_sc_hd__tapvpwrvgnd_1
XPHY_EDGE_ROW_85_Left_224 VGND VGND VPWR VPWR sky130_fd_sc_hd__decap_3
XFILLER_46_477 VGND VGND VPWR VPWR sky130_fd_sc_hd__decap_4
XFILLER_19_669 VGND VGND VPWR VPWR sky130_fd_sc_hd__decap_3
XFILLER_34_606 VPWR VGND VPWR VGND sky130_ef_sc_hd__decap_12
XFILLER_92_53 VPWR VGND VPWR VGND sky130_ef_sc_hd__decap_12
X_12854_ _05661_ _05674_ VGND VGND VPWR VPWR _05675_ sky130_fd_sc_hd__nor2_1
X_12785_ net423 _05432_ _05429_ VGND VGND VPWR VPWR _05599_ sky130_fd_sc_hd__a21oi_1
XFILLER_92_97 VPWR VGND VPWR VGND sky130_ef_sc_hd__decap_12
X_11805_ _04309_ _04418_ _04416_ VGND VGND VPWR VPWR _04534_ sky130_fd_sc_hd__a21oi_1
XFILLER_14_330 VPWR VGND VPWR VGND sky130_ef_sc_hd__decap_12
X_11736_ _04452_ _04456_ VGND VGND VPWR VPWR _04458_ sky130_fd_sc_hd__xnor2_1
X_11667_ net483 net474 net286 VGND VGND VPWR VPWR _04383_ sky130_fd_sc_hd__o21ai_1
X_13406_ _06248_ _06277_ VGND VGND VPWR VPWR _06278_ sky130_fd_sc_hd__xnor2_1
X_11598_ _04205_ _04207_ _04305_ VGND VGND VPWR VPWR _04308_ sky130_fd_sc_hd__or3b_1
X_10618_ _03094_ _03236_ VGND VGND VPWR VPWR _03238_ sky130_fd_sc_hd__xnor2_1
XTAP_TAPCELL_ROW_40_873 VGND VPWR sky130_fd_sc_hd__tapvpwrvgnd_1
XTAP_TAPCELL_ROW_40_884 VGND VPWR sky130_fd_sc_hd__tapvpwrvgnd_1
XFILLER_127_254 VPWR VGND VPWR VGND sky130_ef_sc_hd__decap_12
XPHY_EDGE_ROW_94_Left_233 VGND VGND VPWR VPWR sky130_fd_sc_hd__decap_3
X_13337_ _06201_ _06193_ VGND VGND VPWR VPWR _06202_ sky130_fd_sc_hd__and2b_1
X_10549_ net643 net70 net318 net651 VGND VGND VPWR VPWR _03163_ sky130_fd_sc_hd__a22oi_2
X_13268_ _05993_ _06002_ _06001_ VGND VGND VPWR VPWR _06128_ sky130_fd_sc_hd__a21bo_1
XFILLER_130_419 VGND VGND VPWR VPWR sky130_fd_sc_hd__fill_1
X_13199_ _05915_ _05917_ VGND VGND VPWR VPWR _06052_ sky130_fd_sc_hd__nand2_1
X_12219_ _04979_ _04981_ VGND VGND VPWR VPWR _04982_ sky130_fd_sc_hd__and2b_1
XFILLER_37_3 VPWR VGND VPWR VGND sky130_ef_sc_hd__decap_12
XFILLER_96_322 VGND VGND VPWR VPWR sky130_fd_sc_hd__decap_8
XFILLER_110_165 VPWR VGND VPWR VGND sky130_ef_sc_hd__decap_12
X_07760_ _00230_ _00238_ VGND VGND VPWR VPWR _00239_ sky130_fd_sc_hd__xnor2_1
XFILLER_77_591 VGND VGND VPWR VPWR sky130_fd_sc_hd__decap_8
X_09430_ _01941_ _01942_ VGND VGND VPWR VPWR _01946_ sky130_fd_sc_hd__xnor2_1
XFILLER_80_701 VPWR VGND VPWR VGND sky130_ef_sc_hd__decap_12
XFILLER_65_764 VPWR VGND VPWR VGND sky130_ef_sc_hd__decap_12
X_07691_ _06788_ _06796_ _06795_ VGND VGND VPWR VPWR _00170_ sky130_fd_sc_hd__a21oi_1
XTAP_TAPCELL_ROW_84_1518 VGND VPWR sky130_fd_sc_hd__tapvpwrvgnd_1
XFILLER_65_797 VPWR VGND VPWR VGND sky130_ef_sc_hd__decap_12
XTAP_TAPCELL_ROW_48_995 VGND VPWR sky130_fd_sc_hd__tapvpwrvgnd_1
XFILLER_25_639 VPWR VGND VPWR VGND sky130_ef_sc_hd__decap_12
X_09361_ net555 net358 net355 net564 VGND VGND VPWR VPWR _01871_ sky130_fd_sc_hd__a22oi_1
XFILLER_24_149 VPWR VGND VPWR VGND sky130_ef_sc_hd__decap_12
X_09292_ _01793_ _01794_ _01795_ VGND VGND VPWR VPWR _01796_ sky130_fd_sc_hd__nand3_1
X_08312_ _00689_ _00786_ VGND VGND VPWR VPWR _00787_ sky130_fd_sc_hd__xnor2_1
XFILLER_21_801 VGND VGND VPWR VPWR sky130_fd_sc_hd__fill_1
XANTENNA_23 net448 VGND VGND VPWR VPWR sky130_fd_sc_hd__diode_2
XANTENNA_12 net149 VGND VGND VPWR VPWR sky130_fd_sc_hd__diode_2
X_08243_ _00717_ _00691_ VGND VGND VPWR VPWR _00718_ sky130_fd_sc_hd__and2b_1
XFILLER_138_519 VGND VGND VPWR VPWR sky130_fd_sc_hd__fill_2
X_08174_ _00647_ _00649_ VGND VGND VPWR VPWR _00650_ sky130_fd_sc_hd__nand2_1
XFILLER_21_27 VPWR VGND VPWR VGND sky130_ef_sc_hd__decap_12
XFILLER_137_27 VPWR VGND VPWR VGND sky130_ef_sc_hd__decap_12
XFILLER_118_265 VGND VGND VPWR VPWR sky130_fd_sc_hd__decap_4
X_07125_ net526 net683 _04686_ VGND VGND VPWR VPWR _04697_ sky130_fd_sc_hd__and3_1
XFILLER_134_725 VPWR VGND VPWR VGND sky130_ef_sc_hd__decap_12
X_07056_ _02194_ _02554_ VGND VGND VPWR VPWR _03948_ sky130_fd_sc_hd__xor2_1
XFILLER_134_769 VPWR VGND VPWR VGND sky130_ef_sc_hd__decap_12
Xoutput185 net185 VGND VGND VPWR VPWR y1[15] sky130_fd_sc_hd__buf_2
XFILLER_133_279 VGND VGND VPWR VPWR sky130_fd_sc_hd__fill_1
Xoutput163 net163 VGND VGND VPWR VPWR y0[10] sky130_fd_sc_hd__buf_2
Xoutput174 net174 VGND VGND VPWR VPWR y0[5] sky130_fd_sc_hd__buf_2
Xoutput196 net196 VGND VGND VPWR VPWR y2[0] sky130_fd_sc_hd__buf_2
XTAP_TAPCELL_ROW_126_2124 VGND VPWR sky130_fd_sc_hd__tapvpwrvgnd_1
XFILLER_102_699 VGND VGND VPWR VPWR sky130_fd_sc_hd__fill_1
XFILLER_56_720 VPWR VGND VPWR VGND sky130_ef_sc_hd__decap_12
X_07958_ _00335_ _00363_ _00362_ VGND VGND VPWR VPWR _00435_ sky130_fd_sc_hd__a21oi_1
XFILLER_28_433 VPWR VGND VPWR VGND sky130_ef_sc_hd__decap_12
XFILLER_83_561 VPWR VGND VPWR VGND sky130_ef_sc_hd__decap_12
X_06909_ _02249_ _02336_ VGND VGND VPWR VPWR _02347_ sky130_fd_sc_hd__or2_1
XFILLER_56_753 VGND VGND VPWR VPWR sky130_fd_sc_hd__decap_3
X_07889_ net434 net665 net425 net663 VGND VGND VPWR VPWR _00367_ sky130_fd_sc_hd__and4_1
X_09628_ _02159_ _02160_ VGND VGND VPWR VPWR _02163_ sky130_fd_sc_hd__xnor2_2
XFILLER_43_425 VPWR VGND VPWR VGND sky130_ef_sc_hd__decap_12
XFILLER_16_617 VGND VGND VPWR VPWR sky130_fd_sc_hd__decap_4
XFILLER_28_477 VGND VGND VPWR VPWR sky130_fd_sc_hd__fill_2
X_09559_ _02083_ _02084_ _01920_ _01925_ VGND VGND VPWR VPWR _02087_ sky130_fd_sc_hd__a211o_1
XFILLER_102_41 VPWR VGND VPWR VGND sky130_ef_sc_hd__decap_12
XFILLER_55_296 VGND VGND VPWR VPWR sky130_fd_sc_hd__decap_8
XFILLER_102_85 VPWR VGND VPWR VGND sky130_ef_sc_hd__decap_12
X_12570_ _05362_ _05364_ VGND VGND VPWR VPWR _05366_ sky130_fd_sc_hd__xnor2_1
XFILLER_24_672 VGND VGND VPWR VPWR sky130_fd_sc_hd__decap_4
XTAP_TAPCELL_ROW_26_678 VGND VPWR sky130_fd_sc_hd__tapvpwrvgnd_1
XFILLER_30_119 VGND VGND VPWR VPWR sky130_fd_sc_hd__decap_4
XFILLER_8_805 VGND VGND VPWR VPWR sky130_fd_sc_hd__decap_6
XFILLER_11_311 VGND VGND VPWR VPWR sky130_fd_sc_hd__fill_1
X_11521_ _04223_ _04224_ VGND VGND VPWR VPWR _04225_ sky130_fd_sc_hd__nor2_1
XTAP_TAPCELL_ROW_137_2286 VGND VPWR sky130_fd_sc_hd__tapvpwrvgnd_1
XFILLER_7_337 VPWR VGND VPWR VGND sky130_ef_sc_hd__decap_12
XFILLER_7_326 VGND VGND VPWR VPWR sky130_fd_sc_hd__decap_8
X_11452_ _04147_ _04148_ VGND VGND VPWR VPWR _04150_ sky130_fd_sc_hd__xor2_1
XFILLER_137_552 VGND VGND VPWR VPWR sky130_fd_sc_hd__fill_1
X_11383_ _04072_ _04073_ VGND VGND VPWR VPWR _04074_ sky130_fd_sc_hd__and2b_1
X_10403_ _02992_ _02994_ _02993_ VGND VGND VPWR VPWR _03003_ sky130_fd_sc_hd__a21o_1
X_13122_ _05934_ _05966_ VGND VGND VPWR VPWR _05968_ sky130_fd_sc_hd__xnor2_2
X_10334_ _02870_ _02873_ _02922_ VGND VGND VPWR VPWR _02927_ sky130_fd_sc_hd__nor3_1
XFILLER_3_510 VGND VGND VPWR VPWR sky130_fd_sc_hd__decap_6
XFILLER_125_769 VPWR VGND VPWR VGND sky130_ef_sc_hd__decap_12
XFILLER_11_93 VGND VGND VPWR VPWR sky130_fd_sc_hd__decap_8
XFILLER_127_93 VPWR VGND VPWR VGND sky130_ef_sc_hd__decap_12
XFILLER_112_419 VGND VGND VPWR VPWR sky130_fd_sc_hd__fill_1
X_13053_ _05758_ _05772_ _05771_ VGND VGND VPWR VPWR _05892_ sky130_fd_sc_hd__o21a_1
XFILLER_87_31 VPWR VGND VPWR VGND sky130_ef_sc_hd__decap_12
X_10265_ _02850_ _02851_ VGND VGND VPWR VPWR _02852_ sky130_fd_sc_hd__nor2_1
X_10196_ _02777_ _02779_ VGND VGND VPWR VPWR _02780_ sky130_fd_sc_hd__xnor2_1
X_12004_ _04735_ _04745_ VGND VGND VPWR VPWR _04747_ sky130_fd_sc_hd__and2_1
XFILLER_39_709 VGND VGND VPWR VPWR sky130_fd_sc_hd__decap_3
XFILLER_78_377 VGND VGND VPWR VPWR sky130_fd_sc_hd__decap_6
XFILLER_66_517 VGND VGND VPWR VPWR sky130_fd_sc_hd__decap_4
XFILLER_38_219 VPWR VGND VPWR VGND sky130_ef_sc_hd__decap_12
Xfanout390 net28 VGND VGND VPWR VPWR net390 sky130_fd_sc_hd__buf_1
XFILLER_66_539 VGND VGND VPWR VPWR sky130_fd_sc_hd__decap_8
XTAP_TAPCELL_ROW_6_392 VGND VPWR sky130_fd_sc_hd__tapvpwrvgnd_1
XTAP_TAPCELL_ROW_6_381 VGND VPWR sky130_fd_sc_hd__tapvpwrvgnd_1
XFILLER_19_422 VPWR VGND VPWR VGND sky130_ef_sc_hd__decap_12
X_12906_ _05730_ _05731_ VGND VGND VPWR VPWR _00039_ sky130_fd_sc_hd__xnor2_1
XFILLER_61_211 VPWR VGND VPWR VGND sky130_ef_sc_hd__decap_12
XFILLER_47_797 VPWR VGND VPWR VGND sky130_ef_sc_hd__decap_12
X_12837_ _05621_ _05655_ VGND VGND VPWR VPWR _05656_ sky130_fd_sc_hd__and2b_1
XTAP_TAPCELL_ROW_66_1259 VGND VPWR sky130_fd_sc_hd__tapvpwrvgnd_1
XTAP_TAPCELL_ROW_45_954 VGND VPWR sky130_fd_sc_hd__tapvpwrvgnd_1
XFILLER_61_255 VGND VGND VPWR VPWR sky130_fd_sc_hd__fill_1
X_12768_ _05578_ _05579_ VGND VGND VPWR VPWR _05581_ sky130_fd_sc_hd__nor2_1
XFILLER_61_288 VGND VGND VPWR VPWR sky130_fd_sc_hd__decap_8
XFILLER_14_182 VGND VGND VPWR VPWR sky130_fd_sc_hd__fill_2
X_12699_ _05503_ _05504_ _05496_ VGND VGND VPWR VPWR _05507_ sky130_fd_sc_hd__a21o_1
X_11719_ _04350_ _04439_ VGND VGND VPWR VPWR _04440_ sky130_fd_sc_hd__nand2_1
Xinput10 w01[0] VGND VGND VPWR VPWR net10 sky130_fd_sc_hd__clkbuf_2
Xinput21 w02[3] VGND VGND VPWR VPWR net21 sky130_fd_sc_hd__buf_1
XFILLER_30_697 VGND VGND VPWR VPWR sky130_fd_sc_hd__decap_3
Xinput43 w11[1] VGND VGND VPWR VPWR net43 sky130_fd_sc_hd__buf_1
Xinput54 w12[4] VGND VGND VPWR VPWR net54 sky130_fd_sc_hd__clkbuf_2
Xinput32 w03[6] VGND VGND VPWR VPWR net32 sky130_fd_sc_hd__dlymetal6s2s_1
Xinput65 w13[7] VGND VGND VPWR VPWR net65 sky130_fd_sc_hd__clkbuf_2
Xinput98 w30[0] VGND VGND VPWR VPWR net98 sky130_fd_sc_hd__clkbuf_2
Xinput87 w22[5] VGND VGND VPWR VPWR net87 sky130_fd_sc_hd__dlymetal6s2s_1
Xinput76 w21[2] VGND VGND VPWR VPWR net76 sky130_fd_sc_hd__clkbuf_2
XFILLER_116_769 VGND VGND VPWR VPWR sky130_fd_sc_hd__decap_4
XFILLER_6_392 VGND VGND VPWR VPWR sky130_fd_sc_hd__fill_1
X_08930_ _01396_ _01399_ VGND VGND VPWR VPWR _01401_ sky130_fd_sc_hd__and2b_1
X_08861_ _01324_ _01323_ _01325_ VGND VGND VPWR VPWR _01327_ sky130_fd_sc_hd__a21o_1
XFILLER_97_653 VGND VGND VPWR VPWR sky130_fd_sc_hd__decap_8
XFILLER_111_441 VGND VGND VPWR VPWR sky130_fd_sc_hd__decap_6
XFILLER_96_163 VPWR VGND VPWR VGND sky130_ef_sc_hd__decap_12
XFILLER_96_141 VGND VGND VPWR VPWR sky130_fd_sc_hd__decap_8
XTAP_TAPCELL_ROW_90_1599 VGND VPWR sky130_fd_sc_hd__tapvpwrvgnd_1
XFILLER_84_303 VGND VGND VPWR VPWR sky130_fd_sc_hd__decap_4
XFILLER_69_366 VPWR VGND VPWR VGND sky130_ef_sc_hd__decap_12
X_07812_ _00139_ _00143_ VGND VGND VPWR VPWR _00291_ sky130_fd_sc_hd__and2b_1
X_08792_ _01256_ _01257_ VGND VGND VPWR VPWR _01258_ sky130_fd_sc_hd__xnor2_2
X_07743_ _00191_ _00220_ VGND VGND VPWR VPWR _00222_ sky130_fd_sc_hd__xnor2_2
XFILLER_65_583 VPWR VGND VPWR VGND sky130_ef_sc_hd__decap_12
XFILLER_65_561 VGND VGND VPWR VPWR sky130_fd_sc_hd__decap_4
X_07674_ net552 net692 net690 net560 VGND VGND VPWR VPWR _00153_ sky130_fd_sc_hd__a22oi_1
X_09413_ net496 net347 _01754_ _01753_ VGND VGND VPWR VPWR _01927_ sky130_fd_sc_hd__a31o_1
XFILLER_16_27 VGND VGND VPWR VPWR sky130_fd_sc_hd__fill_1
XTAP_TAPCELL_ROW_121_2054 VGND VPWR sky130_fd_sc_hd__tapvpwrvgnd_1
XFILLER_80_586 VGND VGND VPWR VPWR sky130_fd_sc_hd__fill_2
X_09344_ _01852_ VGND VGND VPWR VPWR _01853_ sky130_fd_sc_hd__inv_2
XTAP_TAPCELL_ROW_23_626 VGND VPWR sky130_fd_sc_hd__tapvpwrvgnd_1
XTAP_TAPCELL_ROW_23_637 VGND VPWR sky130_fd_sc_hd__tapvpwrvgnd_1
XFILLER_33_480 VGND VGND VPWR VPWR sky130_fd_sc_hd__fill_1
X_09275_ _01762_ _01776_ VGND VGND VPWR VPWR _01777_ sky130_fd_sc_hd__xnor2_1
XFILLER_21_653 VPWR VGND VPWR VGND sky130_ef_sc_hd__decap_12
XFILLER_32_15 VPWR VGND VPWR VGND sky130_ef_sc_hd__decap_12
XFILLER_138_349 VGND VGND VPWR VPWR sky130_fd_sc_hd__decap_6
XTAP_TAPCELL_ROW_97_1709 VGND VPWR sky130_fd_sc_hd__tapvpwrvgnd_1
XFILLER_21_686 VGND VGND VPWR VPWR sky130_fd_sc_hd__fill_2
X_08226_ _00562_ _00700_ VGND VGND VPWR VPWR _00701_ sky130_fd_sc_hd__xnor2_1
X_08157_ _06659_ _00632_ VGND VGND VPWR VPWR _00633_ sky130_fd_sc_hd__xnor2_1
XFILLER_134_533 VPWR VGND VPWR VGND sky130_ef_sc_hd__decap_12
XFILLER_119_585 VGND VGND VPWR VPWR sky130_fd_sc_hd__decap_8
X_07108_ _03095_ _04493_ VGND VGND VPWR VPWR _04515_ sky130_fd_sc_hd__xnor2_1
X_08088_ _00562_ _00563_ VGND VGND VPWR VPWR _00564_ sky130_fd_sc_hd__nor2_1
XFILLER_122_717 VGND VGND VPWR VPWR sky130_fd_sc_hd__decap_6
XFILLER_106_279 VGND VGND VPWR VPWR sky130_fd_sc_hd__fill_1
X_07039_ _03336_ _03718_ _03740_ VGND VGND VPWR VPWR _03762_ sky130_fd_sc_hd__or3_4
XFILLER_121_249 VPWR VGND VPWR VGND sky130_ef_sc_hd__decap_12
X_10050_ _02609_ _02621_ VGND VGND VPWR VPWR _02622_ sky130_fd_sc_hd__nand2_1
XFILLER_88_653 VGND VGND VPWR VPWR sky130_fd_sc_hd__decap_4
XFILLER_88_620 VGND VGND VPWR VPWR sky130_fd_sc_hd__fill_1
XFILLER_0_524 VGND VGND VPWR VPWR sky130_fd_sc_hd__fill_2
XFILLER_87_163 VGND VGND VPWR VPWR sky130_fd_sc_hd__decap_4
XTAP_TAPCELL_ROW_50_1027 VGND VPWR sky130_fd_sc_hd__tapvpwrvgnd_1
XFILLER_75_369 VGND VGND VPWR VPWR sky130_fd_sc_hd__decap_8
XTAP_TAPCELL_ROW_3_340 VGND VPWR sky130_fd_sc_hd__tapvpwrvgnd_1
XFILLER_28_241 VGND VGND VPWR VPWR sky130_fd_sc_hd__fill_1
XFILLER_29_753 VPWR VGND VPWR VGND sky130_ef_sc_hd__decap_12
XFILLER_113_51 VGND VGND VPWR VPWR sky130_fd_sc_hd__decap_4
XFILLER_90_339 VPWR VGND VPWR VGND sky130_ef_sc_hd__decap_12
XFILLER_90_306 VGND VGND VPWR VPWR sky130_fd_sc_hd__fill_2
XFILLER_44_701 VPWR VGND VPWR VGND sky130_ef_sc_hd__decap_12
X_10952_ net502 net87 net289 net510 VGND VGND VPWR VPWR _03603_ sky130_fd_sc_hd__a22o_1
XFILLER_29_797 VPWR VGND VPWR VGND sky130_ef_sc_hd__decap_12
XTAP_TAPCELL_ROW_106_1838 VGND VPWR sky130_fd_sc_hd__tapvpwrvgnd_1
XFILLER_83_391 VGND VGND VPWR VPWR sky130_fd_sc_hd__fill_1
XFILLER_73_55 VGND VGND VPWR VPWR sky130_fd_sc_hd__fill_1
XFILLER_43_233 VGND VGND VPWR VPWR sky130_fd_sc_hd__fill_1
XFILLER_73_77 VPWR VGND VPWR VGND sky130_ef_sc_hd__decap_12
XTAP_TAPCELL_ROW_42_913 VGND VPWR sky130_fd_sc_hd__tapvpwrvgnd_1
XTAP_TAPCELL_ROW_42_902 VGND VPWR sky130_fd_sc_hd__tapvpwrvgnd_1
X_10883_ _03527_ VGND VGND VPWR VPWR _03528_ sky130_fd_sc_hd__inv_2
X_13671_ clknet_3_2__leaf_clk _00012_ net714 VGND VGND VPWR VPWR net206 sky130_fd_sc_hd__dfrtp_1
X_12622_ _05420_ _05421_ VGND VGND VPWR VPWR _05422_ sky130_fd_sc_hd__nand2b_1
XFILLER_12_620 VGND VGND VPWR VPWR sky130_fd_sc_hd__fill_1
XFILLER_31_428 VGND VGND VPWR VPWR sky130_fd_sc_hd__fill_1
X_12553_ _05169_ _05346_ VGND VGND VPWR VPWR _05347_ sky130_fd_sc_hd__xnor2_1
XFILLER_8_613 VPWR VGND VPWR VGND sky130_ef_sc_hd__decap_12
XFILLER_12_653 VGND VGND VPWR VPWR sky130_fd_sc_hd__fill_1
XFILLER_129_327 VGND VGND VPWR VPWR sky130_fd_sc_hd__decap_8
XTAP_TAPCELL_ROW_61_1189 VGND VPWR sky130_fd_sc_hd__tapvpwrvgnd_1
XTAP_TAPCELL_ROW_61_1178 VGND VPWR sky130_fd_sc_hd__tapvpwrvgnd_1
X_11504_ _04172_ _04204_ VGND VGND VPWR VPWR _04206_ sky130_fd_sc_hd__xnor2_1
X_12484_ _05225_ _05269_ VGND VGND VPWR VPWR _05271_ sky130_fd_sc_hd__xnor2_1
X_11435_ _04129_ _04130_ VGND VGND VPWR VPWR _04131_ sky130_fd_sc_hd__xnor2_1
XFILLER_138_81 VGND VGND VPWR VPWR sky130_fd_sc_hd__decap_3
XFILLER_137_393 VGND VGND VPWR VPWR sky130_fd_sc_hd__decap_6
XTAP_TAPCELL_ROW_117_1989 VGND VPWR sky130_fd_sc_hd__tapvpwrvgnd_1
XFILLER_98_41 VPWR VGND VPWR VGND sky130_ef_sc_hd__decap_12
X_11366_ _04048_ _04053_ VGND VGND VPWR VPWR _04055_ sky130_fd_sc_hd__xnor2_1
XFILLER_113_739 VPWR VGND VPWR VGND sky130_ef_sc_hd__decap_12
XFILLER_98_85 VPWR VGND VPWR VGND sky130_ef_sc_hd__decap_12
X_13105_ _05946_ _05947_ _05940_ VGND VGND VPWR VPWR _05949_ sky130_fd_sc_hd__a21oi_1
X_10317_ net588 net579 net306 net308 VGND VGND VPWR VPWR _02908_ sky130_fd_sc_hd__and4_1
XFILLER_3_362 VGND VGND VPWR VPWR sky130_fd_sc_hd__fill_1
X_11297_ _03971_ _03979_ VGND VGND VPWR VPWR _03980_ sky130_fd_sc_hd__xor2_1
X_13036_ _05872_ _05873_ VGND VGND VPWR VPWR _05874_ sky130_fd_sc_hd__nor2_1
X_10248_ _02833_ VGND VGND VPWR VPWR _02835_ sky130_fd_sc_hd__inv_2
XFILLER_94_601 VGND VGND VPWR VPWR sky130_fd_sc_hd__decap_4
XFILLER_79_653 VGND VGND VPWR VPWR sky130_fd_sc_hd__decap_6
XFILLER_78_141 VPWR VGND VPWR VGND sky130_ef_sc_hd__decap_12
X_10179_ _02578_ _02752_ _02749_ VGND VGND VPWR VPWR _02762_ sky130_fd_sc_hd__o21a_1
XFILLER_121_783 VGND VGND VPWR VPWR sky130_fd_sc_hd__fill_1
XFILLER_94_645 VPWR VGND VPWR VGND sky130_ef_sc_hd__decap_12
XFILLER_93_111 VGND VGND VPWR VPWR sky130_fd_sc_hd__fill_1
XFILLER_66_336 VGND VGND VPWR VPWR sky130_fd_sc_hd__fill_2
XFILLER_93_155 VPWR VGND VPWR VGND sky130_ef_sc_hd__decap_12
XFILLER_54_509 VGND VGND VPWR VPWR sky130_fd_sc_hd__decap_6
XFILLER_81_328 VGND VGND VPWR VPWR sky130_fd_sc_hd__fill_2
XFILLER_47_561 VPWR VGND VPWR VGND sky130_ef_sc_hd__decap_12
XFILLER_62_531 VGND VGND VPWR VPWR sky130_fd_sc_hd__fill_1
XFILLER_62_586 VGND VGND VPWR VPWR sky130_fd_sc_hd__fill_2
X_07390_ _06577_ _06618_ VGND VGND VPWR VPWR _06620_ sky130_fd_sc_hd__xnor2_1
XFILLER_22_428 VGND VGND VPWR VPWR sky130_fd_sc_hd__fill_1
XFILLER_15_491 VGND VGND VPWR VPWR sky130_fd_sc_hd__fill_2
X_09060_ _01533_ _01542_ VGND VGND VPWR VPWR _01543_ sky130_fd_sc_hd__xnor2_1
XFILLER_30_450 VGND VGND VPWR VPWR sky130_fd_sc_hd__fill_1
XTAP_TAPCELL_ROW_79_1439 VGND VPWR sky130_fd_sc_hd__tapvpwrvgnd_1
X_08011_ net667 net411 VGND VGND VPWR VPWR _00488_ sky130_fd_sc_hd__and2b_1
XFILLER_118_29 VPWR VGND VPWR VGND sky130_ef_sc_hd__decap_12
XFILLER_128_393 VPWR VGND VPWR VGND sky130_ef_sc_hd__decap_12
XTAP_TAPCELL_ROW_92_1628 VGND VPWR sky130_fd_sc_hd__tapvpwrvgnd_1
X_09962_ _02370_ _02383_ _02382_ VGND VGND VPWR VPWR _02526_ sky130_fd_sc_hd__o21ai_1
XFILLER_116_566 VGND VGND VPWR VPWR sky130_fd_sc_hd__fill_1
XFILLER_103_205 VGND VGND VPWR VPWR sky130_fd_sc_hd__fill_2
XTAP_TAPCELL_ROW_92_1639 VGND VPWR sky130_fd_sc_hd__tapvpwrvgnd_1
XFILLER_89_417 VPWR VGND VPWR VGND sky130_ef_sc_hd__decap_12
X_08913_ _01251_ _01380_ VGND VGND VPWR VPWR _01382_ sky130_fd_sc_hd__and2_1
X_09893_ _02172_ _02174_ _02180_ _02317_ VGND VGND VPWR VPWR _02451_ sky130_fd_sc_hd__a2bb2o_1
XFILLER_112_750 VGND VGND VPWR VPWR sky130_fd_sc_hd__decap_6
XFILLER_97_461 VGND VGND VPWR VPWR sky130_fd_sc_hd__decap_4
X_08844_ _01154_ _01156_ _01308_ VGND VGND VPWR VPWR _01310_ sky130_fd_sc_hd__nand3_1
X_08775_ _01238_ _01240_ _01072_ VGND VGND VPWR VPWR _01242_ sky130_fd_sc_hd__a21o_1
XFILLER_84_122 VPWR VGND VPWR VGND sky130_ef_sc_hd__decap_12
XFILLER_27_15 VPWR VGND VPWR VGND sky130_ef_sc_hd__decap_12
XFILLER_84_188 VGND VGND VPWR VPWR sky130_fd_sc_hd__decap_8
X_07726_ _00201_ _00202_ _00203_ VGND VGND VPWR VPWR _00205_ sky130_fd_sc_hd__a21o_1
XTAP_TAPCELL_ROW_28_707 VGND VPWR sky130_fd_sc_hd__tapvpwrvgnd_1
XFILLER_65_391 VGND VGND VPWR VPWR sky130_fd_sc_hd__fill_1
XFILLER_65_380 VGND VGND VPWR VPWR sky130_fd_sc_hd__decap_6
XFILLER_25_211 VGND VGND VPWR VPWR sky130_fd_sc_hd__fill_1
XFILLER_26_745 VGND VGND VPWR VPWR sky130_fd_sc_hd__fill_1
X_07657_ _06574_ _00135_ _00136_ VGND VGND VPWR VPWR _00137_ sky130_fd_sc_hd__or3_1
XPHY_EDGE_ROW_40_Left_179 VGND VGND VPWR VPWR sky130_fd_sc_hd__decap_3
XFILLER_80_383 VPWR VGND VPWR VGND sky130_ef_sc_hd__decap_12
X_07588_ _06663_ _06672_ _06671_ VGND VGND VPWR VPWR _00068_ sky130_fd_sc_hd__a21bo_1
XFILLER_13_428 VGND VGND VPWR VPWR sky130_fd_sc_hd__decap_6
X_09327_ _01654_ _01656_ _01832_ _01833_ VGND VGND VPWR VPWR _01834_ sky130_fd_sc_hd__o211ai_2
XTAP_TAPCELL_ROW_101_1757 VGND VPWR sky130_fd_sc_hd__tapvpwrvgnd_1
XFILLER_43_69 VPWR VGND VPWR VGND sky130_ef_sc_hd__decap_12
XFILLER_40_247 VGND VGND VPWR VPWR sky130_fd_sc_hd__decap_4
XFILLER_138_113 VPWR VGND VPWR VGND sky130_ef_sc_hd__decap_12
XTAP_TAPCELL_ROW_101_1768 VGND VPWR sky130_fd_sc_hd__tapvpwrvgnd_1
XFILLER_21_461 VGND VGND VPWR VPWR sky130_fd_sc_hd__decap_8
XFILLER_127_809 VPWR VGND VPWR VGND sky130_ef_sc_hd__decap_12
X_09258_ _01580_ _01581_ _01579_ VGND VGND VPWR VPWR _01759_ sky130_fd_sc_hd__a21oi_1
X_09189_ _01509_ _01683_ VGND VGND VPWR VPWR _01684_ sky130_fd_sc_hd__nor2_1
XTAP_TAPCELL_ROW_134_2245 VGND VPWR sky130_fd_sc_hd__tapvpwrvgnd_1
XFILLER_119_382 VGND VGND VPWR VPWR sky130_fd_sc_hd__decap_8
X_08209_ _00679_ _00683_ _00680_ _00677_ VGND VGND VPWR VPWR _00685_ sky130_fd_sc_hd__o31a_2
XFILLER_119_393 VGND VGND VPWR VPWR sky130_fd_sc_hd__decap_4
X_11220_ _03895_ _03894_ VGND VGND VPWR VPWR _03896_ sky130_fd_sc_hd__and2b_1
XTAP_TAPCELL_ROW_8_421 VGND VPWR sky130_fd_sc_hd__tapvpwrvgnd_1
XTAP_TAPCELL_ROW_8_410 VGND VPWR sky130_fd_sc_hd__tapvpwrvgnd_1
X_11151_ net609 net322 _03665_ _03663_ VGND VGND VPWR VPWR _03821_ sky130_fd_sc_hd__a31o_1
XFILLER_134_396 VGND VGND VPWR VPWR sky130_fd_sc_hd__fill_1
X_10102_ _02677_ _02678_ VGND VGND VPWR VPWR _02679_ sky130_fd_sc_hd__nor2_1
XFILLER_122_558 VGND VGND VPWR VPWR sky130_fd_sc_hd__decap_3
XFILLER_0_343 VGND VGND VPWR VPWR sky130_fd_sc_hd__decap_3
X_11082_ _03571_ _03744_ _03573_ VGND VGND VPWR VPWR _03745_ sky130_fd_sc_hd__o21ba_2
X_10033_ _02509_ _02518_ _02508_ VGND VGND VPWR VPWR _02603_ sky130_fd_sc_hd__a21o_1
XFILLER_103_783 VGND VGND VPWR VPWR sky130_fd_sc_hd__fill_1
XFILLER_76_634 VGND VGND VPWR VPWR sky130_fd_sc_hd__decap_8
XFILLER_124_83 VGND VGND VPWR VPWR sky130_fd_sc_hd__fill_1
XFILLER_76_656 VGND VGND VPWR VPWR sky130_fd_sc_hd__fill_1
XFILLER_76_645 VGND VGND VPWR VPWR sky130_fd_sc_hd__decap_3
XFILLER_48_358 VGND VGND VPWR VPWR sky130_fd_sc_hd__decap_6
XFILLER_84_65 VGND VGND VPWR VPWR sky130_fd_sc_hd__decap_3
XFILLER_75_188 VPWR VGND VPWR VGND sky130_ef_sc_hd__decap_12
XFILLER_29_561 VPWR VGND VPWR VGND sky130_ef_sc_hd__decap_12
X_11984_ net529 net402 VGND VGND VPWR VPWR _04725_ sky130_fd_sc_hd__nand2_1
XFILLER_17_756 VGND VGND VPWR VPWR sky130_fd_sc_hd__decap_3
XTAP_TAPCELL_ROW_63_1207 VGND VPWR sky130_fd_sc_hd__tapvpwrvgnd_1
X_10935_ _03234_ _03403_ _03400_ VGND VGND VPWR VPWR _03584_ sky130_fd_sc_hd__o21a_1
XFILLER_17_92 VGND VGND VPWR VPWR sky130_fd_sc_hd__fill_1
XFILLER_17_778 VGND VGND VPWR VPWR sky130_fd_sc_hd__decap_6
XFILLER_32_704 VPWR VGND VPWR VGND sky130_ef_sc_hd__decap_12
X_13654_ clknet_3_7__leaf_clk _00054_ net717 VGND VGND VPWR VPWR net189 sky130_fd_sc_hd__dfrtp_1
XTAP_TAPCELL_ROW_63_1218 VGND VPWR sky130_fd_sc_hd__tapvpwrvgnd_1
X_10866_ _03304_ _03334_ _03333_ VGND VGND VPWR VPWR _03509_ sky130_fd_sc_hd__a21bo_1
X_12605_ _05400_ _05401_ VGND VGND VPWR VPWR _05403_ sky130_fd_sc_hd__and2_1
XFILLER_31_247 VGND VGND VPWR VPWR sky130_fd_sc_hd__fill_2
XFILLER_129_113 VGND VGND VPWR VPWR sky130_fd_sc_hd__decap_3
X_13585_ _06470_ _06472_ VGND VGND VPWR VPWR _06473_ sky130_fd_sc_hd__nor2_1
XFILLER_8_421 VPWR VGND VPWR VGND sky130_ef_sc_hd__decap_12
XFILLER_8_410 VGND VGND VPWR VPWR sky130_fd_sc_hd__fill_1
X_10797_ _03420_ _03432_ VGND VGND VPWR VPWR _03433_ sky130_fd_sc_hd__xnor2_1
XFILLER_117_308 VGND VGND VPWR VPWR sky130_fd_sc_hd__fill_2
X_12536_ net262 net404 _05324_ _05326_ VGND VGND VPWR VPWR _05328_ sky130_fd_sc_hd__or4b_1
XFILLER_12_494 VPWR VGND VPWR VGND sky130_ef_sc_hd__decap_12
X_12467_ _05116_ _05126_ _05125_ _05124_ VGND VGND VPWR VPWR _05252_ sky130_fd_sc_hd__a2bb2o_1
X_11418_ _04105_ _04110_ VGND VGND VPWR VPWR _04113_ sky130_fd_sc_hd__xnor2_1
X_12398_ _05173_ _05176_ VGND VGND VPWR VPWR _05178_ sky130_fd_sc_hd__xnor2_1
XFILLER_99_748 VPWR VGND VPWR VGND sky130_ef_sc_hd__decap_12
XFILLER_98_236 VGND VGND VPWR VPWR sky130_fd_sc_hd__fill_1
XTAP_TAPCELL_ROW_74_1369 VGND VPWR sky130_fd_sc_hd__tapvpwrvgnd_1
X_11349_ _04036_ VGND VGND VPWR VPWR _04037_ sky130_fd_sc_hd__inv_2
XFILLER_79_461 VGND VGND VPWR VPWR sky130_fd_sc_hd__decap_8
X_13019_ _05688_ _05703_ _05702_ VGND VGND VPWR VPWR _05856_ sky130_fd_sc_hd__a21o_1
X_06890_ net519 net686 VGND VGND VPWR VPWR _02140_ sky130_fd_sc_hd__nand2_1
XFILLER_66_122 VGND VGND VPWR VPWR sky130_fd_sc_hd__fill_1
XFILLER_55_818 VGND VGND VPWR VPWR sky130_fd_sc_hd__decap_6
X_08560_ _01026_ _01027_ _01024_ VGND VGND VPWR VPWR _01029_ sky130_fd_sc_hd__o21ai_1
XTAP_TAPCELL_ROW_89_1590 VGND VPWR sky130_fd_sc_hd__tapvpwrvgnd_1
XFILLER_50_501 VGND VGND VPWR VPWR sky130_fd_sc_hd__decap_6
XFILLER_35_553 VGND VGND VPWR VPWR sky130_fd_sc_hd__decap_6
X_08491_ _00961_ _00963_ VGND VGND VPWR VPWR _00964_ sky130_fd_sc_hd__or2_1
X_07511_ _06738_ _06739_ VGND VGND VPWR VPWR _06740_ sky130_fd_sc_hd__or2_1
X_07442_ _06668_ _06669_ _06670_ VGND VGND VPWR VPWR _06672_ sky130_fd_sc_hd__a21o_1
XFILLER_23_748 VGND VGND VPWR VPWR sky130_fd_sc_hd__decap_4
XFILLER_50_545 VPWR VGND VPWR VGND sky130_ef_sc_hd__decap_12
X_07373_ net571 net694 _05777_ _05766_ VGND VGND VPWR VPWR _06603_ sky130_fd_sc_hd__a31oi_2
X_09112_ _01285_ _01427_ _01425_ VGND VGND VPWR VPWR _01599_ sky130_fd_sc_hd__a21o_1
XFILLER_13_39 VPWR VGND VPWR VGND sky130_ef_sc_hd__decap_12
XTAP_TAPCELL_ROW_33_776 VGND VPWR sky130_fd_sc_hd__tapvpwrvgnd_1
XFILLER_136_617 VGND VGND VPWR VPWR sky130_fd_sc_hd__decap_8
XFILLER_129_39 VPWR VGND VPWR VGND sky130_ef_sc_hd__decap_12
XFILLER_109_809 VPWR VGND VPWR VGND sky130_ef_sc_hd__decap_12
XFILLER_30_280 VGND VGND VPWR VPWR sky130_fd_sc_hd__decap_8
XFILLER_135_105 VGND VGND VPWR VPWR sky130_fd_sc_hd__decap_6
X_09043_ net541 net364 net363 net550 VGND VGND VPWR VPWR _01524_ sky130_fd_sc_hd__a22o_1
XFILLER_135_149 VPWR VGND VPWR VGND sky130_ef_sc_hd__decap_12
XPHY_EDGE_ROW_111_Right_111 VGND VGND VPWR VPWR sky130_fd_sc_hd__decap_3
XFILLER_116_352 VGND VGND VPWR VPWR sky130_fd_sc_hd__decap_4
XFILLER_131_311 VGND VGND VPWR VPWR sky130_fd_sc_hd__fill_2
XFILLER_89_225 VGND VGND VPWR VPWR sky130_fd_sc_hd__decap_8
X_09945_ _02395_ _02406_ _02394_ VGND VGND VPWR VPWR _02507_ sky130_fd_sc_hd__a21o_1
X_09876_ _02305_ _02307_ _02431_ VGND VGND VPWR VPWR _02432_ sky130_fd_sc_hd__a21o_1
XFILLER_98_781 VPWR VGND VPWR VGND sky130_ef_sc_hd__decap_12
XFILLER_85_420 VGND VGND VPWR VPWR sky130_fd_sc_hd__decap_6
XFILLER_57_111 VGND VGND VPWR VPWR sky130_fd_sc_hd__fill_1
X_08827_ _01292_ _01272_ VGND VGND VPWR VPWR _01293_ sky130_fd_sc_hd__and2b_1
XFILLER_58_645 VGND VGND VPWR VPWR sky130_fd_sc_hd__decap_8
XFILLER_85_464 VPWR VGND VPWR VGND sky130_ef_sc_hd__decap_12
X_08758_ _01125_ _01222_ _01223_ VGND VGND VPWR VPWR _01225_ sky130_fd_sc_hd__nand3_2
XFILLER_73_637 VGND VGND VPWR VPWR sky130_fd_sc_hd__fill_1
XFILLER_57_199 VGND VGND VPWR VPWR sky130_fd_sc_hd__fill_1
XFILLER_45_328 VGND VGND VPWR VPWR sky130_fd_sc_hd__decap_8
X_08689_ _01143_ _01155_ VGND VGND VPWR VPWR _01156_ sky130_fd_sc_hd__nand2b_1
X_07709_ _00187_ _00150_ VGND VGND VPWR VPWR _00188_ sky130_fd_sc_hd__nand2b_1
XFILLER_81_692 VGND VGND VPWR VPWR sky130_fd_sc_hd__fill_2
XFILLER_41_534 VGND VGND VPWR VPWR sky130_fd_sc_hd__decap_4
XFILLER_13_225 VGND VGND VPWR VPWR sky130_fd_sc_hd__decap_4
X_10720_ _03101_ _03104_ _03346_ _03349_ VGND VGND VPWR VPWR _03350_ sky130_fd_sc_hd__o211a_1
XFILLER_110_41 VPWR VGND VPWR VGND sky130_ef_sc_hd__decap_12
XFILLER_13_258 VGND VGND VPWR VPWR sky130_fd_sc_hd__fill_1
XFILLER_110_85 VPWR VGND VPWR VGND sky130_ef_sc_hd__decap_12
XFILLER_13_269 VGND VGND VPWR VPWR sky130_fd_sc_hd__decap_8
X_10651_ _03265_ _03273_ VGND VGND VPWR VPWR _03274_ sky130_fd_sc_hd__and2_1
X_13370_ _05971_ _06238_ VGND VGND VPWR VPWR _06239_ sky130_fd_sc_hd__xor2_2
X_10582_ _03196_ _03197_ _03077_ VGND VGND VPWR VPWR _03199_ sky130_fd_sc_hd__a21o_1
XFILLER_127_617 VGND VGND VPWR VPWR sky130_fd_sc_hd__decap_6
X_12321_ net583 net500 net423 net593 VGND VGND VPWR VPWR _05093_ sky130_fd_sc_hd__a22o_1
XFILLER_70_89 VGND VGND VPWR VPWR sky130_fd_sc_hd__fill_1
XTAP_TAPCELL_ROW_11_459 VGND VPWR sky130_fd_sc_hd__tapvpwrvgnd_1
X_12252_ _05016_ _05017_ VGND VGND VPWR VPWR _05018_ sky130_fd_sc_hd__or2_1
XTAP_TAPCELL_ROW_114_1948 VGND VPWR sky130_fd_sc_hd__tapvpwrvgnd_1
XFILLER_79_21 VPWR VGND VPWR VGND sky130_ef_sc_hd__decap_12
X_11203_ _03875_ _03876_ VGND VGND VPWR VPWR _03877_ sky130_fd_sc_hd__nor2_1
XFILLER_5_468 VPWR VGND VPWR VGND sky130_ef_sc_hd__decap_12
XTAP_TAPCELL_ROW_114_1959 VGND VPWR sky130_fd_sc_hd__tapvpwrvgnd_1
X_12183_ net565 net556 net696 net679 VGND VGND VPWR VPWR _04942_ sky130_fd_sc_hd__and4_1
XFILLER_134_193 VGND VGND VPWR VPWR sky130_fd_sc_hd__decap_3
X_11134_ _03654_ _03661_ _03660_ VGND VGND VPWR VPWR _03802_ sky130_fd_sc_hd__a21oi_1
XFILLER_110_528 VGND VGND VPWR VPWR sky130_fd_sc_hd__decap_4
XFILLER_103_580 VGND VGND VPWR VPWR sky130_fd_sc_hd__decap_4
XFILLER_49_601 VGND VGND VPWR VPWR sky130_fd_sc_hd__decap_3
X_11065_ net546 net308 _03551_ _03550_ net306 VGND VGND VPWR VPWR _03726_ sky130_fd_sc_hd__a32o_1
XFILLER_135_93 VPWR VGND VPWR VGND sky130_ef_sc_hd__decap_12
X_10016_ _02496_ _02581_ VGND VGND VPWR VPWR _02584_ sky130_fd_sc_hd__nor2_1
XFILLER_48_133 VGND VGND VPWR VPWR sky130_fd_sc_hd__decap_6
XFILLER_76_464 VPWR VGND VPWR VGND sky130_ef_sc_hd__decap_12
XFILLER_49_678 VGND VGND VPWR VPWR sky130_fd_sc_hd__decap_8
XFILLER_91_434 VGND VGND VPWR VPWR sky130_fd_sc_hd__decap_6
XFILLER_63_125 VPWR VGND VPWR VGND sky130_ef_sc_hd__decap_12
XFILLER_29_380 VGND VGND VPWR VPWR sky130_fd_sc_hd__fill_1
XFILLER_29_391 VGND VGND VPWR VPWR sky130_fd_sc_hd__fill_1
X_11967_ _04704_ _04705_ VGND VGND VPWR VPWR _04706_ sky130_fd_sc_hd__and2b_1
XFILLER_63_169 VGND VGND VPWR VPWR sky130_fd_sc_hd__decap_4
XFILLER_72_692 VGND VGND VPWR VPWR sky130_fd_sc_hd__decap_8
X_10918_ _03546_ _03564_ VGND VGND VPWR VPWR _03566_ sky130_fd_sc_hd__xnor2_1
XFILLER_32_523 VGND VGND VPWR VPWR sky130_fd_sc_hd__fill_1
XFILLER_71_191 VPWR VGND VPWR VGND sky130_ef_sc_hd__decap_12
X_11898_ _04626_ _04633_ VGND VGND VPWR VPWR _04635_ sky130_fd_sc_hd__xnor2_1
X_13637_ clknet_3_6__leaf_clk _00026_ net716 VGND VGND VPWR VPWR net172 sky130_fd_sc_hd__dfrtp_1
X_10849_ net644 net72 _03488_ _03490_ VGND VGND VPWR VPWR _03491_ sky130_fd_sc_hd__o2bb2a_1
XFILLER_32_589 VGND VGND VPWR VPWR sky130_fd_sc_hd__decap_8
X_13568_ _06452_ _06453_ VGND VGND VPWR VPWR _06455_ sky130_fd_sc_hd__xnor2_1
XTAP_TAPCELL_ROW_30_735 VGND VPWR sky130_fd_sc_hd__tapvpwrvgnd_1
X_12519_ _05309_ _05276_ VGND VGND VPWR VPWR _05310_ sky130_fd_sc_hd__and2b_1
XFILLER_9_785 VPWR VGND VPWR VGND sky130_ef_sc_hd__decap_12
X_13499_ _06369_ _06377_ VGND VGND VPWR VPWR _06380_ sky130_fd_sc_hd__xnor2_1
XFILLER_8_295 VGND VGND VPWR VPWR sky130_fd_sc_hd__fill_1
XFILLER_126_683 VGND VGND VPWR VPWR sky130_fd_sc_hd__fill_1
XFILLER_5_51 VGND VGND VPWR VPWR sky130_fd_sc_hd__decap_4
XFILLER_113_366 VGND VGND VPWR VPWR sky130_fd_sc_hd__decap_8
XFILLER_113_333 VGND VGND VPWR VPWR sky130_fd_sc_hd__decap_3
XFILLER_99_556 VGND VGND VPWR VPWR sky130_fd_sc_hd__decap_4
XFILLER_87_729 VPWR VGND VPWR VGND sky130_ef_sc_hd__decap_12
X_07991_ _00434_ _00467_ VGND VGND VPWR VPWR _00468_ sky130_fd_sc_hd__and2b_1
X_09730_ net629 net620 net367 VGND VGND VPWR VPWR _02274_ sky130_fd_sc_hd__o21a_1
X_06942_ net590 net693 net698 net581 VGND VGND VPWR VPWR _02706_ sky130_fd_sc_hd__a22oi_1
XPHY_EDGE_ROW_105_Left_244 VGND VGND VPWR VPWR sky130_fd_sc_hd__decap_3
XFILLER_39_111 VGND VGND VPWR VPWR sky130_fd_sc_hd__fill_1
X_09661_ _02195_ _02197_ VGND VGND VPWR VPWR _02198_ sky130_fd_sc_hd__nor2_1
XFILLER_95_773 VGND VGND VPWR VPWR sky130_fd_sc_hd__decap_8
XFILLER_95_762 VGND VGND VPWR VPWR sky130_fd_sc_hd__fill_2
X_06873_ net268 net642 net710 net654 VGND VGND VPWR VPWR _01954_ sky130_fd_sc_hd__a22o_1
XFILLER_55_615 VGND VGND VPWR VPWR sky130_fd_sc_hd__fill_1
X_08612_ net50 _01078_ VGND VGND VPWR VPWR _01079_ sky130_fd_sc_hd__and2_1
X_09592_ _02116_ _02121_ VGND VGND VPWR VPWR _02123_ sky130_fd_sc_hd__xor2_1
XFILLER_94_283 VGND VGND VPWR VPWR sky130_fd_sc_hd__decap_4
XFILLER_54_136 VGND VGND VPWR VPWR sky130_fd_sc_hd__fill_1
XFILLER_54_125 VGND VGND VPWR VPWR sky130_fd_sc_hd__decap_4
XTAP_TAPCELL_ROW_38_846 VGND VPWR sky130_fd_sc_hd__tapvpwrvgnd_1
X_08543_ _00999_ _01010_ VGND VGND VPWR VPWR _01012_ sky130_fd_sc_hd__xnor2_1
XFILLER_54_147 VGND VGND VPWR VPWR sky130_fd_sc_hd__fill_1
XFILLER_42_309 VPWR VGND VPWR VGND sky130_ef_sc_hd__decap_12
XTAP_TAPCELL_ROW_38_857 VGND VPWR sky130_fd_sc_hd__tapvpwrvgnd_1
XFILLER_82_489 VPWR VGND VPWR VGND sky130_ef_sc_hd__decap_12
XFILLER_70_629 VGND VGND VPWR VPWR sky130_fd_sc_hd__fill_2
X_08474_ _00850_ _00879_ _00849_ VGND VGND VPWR VPWR _00947_ sky130_fd_sc_hd__a21oi_1
XFILLER_24_27 VGND VGND VPWR VPWR sky130_fd_sc_hd__fill_1
XTAP_TAPCELL_ROW_118_2004 VGND VPWR sky130_fd_sc_hd__tapvpwrvgnd_1
XPHY_EDGE_ROW_114_Left_253 VGND VGND VPWR VPWR sky130_fd_sc_hd__decap_3
X_07425_ _06624_ _06654_ VGND VGND VPWR VPWR _06655_ sky130_fd_sc_hd__xnor2_1
XFILLER_23_589 VGND VGND VPWR VPWR sky130_fd_sc_hd__decap_6
XTAP_TAPCELL_ROW_118_2015 VGND VPWR sky130_fd_sc_hd__tapvpwrvgnd_1
X_07356_ _06584_ _06585_ VGND VGND VPWR VPWR _06586_ sky130_fd_sc_hd__and2b_1
XFILLER_109_617 VGND VGND VPWR VPWR sky130_fd_sc_hd__decap_6
X_07287_ _06356_ _06443_ _06454_ VGND VGND VPWR VPWR _06465_ sky130_fd_sc_hd__nand3_1
XFILLER_40_15 VPWR VGND VPWR VGND sky130_ef_sc_hd__decap_12
XTAP_TAPCELL_ROW_131_2204 VGND VPWR sky130_fd_sc_hd__tapvpwrvgnd_1
X_09026_ _01267_ _01270_ _01504_ _01505_ VGND VGND VPWR VPWR _01506_ sky130_fd_sc_hd__o211ai_2
XFILLER_108_149 VGND VGND VPWR VPWR sky130_fd_sc_hd__decap_4
X_09928_ _02462_ _02487_ VGND VGND VPWR VPWR _02489_ sky130_fd_sc_hd__xnor2_1
XPHY_EDGE_ROW_123_Left_262 VGND VGND VPWR VPWR sky130_fd_sc_hd__decap_3
XFILLER_104_388 VPWR VGND VPWR VGND sky130_ef_sc_hd__decap_12
XFILLER_77_206 VGND VGND VPWR VPWR sky130_fd_sc_hd__fill_1
XFILLER_49_57 VPWR VGND VPWR VGND sky130_ef_sc_hd__decap_12
XTAP_TAPCELL_ROW_129_2166 VGND VPWR sky130_fd_sc_hd__tapvpwrvgnd_1
X_09859_ net438 net429 net329 VGND VGND VPWR VPWR _02415_ sky130_fd_sc_hd__o21ai_1
XFILLER_92_209 VGND VGND VPWR VPWR sky130_fd_sc_hd__decap_8
XFILLER_73_401 VGND VGND VPWR VPWR sky130_fd_sc_hd__decap_8
XFILLER_58_475 VGND VGND VPWR VPWR sky130_fd_sc_hd__fill_1
XFILLER_100_583 VGND VGND VPWR VPWR sky130_fd_sc_hd__decap_4
XFILLER_85_272 VGND VGND VPWR VPWR sky130_fd_sc_hd__decap_3
X_12870_ _05689_ _05691_ net613 net338 VGND VGND VPWR VPWR _05693_ sky130_fd_sc_hd__and4bb_1
XFILLER_18_328 VPWR VGND VPWR VGND sky130_ef_sc_hd__decap_12
XFILLER_45_169 VGND VGND VPWR VPWR sky130_fd_sc_hd__decap_8
XFILLER_45_158 VGND VGND VPWR VPWR sky130_fd_sc_hd__decap_4
X_11821_ _04441_ _04444_ _04369_ VGND VGND VPWR VPWR _04551_ sky130_fd_sc_hd__o21a_1
XFILLER_121_51 VGND VGND VPWR VPWR sky130_fd_sc_hd__decap_4
XFILLER_60_128 VGND VGND VPWR VPWR sky130_fd_sc_hd__fill_1
XTAP_TAPCELL_ROW_16_529 VGND VPWR sky130_fd_sc_hd__tapvpwrvgnd_1
XFILLER_26_372 VGND VGND VPWR VPWR sky130_fd_sc_hd__decap_3
XPHY_EDGE_ROW_132_Left_271 VGND VGND VPWR VPWR sky130_fd_sc_hd__decap_3
XFILLER_14_545 VPWR VGND VPWR VGND sky130_ef_sc_hd__decap_12
X_11752_ _04468_ _04474_ VGND VGND VPWR VPWR _04476_ sky130_fd_sc_hd__xnor2_1
XFILLER_81_55 VGND VGND VPWR VPWR sky130_fd_sc_hd__fill_1
XFILLER_14_589 VGND VGND VPWR VPWR sky130_fd_sc_hd__decap_6
X_11683_ _04220_ _04229_ _04228_ VGND VGND VPWR VPWR _04401_ sky130_fd_sc_hd__a21oi_1
X_10703_ _03310_ _03329_ _03330_ VGND VGND VPWR VPWR _03331_ sky130_fd_sc_hd__and3_1
X_13422_ _06295_ VGND VGND VPWR VPWR _06296_ sky130_fd_sc_hd__inv_2
X_10634_ net502 net292 VGND VGND VPWR VPWR _03255_ sky130_fd_sc_hd__nand2_1
X_13353_ net613 _05986_ _05983_ VGND VGND VPWR VPWR _06220_ sky130_fd_sc_hd__a21o_1
XFILLER_127_447 VGND VGND VPWR VPWR sky130_fd_sc_hd__fill_1
X_12304_ net566 net556 net679 net660 VGND VGND VPWR VPWR _05074_ sky130_fd_sc_hd__and4_1
XFILLER_5_210 VGND VGND VPWR VPWR sky130_fd_sc_hd__fill_2
X_10565_ _03176_ _03177_ _03178_ VGND VGND VPWR VPWR _03180_ sky130_fd_sc_hd__a21oi_1
XFILLER_127_469 VGND VGND VPWR VPWR sky130_fd_sc_hd__fill_1
X_13284_ _06102_ _06143_ VGND VGND VPWR VPWR _06145_ sky130_fd_sc_hd__or2_1
XTAP_TAPCELL_ROW_58_1139 VGND VPWR sky130_fd_sc_hd__tapvpwrvgnd_1
XFILLER_6_755 VGND VGND VPWR VPWR sky130_fd_sc_hd__fill_1
X_10496_ _02930_ _02933_ _03103_ VGND VGND VPWR VPWR _03104_ sky130_fd_sc_hd__a21oi_2
XFILLER_135_480 VPWR VGND VPWR VGND sky130_ef_sc_hd__decap_12
XFILLER_107_160 VGND VGND VPWR VPWR sky130_fd_sc_hd__fill_1
X_12235_ net439 net430 net393 net391 VGND VGND VPWR VPWR _04999_ sky130_fd_sc_hd__and4_1
XFILLER_122_130 VGND VGND VPWR VPWR sky130_fd_sc_hd__fill_2
X_12166_ _04920_ _04922_ _04923_ VGND VGND VPWR VPWR _04924_ sky130_fd_sc_hd__nand3_2
XTAP_TAPCELL_ROW_71_1328 VGND VPWR sky130_fd_sc_hd__tapvpwrvgnd_1
XFILLER_123_697 VGND VGND VPWR VPWR sky130_fd_sc_hd__decap_3
XFILLER_69_729 VPWR VGND VPWR VGND sky130_ef_sc_hd__decap_12
X_11117_ net416 net279 _03634_ _03633_ VGND VGND VPWR VPWR _03783_ sky130_fd_sc_hd__a31o_1
X_12097_ net634 net624 net404 net387 VGND VGND VPWR VPWR _04848_ sky130_fd_sc_hd__and4_1
Xinput8 w00[6] VGND VGND VPWR VPWR net8 sky130_fd_sc_hd__clkbuf_2
XFILLER_64_401 VGND VGND VPWR VPWR sky130_fd_sc_hd__decap_4
X_11048_ _03528_ _03707_ VGND VGND VPWR VPWR _03709_ sky130_fd_sc_hd__xnor2_1
XFILLER_37_615 VGND VGND VPWR VPWR sky130_fd_sc_hd__fill_1
XFILLER_92_743 VGND VGND VPWR VPWR sky130_fd_sc_hd__fill_1
XFILLER_92_732 VGND VGND VPWR VPWR sky130_fd_sc_hd__fill_2
XFILLER_91_253 VGND VGND VPWR VPWR sky130_fd_sc_hd__decap_8
XFILLER_24_309 VGND VGND VPWR VPWR sky130_fd_sc_hd__decap_8
XTAP_TAPCELL_ROW_35_805 VGND VPWR sky130_fd_sc_hd__tapvpwrvgnd_1
XFILLER_91_297 VGND VGND VPWR VPWR sky130_fd_sc_hd__fill_1
X_12999_ _05689_ _05693_ VGND VGND VPWR VPWR _05834_ sky130_fd_sc_hd__nor2_1
XFILLER_64_489 VGND VGND VPWR VPWR sky130_fd_sc_hd__decap_8
XFILLER_33_821 VGND VGND VPWR VPWR sky130_fd_sc_hd__decap_3
X_08190_ _00664_ _00665_ VGND VGND VPWR VPWR _00666_ sky130_fd_sc_hd__nor2_1
X_07210_ net701 net546 VGND VGND VPWR VPWR _05624_ sky130_fd_sc_hd__nand2_1
X_07141_ net459 net451 net667 net669 VGND VGND VPWR VPWR _04871_ sky130_fd_sc_hd__and4_1
X_07072_ _04014_ _04024_ _04057_ _04101_ VGND VGND VPWR VPWR _04123_ sky130_fd_sc_hd__a211oi_1
XFILLER_10_29 VPWR VGND VPWR VGND sky130_ef_sc_hd__decap_12
XFILLER_126_29 VPWR VGND VPWR VGND sky130_ef_sc_hd__decap_12
X_07974_ net251 _00322_ _00321_ VGND VGND VPWR VPWR _00451_ sky130_fd_sc_hd__o21ai_1
XFILLER_19_27 VPWR VGND VPWR VGND sky130_ef_sc_hd__decap_12
X_09713_ _02225_ _02254_ VGND VGND VPWR VPWR _02255_ sky130_fd_sc_hd__and2b_1
XFILLER_67_250 VPWR VGND VPWR VGND sky130_ef_sc_hd__decap_12
X_06925_ _02499_ _02510_ VGND VGND VPWR VPWR _02521_ sky130_fd_sc_hd__xor2_1
X_09644_ _02178_ _02179_ VGND VGND VPWR VPWR _00055_ sky130_fd_sc_hd__and2_1
X_06856_ _01692_ _01758_ VGND VGND VPWR VPWR _01769_ sky130_fd_sc_hd__nand2_1
XFILLER_43_607 VGND VGND VPWR VPWR sky130_fd_sc_hd__decap_4
XFILLER_35_15 VPWR VGND VPWR VGND sky130_ef_sc_hd__decap_12
XTAP_TAPCELL_ROW_124_2096 VGND VPWR sky130_fd_sc_hd__tapvpwrvgnd_1
X_09575_ _02089_ _02103_ VGND VGND VPWR VPWR _02104_ sky130_fd_sc_hd__xnor2_1
XFILLER_82_297 VGND VGND VPWR VPWR sky130_fd_sc_hd__decap_8
X_08526_ _02402_ _04221_ VGND VGND VPWR VPWR _00040_ sky130_fd_sc_hd__xnor2_1
XFILLER_42_139 VGND VGND VPWR VPWR sky130_fd_sc_hd__fill_1
XFILLER_51_673 VGND VGND VPWR VPWR sky130_fd_sc_hd__fill_1
X_08457_ _00862_ _00929_ VGND VGND VPWR VPWR _00930_ sky130_fd_sc_hd__nand2b_1
X_07408_ _06634_ _06635_ VGND VGND VPWR VPWR _06638_ sky130_fd_sc_hd__xnor2_1
XFILLER_51_69 VGND VGND VPWR VPWR sky130_fd_sc_hd__decap_8
X_08388_ net252 _00755_ VGND VGND VPWR VPWR _00862_ sky130_fd_sc_hd__nor2_1
XFILLER_11_559 VGND VGND VPWR VPWR sky130_fd_sc_hd__fill_1
X_07339_ _06568_ _06569_ VGND VGND VPWR VPWR _06570_ sky130_fd_sc_hd__and2b_1
XFILLER_136_244 VGND VGND VPWR VPWR sky130_fd_sc_hd__decap_8
X_10350_ net295 _02889_ _02944_ VGND VGND VPWR VPWR _02945_ sky130_fd_sc_hd__a21bo_1
XTAP_TAPCELL_ROW_21_598 VGND VPWR sky130_fd_sc_hd__tapvpwrvgnd_1
XFILLER_136_288 VGND VGND VPWR VPWR sky130_fd_sc_hd__fill_1
XFILLER_117_480 VPWR VGND VPWR VGND sky130_ef_sc_hd__decap_12
X_09009_ _01483_ _01484_ _01485_ VGND VGND VPWR VPWR _01488_ sky130_fd_sc_hd__a21o_1
X_10281_ net589 net580 net311 net310 VGND VGND VPWR VPWR _02870_ sky130_fd_sc_hd__and4_1
XTAP_TAPCELL_ROW_111_1907 VGND VPWR sky130_fd_sc_hd__tapvpwrvgnd_1
X_12020_ net18 net402 _04684_ VGND VGND VPWR VPWR _04764_ sky130_fd_sc_hd__o21ai_1
XFILLER_120_612 VPWR VGND VPWR VGND sky130_ef_sc_hd__decap_12
XFILLER_120_601 VGND VGND VPWR VPWR sky130_fd_sc_hd__decap_4
XFILLER_105_697 VPWR VGND VPWR VGND sky130_ef_sc_hd__decap_12
XFILLER_104_141 VGND VGND VPWR VPWR sky130_fd_sc_hd__fill_1
XFILLER_120_645 VGND VGND VPWR VPWR sky130_fd_sc_hd__fill_2
Xfanout550 net551 VGND VGND VPWR VPWR net550 sky130_fd_sc_hd__buf_4
XTAP_TAPCELL_ROW_53_1069 VGND VPWR sky130_fd_sc_hd__tapvpwrvgnd_1
Xfanout572 net576 VGND VGND VPWR VPWR net572 sky130_fd_sc_hd__buf_2
Xfanout583 net587 VGND VGND VPWR VPWR net583 sky130_fd_sc_hd__clkbuf_4
XFILLER_93_529 VPWR VGND VPWR VGND sky130_ef_sc_hd__decap_12
XFILLER_65_209 VPWR VGND VPWR VGND sky130_ef_sc_hd__decap_12
XFILLER_59_773 VGND VGND VPWR VPWR sky130_fd_sc_hd__fill_2
Xfanout561 net562 VGND VGND VPWR VPWR net561 sky130_fd_sc_hd__clkbuf_4
Xfanout594 net597 VGND VGND VPWR VPWR net594 sky130_fd_sc_hd__dlymetal6s2s_1
X_12922_ _05747_ _05748_ VGND VGND VPWR VPWR _05749_ sky130_fd_sc_hd__xnor2_1
XFILLER_74_743 VGND VGND VPWR VPWR sky130_fd_sc_hd__fill_1
XFILLER_58_272 VPWR VGND VPWR VGND sky130_ef_sc_hd__decap_12
XFILLER_73_220 VGND VGND VPWR VPWR sky130_fd_sc_hd__fill_1
XFILLER_46_467 VGND VGND VPWR VPWR sky130_fd_sc_hd__decap_8
XFILLER_46_456 VGND VGND VPWR VPWR sky130_fd_sc_hd__fill_1
XFILLER_132_83 VGND VGND VPWR VPWR sky130_fd_sc_hd__fill_1
X_12853_ _05666_ _05673_ VGND VGND VPWR VPWR _05674_ sky130_fd_sc_hd__xnor2_1
XFILLER_34_618 VPWR VGND VPWR VGND sky130_ef_sc_hd__decap_12
XFILLER_92_65 VPWR VGND VPWR VGND sky130_ef_sc_hd__decap_12
X_12784_ _05459_ _05468_ _05467_ VGND VGND VPWR VPWR _05598_ sky130_fd_sc_hd__a21oi_1
XTAP_TAPCELL_ROW_68_1290 VGND VPWR sky130_fd_sc_hd__tapvpwrvgnd_1
XFILLER_61_437 VGND VGND VPWR VPWR sky130_fd_sc_hd__decap_8
X_11804_ _04433_ _04532_ VGND VGND VPWR VPWR _04533_ sky130_fd_sc_hd__xnor2_1
XFILLER_26_180 VGND VGND VPWR VPWR sky130_fd_sc_hd__decap_8
XFILLER_26_191 VGND VGND VPWR VPWR sky130_fd_sc_hd__decap_4
XFILLER_42_673 VPWR VGND VPWR VGND sky130_ef_sc_hd__decap_12
XFILLER_41_150 VGND VGND VPWR VPWR sky130_fd_sc_hd__fill_1
XFILLER_14_342 VGND VGND VPWR VPWR sky130_fd_sc_hd__fill_1
X_11735_ _04453_ _04456_ VGND VGND VPWR VPWR _04457_ sky130_fd_sc_hd__and2_1
XFILLER_30_813 VGND VGND VPWR VPWR sky130_fd_sc_hd__decap_6
XFILLER_128_723 VGND VGND VPWR VPWR sky130_fd_sc_hd__fill_2
X_13405_ _06249_ _06275_ VGND VGND VPWR VPWR _06277_ sky130_fd_sc_hd__xnor2_1
X_11666_ net483 net474 net286 VGND VGND VPWR VPWR _04382_ sky130_fd_sc_hd__and3_1
XFILLER_127_211 VGND VGND VPWR VPWR sky130_fd_sc_hd__decap_6
X_11597_ _04205_ _04207_ _04305_ VGND VGND VPWR VPWR _04306_ sky130_fd_sc_hd__o21ba_1
X_10617_ _03225_ _03235_ VGND VGND VPWR VPWR _03236_ sky130_fd_sc_hd__xor2_1
XTAP_TAPCELL_ROW_40_874 VGND VPWR sky130_fd_sc_hd__tapvpwrvgnd_1
XTAP_TAPCELL_ROW_40_885 VGND VPWR sky130_fd_sc_hd__tapvpwrvgnd_1
XFILLER_127_266 VPWR VGND VPWR VGND sky130_ef_sc_hd__decap_12
X_13336_ _06194_ _06199_ VGND VGND VPWR VPWR _06201_ sky130_fd_sc_hd__xor2_1
X_10548_ net651 net643 net319 net317 VGND VGND VPWR VPWR _03162_ sky130_fd_sc_hd__and4_1
X_13267_ _05826_ _05978_ VGND VGND VPWR VPWR _06126_ sky130_fd_sc_hd__nand2_1
X_12218_ _04976_ _04977_ _04978_ VGND VGND VPWR VPWR _04981_ sky130_fd_sc_hd__a21o_1
X_10479_ _03083_ _03085_ VGND VGND VPWR VPWR _03086_ sky130_fd_sc_hd__nand2_1
XFILLER_123_472 VGND VGND VPWR VPWR sky130_fd_sc_hd__decap_6
X_13198_ _05902_ _06049_ VGND VGND VPWR VPWR _06051_ sky130_fd_sc_hd__xnor2_1
X_12149_ _04715_ _04719_ _04714_ VGND VGND VPWR VPWR _04906_ sky130_fd_sc_hd__a21o_1
XFILLER_69_559 VGND VGND VPWR VPWR sky130_fd_sc_hd__fill_1
XFILLER_84_507 VGND VGND VPWR VPWR sky130_fd_sc_hd__fill_1
XFILLER_2_41 VPWR VGND VPWR VGND sky130_ef_sc_hd__decap_12
XFILLER_110_177 VPWR VGND VPWR VGND sky130_ef_sc_hd__decap_12
XFILLER_65_743 VGND VGND VPWR VPWR sky130_fd_sc_hd__fill_1
XFILLER_49_261 VGND VGND VPWR VPWR sky130_fd_sc_hd__decap_8
XFILLER_2_85 VPWR VGND VPWR VGND sky130_ef_sc_hd__decap_12
XFILLER_65_776 VGND VGND VPWR VPWR sky130_fd_sc_hd__decap_8
X_07690_ _06768_ _06770_ _06767_ VGND VGND VPWR VPWR _00169_ sky130_fd_sc_hd__a21o_1
XTAP_TAPCELL_ROW_84_1519 VGND VPWR sky130_fd_sc_hd__tapvpwrvgnd_1
XFILLER_80_713 VGND VGND VPWR VPWR sky130_fd_sc_hd__decap_3
XFILLER_64_253 VGND VGND VPWR VPWR sky130_fd_sc_hd__decap_8
XTAP_TAPCELL_ROW_48_996 VGND VPWR sky130_fd_sc_hd__tapvpwrvgnd_1
XFILLER_18_681 VGND VGND VPWR VPWR sky130_fd_sc_hd__decap_4
X_09360_ net564 net555 net358 net355 VGND VGND VPWR VPWR _01870_ sky130_fd_sc_hd__and4_1
XFILLER_80_768 VPWR VGND VPWR VGND sky130_ef_sc_hd__decap_12
XFILLER_80_757 VGND VGND VPWR VPWR sky130_fd_sc_hd__decap_3
X_09291_ net600 _01409_ _01621_ _01619_ VGND VGND VPWR VPWR _01795_ sky130_fd_sc_hd__a31o_1
X_08311_ _00783_ _00784_ VGND VGND VPWR VPWR _00786_ sky130_fd_sc_hd__xor2_1
XFILLER_33_662 VGND VGND VPWR VPWR sky130_fd_sc_hd__decap_3
XANTENNA_13 net153 VGND VGND VPWR VPWR sky130_fd_sc_hd__diode_2
XFILLER_60_481 VGND VGND VPWR VPWR sky130_fd_sc_hd__fill_1
X_08242_ _00701_ _00716_ VGND VGND VPWR VPWR _00717_ sky130_fd_sc_hd__xnor2_1
XANTENNA_24 net482 VGND VGND VPWR VPWR sky130_fd_sc_hd__diode_2
XTAP_TAPCELL_ROW_99_1740 VGND VPWR sky130_fd_sc_hd__tapvpwrvgnd_1
X_08173_ net663 _00648_ VGND VGND VPWR VPWR _00649_ sky130_fd_sc_hd__nand2_1
X_07124_ net519 net681 VGND VGND VPWR VPWR _04686_ sky130_fd_sc_hd__and2_1
XFILLER_21_39 VPWR VGND VPWR VGND sky130_ef_sc_hd__decap_12
XFILLER_137_39 VPWR VGND VPWR VGND sky130_ef_sc_hd__decap_12
XFILLER_134_737 VPWR VGND VPWR VGND sky130_ef_sc_hd__decap_12
XFILLER_133_225 VGND VGND VPWR VPWR sky130_fd_sc_hd__decap_4
XFILLER_133_203 VPWR VGND VPWR VGND sky130_ef_sc_hd__decap_12
X_07055_ _03850_ _03915_ _03926_ VGND VGND VPWR VPWR _03937_ sky130_fd_sc_hd__and3_2
Xoutput186 net186 VGND VGND VPWR VPWR y1[16] sky130_fd_sc_hd__buf_2
Xoutput164 net164 VGND VGND VPWR VPWR y0[11] sky130_fd_sc_hd__buf_2
XFILLER_88_813 VGND VGND VPWR VPWR sky130_fd_sc_hd__decap_8
XFILLER_87_301 VPWR VGND VPWR VGND sky130_ef_sc_hd__decap_12
Xoutput175 net175 VGND VGND VPWR VPWR y0[6] sky130_fd_sc_hd__buf_2
XFILLER_101_111 VGND VGND VPWR VPWR sky130_fd_sc_hd__fill_1
Xoutput197 net197 VGND VGND VPWR VPWR y2[10] sky130_fd_sc_hd__buf_2
XFILLER_102_667 VGND VGND VPWR VPWR sky130_fd_sc_hd__fill_2
X_07957_ _00316_ _00329_ _00328_ VGND VGND VPWR VPWR _00434_ sky130_fd_sc_hd__o21a_1
XTAP_TAPCELL_ROW_126_2125 VGND VPWR sky130_fd_sc_hd__tapvpwrvgnd_1
XFILLER_56_732 VGND VGND VPWR VPWR sky130_fd_sc_hd__fill_1
X_06908_ _02315_ _02325_ VGND VGND VPWR VPWR _02336_ sky130_fd_sc_hd__or2_1
X_07888_ _00243_ _00251_ _00250_ VGND VGND VPWR VPWR _00366_ sky130_fd_sc_hd__a21o_1
XFILLER_28_445 VPWR VGND VPWR VGND sky130_ef_sc_hd__decap_12
X_09627_ _02159_ _02160_ VGND VGND VPWR VPWR _02161_ sky130_fd_sc_hd__and2b_1
XFILLER_83_573 VPWR VGND VPWR VGND sky130_ef_sc_hd__decap_12
X_06839_ _01551_ _01562_ VGND VGND VPWR VPWR _00006_ sky130_fd_sc_hd__xnor2_1
XFILLER_55_253 VGND VGND VPWR VPWR sky130_fd_sc_hd__decap_8
X_09558_ _01920_ _01925_ _02083_ _02084_ VGND VGND VPWR VPWR _02086_ sky130_fd_sc_hd__o211a_1
XFILLER_102_53 VPWR VGND VPWR VGND sky130_ef_sc_hd__decap_12
XFILLER_70_223 VGND VGND VPWR VPWR sky130_fd_sc_hd__decap_4
XFILLER_43_437 VGND VGND VPWR VPWR sky130_fd_sc_hd__decap_8
XFILLER_102_97 VPWR VGND VPWR VGND sky130_ef_sc_hd__decap_12
X_08509_ _00915_ _00974_ VGND VGND VPWR VPWR _00981_ sky130_fd_sc_hd__xnor2_1
XFILLER_12_802 VGND VGND VPWR VPWR sky130_fd_sc_hd__decap_8
XFILLER_12_813 VGND VGND VPWR VPWR sky130_fd_sc_hd__decap_6
XTAP_TAPCELL_ROW_26_679 VGND VPWR sky130_fd_sc_hd__tapvpwrvgnd_1
X_09489_ _02007_ _02008_ VGND VGND VPWR VPWR _02011_ sky130_fd_sc_hd__xnor2_1
X_11520_ net274 _03426_ net410 VGND VGND VPWR VPWR _04224_ sky130_fd_sc_hd__and3b_1
XFILLER_134_3 VPWR VGND VPWR VGND sky130_ef_sc_hd__decap_12
X_11451_ _04147_ _04148_ VGND VGND VPWR VPWR _04149_ sky130_fd_sc_hd__nor2_1
XTAP_TAPCELL_ROW_137_2287 VGND VPWR sky130_fd_sc_hd__tapvpwrvgnd_1
XFILLER_109_244 VGND VGND VPWR VPWR sky130_fd_sc_hd__fill_1
XFILLER_7_349 VGND VGND VPWR VPWR sky130_fd_sc_hd__decap_8
X_11382_ net257 net291 VGND VGND VPWR VPWR _04073_ sky130_fd_sc_hd__nor2_1
X_10402_ net641 net328 _02839_ _02838_ VGND VGND VPWR VPWR _03002_ sky130_fd_sc_hd__a31o_1
XFILLER_125_726 VGND VGND VPWR VPWR sky130_fd_sc_hd__fill_2
X_13121_ _05934_ _05966_ VGND VGND VPWR VPWR _05967_ sky130_fd_sc_hd__and2b_1
X_10333_ _02924_ _02925_ VGND VGND VPWR VPWR _02926_ sky130_fd_sc_hd__nor2_1
X_13052_ _05889_ _05890_ VGND VGND VPWR VPWR _05891_ sky130_fd_sc_hd__nor2_1
XFILLER_87_43 VPWR VGND VPWR VGND sky130_ef_sc_hd__decap_12
X_10264_ net460 net450 net90 net281 VGND VGND VPWR VPWR _02851_ sky130_fd_sc_hd__and4_1
X_10195_ _02776_ _02778_ VGND VGND VPWR VPWR _02779_ sky130_fd_sc_hd__xnor2_1
X_12003_ _04735_ _04745_ VGND VGND VPWR VPWR _04746_ sky130_fd_sc_hd__nor2_1
XFILLER_93_337 VGND VGND VPWR VPWR sky130_fd_sc_hd__decap_3
XFILLER_78_389 VPWR VGND VPWR VGND sky130_ef_sc_hd__decap_12
Xfanout380 net33 VGND VGND VPWR VPWR net380 sky130_fd_sc_hd__buf_1
Xfanout391 net27 VGND VGND VPWR VPWR net391 sky130_fd_sc_hd__buf_2
XFILLER_59_592 VPWR VGND VPWR VGND sky130_ef_sc_hd__decap_12
XTAP_TAPCELL_ROW_6_393 VGND VPWR sky130_fd_sc_hd__tapvpwrvgnd_1
XTAP_TAPCELL_ROW_6_382 VGND VPWR sky130_fd_sc_hd__tapvpwrvgnd_1
XFILLER_19_401 VGND VGND VPWR VPWR sky130_fd_sc_hd__decap_3
XFILLER_19_434 VPWR VGND VPWR VGND sky130_ef_sc_hd__decap_12
XFILLER_19_456 VGND VGND VPWR VPWR sky130_fd_sc_hd__decap_8
X_12905_ _05564_ _05568_ VGND VGND VPWR VPWR _05731_ sky130_fd_sc_hd__nor2_1
XFILLER_74_573 VGND VGND VPWR VPWR sky130_fd_sc_hd__fill_1
XFILLER_62_724 VPWR VGND VPWR VGND sky130_ef_sc_hd__decap_12
XFILLER_62_713 VGND VGND VPWR VPWR sky130_fd_sc_hd__fill_1
XFILLER_46_253 VGND VGND VPWR VPWR sky130_fd_sc_hd__fill_2
X_12836_ _05640_ _05654_ VGND VGND VPWR VPWR _05655_ sky130_fd_sc_hd__xnor2_1
XTAP_TAPCELL_ROW_66_1249 VGND VPWR sky130_fd_sc_hd__tapvpwrvgnd_1
XFILLER_61_223 VGND VGND VPWR VPWR sky130_fd_sc_hd__fill_1
XTAP_TAPCELL_ROW_45_955 VGND VPWR sky130_fd_sc_hd__tapvpwrvgnd_1
XFILLER_15_673 VGND VGND VPWR VPWR sky130_fd_sc_hd__fill_2
X_12767_ net555 net501 net423 net564 VGND VGND VPWR VPWR _05579_ sky130_fd_sc_hd__a22oi_1
XFILLER_99_6 VPWR VGND VPWR VGND sky130_ef_sc_hd__decap_12
X_12698_ _05496_ _05503_ _05504_ VGND VGND VPWR VPWR _05506_ sky130_fd_sc_hd__nand3_1
X_11718_ _04437_ VGND VGND VPWR VPWR _04439_ sky130_fd_sc_hd__inv_2
Xinput22 w02[4] VGND VGND VPWR VPWR net22 sky130_fd_sc_hd__clkbuf_2
XFILLER_128_531 VGND VGND VPWR VPWR sky130_fd_sc_hd__fill_1
Xinput11 w01[1] VGND VGND VPWR VPWR net11 sky130_fd_sc_hd__buf_1
X_11649_ _04360_ _04361_ VGND VGND VPWR VPWR _04364_ sky130_fd_sc_hd__xor2_1
XFILLER_30_676 VGND VGND VPWR VPWR sky130_fd_sc_hd__decap_8
Xinput44 w11[2] VGND VGND VPWR VPWR net44 sky130_fd_sc_hd__buf_1
Xinput55 w12[5] VGND VGND VPWR VPWR net55 sky130_fd_sc_hd__buf_1
Xinput33 w03[7] VGND VGND VPWR VPWR net33 sky130_fd_sc_hd__dlymetal6s2s_1
XFILLER_116_726 VGND VGND VPWR VPWR sky130_fd_sc_hd__decap_3
X_13319_ net539 net408 net422 net265 VGND VGND VPWR VPWR _06183_ sky130_fd_sc_hd__o2bb2a_1
XFILLER_6_371 VGND VGND VPWR VPWR sky130_fd_sc_hd__decap_6
Xinput88 w22[6] VGND VGND VPWR VPWR net88 sky130_fd_sc_hd__buf_1
Xinput77 w21[3] VGND VGND VPWR VPWR net77 sky130_fd_sc_hd__buf_1
Xinput66 w20[0] VGND VGND VPWR VPWR net66 sky130_fd_sc_hd__clkbuf_2
XFILLER_115_225 VPWR VGND VPWR VGND sky130_ef_sc_hd__decap_12
Xinput99 w30[1] VGND VGND VPWR VPWR net99 sky130_fd_sc_hd__buf_1
XFILLER_131_718 VGND VGND VPWR VPWR sky130_fd_sc_hd__decap_3
X_08860_ _01323_ _01324_ _01325_ VGND VGND VPWR VPWR _01326_ sky130_fd_sc_hd__nand3_1
XFILLER_69_378 VPWR VGND VPWR VGND sky130_ef_sc_hd__decap_12
X_07811_ _00288_ _00289_ VGND VGND VPWR VPWR _00290_ sky130_fd_sc_hd__nand2_1
XFILLER_29_209 VGND VGND VPWR VPWR sky130_fd_sc_hd__decap_8
X_08791_ net574 net362 VGND VGND VPWR VPWR _01257_ sky130_fd_sc_hd__nand2_1
XFILLER_96_197 VPWR VGND VPWR VGND sky130_ef_sc_hd__decap_12
XFILLER_96_175 VGND VGND VPWR VPWR sky130_fd_sc_hd__decap_8
XFILLER_84_337 VGND VGND VPWR VPWR sky130_fd_sc_hd__fill_1
XFILLER_65_551 VGND VGND VPWR VPWR sky130_fd_sc_hd__decap_8
XFILLER_65_540 VGND VGND VPWR VPWR sky130_fd_sc_hd__fill_2
X_07742_ _00191_ _00220_ VGND VGND VPWR VPWR _00221_ sky130_fd_sc_hd__and2b_1
XFILLER_92_370 VPWR VGND VPWR VGND sky130_ef_sc_hd__decap_12
XFILLER_80_510 VGND VGND VPWR VPWR sky130_fd_sc_hd__fill_1
XFILLER_25_404 VPWR VGND VPWR VGND sky130_ef_sc_hd__decap_12
X_07673_ net560 net552 net692 net690 VGND VGND VPWR VPWR _00152_ sky130_fd_sc_hd__and4_1
XFILLER_37_253 VGND VGND VPWR VPWR sky130_fd_sc_hd__decap_8
X_09412_ _01920_ _01923_ _01922_ VGND VGND VPWR VPWR _01926_ sky130_fd_sc_hd__or3b_1
XFILLER_80_521 VGND VGND VPWR VPWR sky130_fd_sc_hd__decap_8
XFILLER_65_595 VGND VGND VPWR VPWR sky130_fd_sc_hd__decap_6
X_09343_ _01676_ _01678_ _01850_ _01851_ VGND VGND VPWR VPWR _01852_ sky130_fd_sc_hd__o211a_1
XTAP_TAPCELL_ROW_121_2055 VGND VPWR sky130_fd_sc_hd__tapvpwrvgnd_1
XFILLER_25_459 VGND VGND VPWR VPWR sky130_fd_sc_hd__fill_1
XTAP_TAPCELL_ROW_23_627 VGND VPWR sky130_fd_sc_hd__tapvpwrvgnd_1
XTAP_TAPCELL_ROW_23_638 VGND VPWR sky130_fd_sc_hd__tapvpwrvgnd_1
X_09274_ _01773_ _01774_ VGND VGND VPWR VPWR _01776_ sky130_fd_sc_hd__xnor2_1
XFILLER_21_665 VGND VGND VPWR VPWR sky130_fd_sc_hd__decap_6
XFILLER_32_27 VGND VGND VPWR VPWR sky130_fd_sc_hd__fill_1
XFILLER_20_164 VGND VGND VPWR VPWR sky130_fd_sc_hd__decap_3
X_08225_ _00698_ _00699_ VGND VGND VPWR VPWR _00700_ sky130_fd_sc_hd__nor2_1
XFILLER_119_542 VPWR VGND VPWR VGND sky130_ef_sc_hd__decap_12
XFILLER_107_704 VPWR VGND VPWR VGND sky130_ef_sc_hd__decap_12
X_08156_ _00630_ _00631_ VGND VGND VPWR VPWR _00632_ sky130_fd_sc_hd__nor2_1
XFILLER_5_809 VPWR VGND VPWR VGND sky130_ef_sc_hd__decap_12
X_07107_ _03095_ _04493_ VGND VGND VPWR VPWR _04504_ sky130_fd_sc_hd__and2_1
XFILLER_4_319 VGND VGND VPWR VPWR sky130_fd_sc_hd__decap_6
XFILLER_134_545 VPWR VGND VPWR VGND sky130_ef_sc_hd__decap_12
X_08087_ net689 net536 net263 net691 VGND VGND VPWR VPWR _00563_ sky130_fd_sc_hd__o2bb2a_1
X_07038_ _03336_ _03718_ _03740_ VGND VGND VPWR VPWR _03751_ sky130_fd_sc_hd__nor3_2
XFILLER_115_781 VGND VGND VPWR VPWR sky130_fd_sc_hd__decap_3
XFILLER_130_751 VGND VGND VPWR VPWR sky130_fd_sc_hd__decap_4
XTAP_TAPCELL_ROW_50_1028 VGND VPWR sky130_fd_sc_hd__tapvpwrvgnd_1
XTAP_TAPCELL_ROW_50_1017 VGND VPWR sky130_fd_sc_hd__tapvpwrvgnd_1
X_08989_ _01463_ _01465_ VGND VGND VPWR VPWR _01466_ sky130_fd_sc_hd__nor2_1
XFILLER_57_57 VPWR VGND VPWR VGND sky130_ef_sc_hd__decap_12
XFILLER_48_529 VGND VGND VPWR VPWR sky130_fd_sc_hd__decap_3
XFILLER_56_540 VPWR VGND VPWR VGND sky130_ef_sc_hd__decap_12
XTAP_TAPCELL_ROW_3_341 VGND VPWR sky130_fd_sc_hd__tapvpwrvgnd_1
XFILLER_29_765 VPWR VGND VPWR VGND sky130_ef_sc_hd__decap_12
XFILLER_44_713 VGND VGND VPWR VPWR sky130_fd_sc_hd__decap_8
X_10951_ net510 net502 net87 net289 VGND VGND VPWR VPWR _03602_ sky130_fd_sc_hd__and4_1
XFILLER_28_253 VPWR VGND VPWR VGND sky130_ef_sc_hd__decap_12
XTAP_TAPCELL_ROW_106_1839 VGND VPWR sky130_fd_sc_hd__tapvpwrvgnd_1
XFILLER_83_370 VGND VGND VPWR VPWR sky130_fd_sc_hd__decap_3
XFILLER_71_532 VPWR VGND VPWR VGND sky130_ef_sc_hd__decap_12
XFILLER_44_757 VPWR VGND VPWR VGND sky130_ef_sc_hd__decap_12
X_13670_ clknet_3_2__leaf_clk _00002_ net712 VGND VGND VPWR VPWR net205 sky130_fd_sc_hd__dfrtp_1
X_12621_ _05237_ _05246_ _05245_ VGND VGND VPWR VPWR _05421_ sky130_fd_sc_hd__a21bo_1
XFILLER_73_89 VGND VGND VPWR VPWR sky130_fd_sc_hd__fill_1
XTAP_TAPCELL_ROW_42_914 VGND VPWR sky130_fd_sc_hd__tapvpwrvgnd_1
XTAP_TAPCELL_ROW_42_903 VGND VPWR sky130_fd_sc_hd__tapvpwrvgnd_1
X_10882_ _03525_ _03526_ VGND VGND VPWR VPWR _03527_ sky130_fd_sc_hd__nor2_1
XPHY_EDGE_ROW_125_Right_125 VGND VGND VPWR VPWR sky130_fd_sc_hd__decap_3
XFILLER_43_278 VGND VGND VPWR VPWR sky130_fd_sc_hd__fill_2
X_12552_ _05344_ _05345_ VGND VGND VPWR VPWR _05346_ sky130_fd_sc_hd__and2b_1
XFILLER_24_492 VPWR VGND VPWR VGND sky130_ef_sc_hd__decap_12
X_12483_ _05225_ _05269_ VGND VGND VPWR VPWR _05270_ sky130_fd_sc_hd__nand2b_1
XTAP_TAPCELL_ROW_61_1179 VGND VPWR sky130_fd_sc_hd__tapvpwrvgnd_1
X_11503_ _04172_ _04204_ VGND VGND VPWR VPWR _04205_ sky130_fd_sc_hd__nor2_1
XFILLER_8_636 VGND VGND VPWR VPWR sky130_fd_sc_hd__decap_3
XFILLER_8_625 VGND VGND VPWR VPWR sky130_fd_sc_hd__decap_8
XFILLER_8_658 VPWR VGND VPWR VGND sky130_ef_sc_hd__decap_12
XFILLER_7_157 VGND VGND VPWR VPWR sky130_fd_sc_hd__decap_8
XFILLER_11_197 VGND VGND VPWR VPWR sky130_fd_sc_hd__fill_1
X_11434_ net319 net598 VGND VGND VPWR VPWR _04130_ sky130_fd_sc_hd__and2b_1
XFILLER_98_53 VPWR VGND VPWR VGND sky130_ef_sc_hd__decap_12
X_11365_ _04048_ _04053_ VGND VGND VPWR VPWR _04054_ sky130_fd_sc_hd__nand2b_1
XFILLER_125_589 VGND VGND VPWR VPWR sky130_fd_sc_hd__decap_6
XFILLER_113_718 VGND VGND VPWR VPWR sky130_fd_sc_hd__fill_1
X_13104_ _05940_ _05946_ _05947_ VGND VGND VPWR VPWR _05948_ sky130_fd_sc_hd__and3_1
X_10316_ _02905_ _02906_ VGND VGND VPWR VPWR _02907_ sky130_fd_sc_hd__nor2_1
X_11296_ _03972_ _03977_ VGND VGND VPWR VPWR _03979_ sky130_fd_sc_hd__xnor2_1
XFILLER_106_781 VPWR VGND VPWR VGND sky130_ef_sc_hd__decap_12
XFILLER_98_97 VPWR VGND VPWR VGND sky130_ef_sc_hd__decap_12
X_13035_ _05575_ _05721_ _05720_ VGND VGND VPWR VPWR _05873_ sky130_fd_sc_hd__a21oi_1
X_10247_ _02803_ _02832_ VGND VGND VPWR VPWR _02833_ sky130_fd_sc_hd__or2_1
XFILLER_78_153 VGND VGND VPWR VPWR sky130_fd_sc_hd__decap_4
X_10178_ _02682_ _02681_ _02757_ _02759_ VGND VGND VPWR VPWR _02761_ sky130_fd_sc_hd__a31o_1
XFILLER_78_164 VGND VGND VPWR VPWR sky130_fd_sc_hd__decap_4
XFILLER_94_657 VPWR VGND VPWR VGND sky130_ef_sc_hd__decap_12
XFILLER_78_197 VGND VGND VPWR VPWR sky130_fd_sc_hd__fill_1
XFILLER_93_167 VGND VGND VPWR VPWR sky130_fd_sc_hd__fill_1
XFILLER_47_573 VPWR VGND VPWR VGND sky130_ef_sc_hd__decap_12
XFILLER_35_702 VGND VGND VPWR VPWR sky130_fd_sc_hd__fill_1
X_12819_ _05633_ _05634_ _05636_ VGND VGND VPWR VPWR _05637_ sky130_fd_sc_hd__and3_1
XFILLER_50_727 VGND VGND VPWR VPWR sky130_fd_sc_hd__fill_1
X_08010_ _00368_ _00370_ _00367_ VGND VGND VPWR VPWR _00487_ sky130_fd_sc_hd__o21ba_1
XFILLER_8_95 VGND VGND VPWR VPWR sky130_fd_sc_hd__decap_8
X_09961_ _02522_ _02524_ VGND VGND VPWR VPWR _02525_ sky130_fd_sc_hd__nand2_1
XFILLER_116_589 VPWR VGND VPWR VGND sky130_ef_sc_hd__decap_12
XTAP_TAPCELL_ROW_92_1629 VGND VPWR sky130_fd_sc_hd__tapvpwrvgnd_1
XFILLER_89_429 VGND VGND VPWR VPWR sky130_fd_sc_hd__decap_3
X_08912_ _01251_ _01380_ VGND VGND VPWR VPWR _01381_ sky130_fd_sc_hd__nor2_1
X_09892_ _01860_ _02448_ _02024_ _01861_ VGND VGND VPWR VPWR _02450_ sky130_fd_sc_hd__nor4_2
XFILLER_134_29 VPWR VGND VPWR VGND sky130_ef_sc_hd__decap_12
XFILLER_131_559 VGND VGND VPWR VPWR sky130_fd_sc_hd__fill_1
X_08843_ _01154_ _01156_ _01308_ VGND VGND VPWR VPWR _01309_ sky130_fd_sc_hd__a21o_1
XFILLER_84_112 VGND VGND VPWR VPWR sky130_fd_sc_hd__decap_6
XFILLER_57_315 VGND VGND VPWR VPWR sky130_fd_sc_hd__decap_8
X_08774_ _01072_ _01238_ _01240_ VGND VGND VPWR VPWR _01241_ sky130_fd_sc_hd__and3_1
XFILLER_57_337 VGND VGND VPWR VPWR sky130_fd_sc_hd__decap_8
XFILLER_27_27 VPWR VGND VPWR VGND sky130_ef_sc_hd__decap_12
X_07725_ _00201_ _00202_ _00203_ VGND VGND VPWR VPWR _00204_ sky130_fd_sc_hd__and3_1
XTAP_TAPCELL_ROW_0_300 VGND VPWR sky130_fd_sc_hd__tapvpwrvgnd_1
XTAP_TAPCELL_ROW_28_708 VGND VPWR sky130_fd_sc_hd__tapvpwrvgnd_1
XFILLER_53_554 VGND VGND VPWR VPWR sky130_fd_sc_hd__fill_1
X_07656_ _00133_ _00134_ _06720_ _06722_ VGND VGND VPWR VPWR _00136_ sky130_fd_sc_hd__a211oi_1
XFILLER_25_256 VPWR VGND VPWR VGND sky130_ef_sc_hd__decap_12
XFILLER_80_395 VGND VGND VPWR VPWR sky130_fd_sc_hd__decap_4
X_07587_ _06782_ _06815_ VGND VGND VPWR VPWR _06816_ sky130_fd_sc_hd__xor2_1
XFILLER_43_15 VPWR VGND VPWR VGND sky130_ef_sc_hd__decap_12
XFILLER_41_727 VGND VGND VPWR VPWR sky130_fd_sc_hd__fill_1
XFILLER_25_289 VPWR VGND VPWR VGND sky130_ef_sc_hd__decap_12
X_09326_ _01830_ _01831_ _01814_ VGND VGND VPWR VPWR _01833_ sky130_fd_sc_hd__a21o_1
XTAP_TAPCELL_ROW_101_1758 VGND VPWR sky130_fd_sc_hd__tapvpwrvgnd_1
XFILLER_138_125 VPWR VGND VPWR VGND sky130_ef_sc_hd__decap_12
X_09257_ _01755_ _01756_ VGND VGND VPWR VPWR _01757_ sky130_fd_sc_hd__xnor2_1
XTAP_TAPCELL_ROW_101_1769 VGND VPWR sky130_fd_sc_hd__tapvpwrvgnd_1
X_08208_ _00428_ _00678_ _00682_ VGND VGND VPWR VPWR _00684_ sky130_fd_sc_hd__o21a_1
XFILLER_21_484 VGND VGND VPWR VPWR sky130_fd_sc_hd__decap_3
XFILLER_138_169 VPWR VGND VPWR VGND sky130_ef_sc_hd__decap_12
XFILLER_135_821 VGND VGND VPWR VPWR sky130_fd_sc_hd__decap_3
XTAP_TAPCELL_ROW_134_2246 VGND VPWR sky130_fd_sc_hd__tapvpwrvgnd_1
XTAP_TAPCELL_ROW_134_2235 VGND VPWR sky130_fd_sc_hd__tapvpwrvgnd_1
X_09188_ _01680_ _01681_ VGND VGND VPWR VPWR _01683_ sky130_fd_sc_hd__or2_1
XFILLER_107_501 VGND VGND VPWR VPWR sky130_fd_sc_hd__decap_3
XFILLER_5_617 VPWR VGND VPWR VGND sky130_ef_sc_hd__decap_12
X_08139_ _00613_ _00614_ VGND VGND VPWR VPWR _00615_ sky130_fd_sc_hd__nor2_1
XFILLER_108_41 VPWR VGND VPWR VGND sky130_ef_sc_hd__decap_12
XTAP_TAPCELL_ROW_8_411 VGND VPWR sky130_fd_sc_hd__tapvpwrvgnd_1
X_11150_ net261 net325 _03463_ _03658_ VGND VGND VPWR VPWR _03820_ sky130_fd_sc_hd__o31ai_2
X_10101_ _02321_ _02569_ _02567_ VGND VGND VPWR VPWR _02678_ sky130_fd_sc_hd__a21oi_1
XFILLER_122_548 VGND VGND VPWR VPWR sky130_fd_sc_hd__decap_3
XTAP_TAPCELL_ROW_8_422 VGND VPWR sky130_fd_sc_hd__tapvpwrvgnd_1
XFILLER_0_300 VGND VGND VPWR VPWR sky130_fd_sc_hd__decap_4
X_11081_ net568 net300 VGND VGND VPWR VPWR _03744_ sky130_fd_sc_hd__and2_1
X_10032_ _02595_ _02601_ VGND VGND VPWR VPWR _02602_ sky130_fd_sc_hd__xnor2_1
XFILLER_102_261 VGND VGND VPWR VPWR sky130_fd_sc_hd__fill_1
XFILLER_48_337 VGND VGND VPWR VPWR sky130_fd_sc_hd__decap_4
XFILLER_91_605 VGND VGND VPWR VPWR sky130_fd_sc_hd__decap_8
XFILLER_75_167 VGND VGND VPWR VPWR sky130_fd_sc_hd__fill_1
XFILLER_64_819 VGND VGND VPWR VPWR sky130_fd_sc_hd__fill_1
XFILLER_17_713 VGND VGND VPWR VPWR sky130_fd_sc_hd__decap_6
XFILLER_29_573 VGND VGND VPWR VPWR sky130_fd_sc_hd__fill_2
X_11983_ net516 net407 VGND VGND VPWR VPWR _04724_ sky130_fd_sc_hd__nand2_1
XFILLER_17_735 VGND VGND VPWR VPWR sky130_fd_sc_hd__decap_8
XTAP_TAPCELL_ROW_63_1208 VGND VPWR sky130_fd_sc_hd__tapvpwrvgnd_1
XFILLER_44_554 VGND VGND VPWR VPWR sky130_fd_sc_hd__fill_2
X_10934_ _03567_ _03582_ VGND VGND VPWR VPWR _03583_ sky130_fd_sc_hd__xor2_1
XFILLER_32_716 VPWR VGND VPWR VGND sky130_ef_sc_hd__decap_12
X_13653_ clknet_3_7__leaf_clk _00011_ net717 VGND VGND VPWR VPWR net188 sky130_fd_sc_hd__dfrtp_1
XTAP_TAPCELL_ROW_63_1219 VGND VPWR sky130_fd_sc_hd__tapvpwrvgnd_1
XFILLER_44_587 VGND VGND VPWR VPWR sky130_fd_sc_hd__fill_1
X_10865_ _03477_ _03506_ VGND VGND VPWR VPWR _03508_ sky130_fd_sc_hd__xnor2_1
X_12604_ _05400_ _05401_ VGND VGND VPWR VPWR _05402_ sky130_fd_sc_hd__nor2_1
X_13584_ _06386_ _06388_ _06469_ VGND VGND VPWR VPWR _06472_ sky130_fd_sc_hd__and3_1
X_12535_ net600 _01453_ _05325_ _05326_ VGND VGND VPWR VPWR _05327_ sky130_fd_sc_hd__a22o_1
XFILLER_12_440 VGND VGND VPWR VPWR sky130_fd_sc_hd__fill_1
XFILLER_12_473 VGND VGND VPWR VPWR sky130_fd_sc_hd__decap_3
X_10796_ _03430_ _03431_ VGND VGND VPWR VPWR _03432_ sky130_fd_sc_hd__nand2_1
XFILLER_8_433 VPWR VGND VPWR VGND sky130_ef_sc_hd__decap_12
XFILLER_33_81 VGND VGND VPWR VPWR sky130_fd_sc_hd__decap_4
XFILLER_129_169 VGND VGND VPWR VPWR sky130_fd_sc_hd__decap_8
XFILLER_126_821 VGND VGND VPWR VPWR sky130_fd_sc_hd__decap_3
X_12466_ _05233_ _05250_ VGND VGND VPWR VPWR _05251_ sky130_fd_sc_hd__xnor2_1
XFILLER_69_7 VPWR VGND VPWR VGND sky130_ef_sc_hd__decap_12
XFILLER_8_477 VPWR VGND VPWR VGND sky130_ef_sc_hd__decap_12
XFILLER_125_331 VGND VGND VPWR VPWR sky130_fd_sc_hd__decap_4
X_12397_ _05174_ _05175_ VGND VGND VPWR VPWR _05176_ sky130_fd_sc_hd__and2b_1
X_11417_ _04105_ _04110_ VGND VGND VPWR VPWR _04111_ sky130_fd_sc_hd__nand2b_1
X_11348_ net307 net304 net535 net532 VGND VGND VPWR VPWR _04036_ sky130_fd_sc_hd__and4b_1
XFILLER_125_397 VGND VGND VPWR VPWR sky130_fd_sc_hd__fill_1
XFILLER_113_537 VGND VGND VPWR VPWR sky130_fd_sc_hd__decap_8
XFILLER_98_226 VGND VGND VPWR VPWR sky130_fd_sc_hd__decap_4
X_11279_ net442 net272 _03809_ _03638_ VGND VGND VPWR VPWR _03961_ sky130_fd_sc_hd__a31o_1
XFILLER_94_410 VGND VGND VPWR VPWR sky130_fd_sc_hd__decap_8
X_13018_ _05842_ _05853_ VGND VGND VPWR VPWR _05855_ sky130_fd_sc_hd__xor2_1
XFILLER_39_315 VGND VGND VPWR VPWR sky130_fd_sc_hd__fill_1
XFILLER_94_454 VGND VGND VPWR VPWR sky130_fd_sc_hd__decap_3
XFILLER_94_421 VGND VGND VPWR VPWR sky130_fd_sc_hd__decap_8
XFILLER_12_3 VPWR VGND VPWR VGND sky130_ef_sc_hd__decap_12
XFILLER_39_337 VGND VGND VPWR VPWR sky130_fd_sc_hd__fill_2
XFILLER_82_627 VGND VGND VPWR VPWR sky130_fd_sc_hd__fill_1
XFILLER_66_156 VGND VGND VPWR VPWR sky130_fd_sc_hd__fill_2
XTAP_TAPCELL_ROW_89_1591 VGND VPWR sky130_fd_sc_hd__tapvpwrvgnd_1
X_07510_ _06736_ _06737_ VGND VGND VPWR VPWR _06739_ sky130_fd_sc_hd__and2_1
XFILLER_81_148 VGND VGND VPWR VPWR sky130_fd_sc_hd__decap_8
X_08490_ _00886_ _00888_ _00959_ VGND VGND VPWR VPWR _00963_ sky130_fd_sc_hd__and3_1
X_07441_ _06668_ _06669_ _06670_ VGND VGND VPWR VPWR _06671_ sky130_fd_sc_hd__nand3_1
XFILLER_23_727 VGND VGND VPWR VPWR sky130_fd_sc_hd__fill_1
XFILLER_35_576 VPWR VGND VPWR VGND sky130_ef_sc_hd__decap_12
XFILLER_50_557 VPWR VGND VPWR VGND sky130_ef_sc_hd__decap_12
X_07372_ _06018_ _06116_ _06105_ VGND VGND VPWR VPWR _06602_ sky130_fd_sc_hd__a21o_1
X_09111_ _01595_ _01596_ _01424_ VGND VGND VPWR VPWR _01598_ sky130_fd_sc_hd__o21ai_1
XTAP_TAPCELL_ROW_33_777 VGND VPWR sky130_fd_sc_hd__tapvpwrvgnd_1
X_09042_ _01372_ _01522_ VGND VGND VPWR VPWR _01523_ sky130_fd_sc_hd__nor2_1
XTAP_TAPCELL_ROW_13_490 VGND VPWR sky130_fd_sc_hd__tapvpwrvgnd_1
XFILLER_128_180 VGND VGND VPWR VPWR sky130_fd_sc_hd__fill_1
XFILLER_132_813 VGND VGND VPWR VPWR sky130_fd_sc_hd__decap_8
XFILLER_2_609 VGND VGND VPWR VPWR sky130_fd_sc_hd__decap_3
XFILLER_131_323 VGND VGND VPWR VPWR sky130_fd_sc_hd__fill_1
X_09944_ _02494_ _02505_ VGND VGND VPWR VPWR _02506_ sky130_fd_sc_hd__xnor2_1
XFILLER_131_389 VGND VGND VPWR VPWR sky130_fd_sc_hd__decap_3
X_09875_ _02359_ _02430_ VGND VGND VPWR VPWR _02431_ sky130_fd_sc_hd__xnor2_1
XFILLER_100_721 VGND VGND VPWR VPWR sky130_fd_sc_hd__fill_2
XFILLER_98_793 VPWR VGND VPWR VGND sky130_ef_sc_hd__decap_12
XFILLER_38_15 VPWR VGND VPWR VGND sky130_ef_sc_hd__decap_12
X_08826_ _01160_ _01291_ VGND VGND VPWR VPWR _01292_ sky130_fd_sc_hd__xnor2_1
XFILLER_97_281 VPWR VGND VPWR VGND sky130_ef_sc_hd__decap_12
XFILLER_85_432 VGND VGND VPWR VPWR sky130_fd_sc_hd__decap_8
XFILLER_85_476 VGND VGND VPWR VPWR sky130_fd_sc_hd__decap_4
XFILLER_57_167 VGND VGND VPWR VPWR sky130_fd_sc_hd__fill_1
XFILLER_46_819 VGND VGND VPWR VPWR sky130_fd_sc_hd__fill_1
X_08757_ _01125_ _01222_ _01223_ VGND VGND VPWR VPWR _01224_ sky130_fd_sc_hd__and3_1
XFILLER_72_104 VGND VGND VPWR VPWR sky130_fd_sc_hd__decap_8
X_08688_ _01148_ _01153_ VGND VGND VPWR VPWR _01155_ sky130_fd_sc_hd__xor2_1
X_07708_ _00151_ _00185_ VGND VGND VPWR VPWR _00187_ sky130_fd_sc_hd__xnor2_1
X_07639_ _06700_ _06702_ _00116_ _00117_ VGND VGND VPWR VPWR _00119_ sky130_fd_sc_hd__o211ai_1
XFILLER_26_576 VGND VGND VPWR VPWR sky130_fd_sc_hd__fill_1
XFILLER_26_587 VGND VGND VPWR VPWR sky130_fd_sc_hd__fill_1
XFILLER_110_53 VPWR VGND VPWR VGND sky130_ef_sc_hd__decap_12
XFILLER_13_237 VGND VGND VPWR VPWR sky130_fd_sc_hd__decap_3
X_10650_ _03271_ _03272_ VGND VGND VPWR VPWR _03273_ sky130_fd_sc_hd__xor2_1
X_09309_ net629 net620 net372 net370 VGND VGND VPWR VPWR _01815_ sky130_fd_sc_hd__and4_1
XFILLER_110_97 VPWR VGND VPWR VGND sky130_ef_sc_hd__decap_12
X_10581_ _03077_ _03196_ _03197_ VGND VGND VPWR VPWR _03198_ sky130_fd_sc_hd__nand3_2
XFILLER_21_281 VGND VGND VPWR VPWR sky130_fd_sc_hd__decap_4
XFILLER_127_629 VGND VGND VPWR VPWR sky130_fd_sc_hd__fill_2
XFILLER_108_821 VGND VGND VPWR VPWR sky130_fd_sc_hd__decap_3
X_12320_ net593 net583 net500 net422 VGND VGND VPWR VPWR _05092_ sky130_fd_sc_hd__and4_1
XFILLER_126_139 VGND VGND VPWR VPWR sky130_fd_sc_hd__fill_1
XFILLER_119_51 VGND VGND VPWR VPWR sky130_fd_sc_hd__decap_4
X_12251_ net470 net383 _04848_ VGND VGND VPWR VPWR _05017_ sky130_fd_sc_hd__a21oi_1
XFILLER_79_33 VPWR VGND VPWR VGND sky130_ef_sc_hd__decap_12
X_11202_ _03758_ _03760_ _03874_ VGND VGND VPWR VPWR _03876_ sky130_fd_sc_hd__and3_1
XFILLER_134_183 VGND VGND VPWR VPWR sky130_fd_sc_hd__fill_2
XFILLER_122_301 VGND VGND VPWR VPWR sky130_fd_sc_hd__decap_6
XTAP_TAPCELL_ROW_114_1949 VGND VPWR sky130_fd_sc_hd__tapvpwrvgnd_1
XFILLER_107_386 VGND VGND VPWR VPWR sky130_fd_sc_hd__decap_3
X_12182_ _04730_ _04768_ _04800_ _04804_ VGND VGND VPWR VPWR _04941_ sky130_fd_sc_hd__o31a_1
XFILLER_1_642 VGND VGND VPWR VPWR sky130_fd_sc_hd__decap_8
X_11133_ _03645_ _03647_ VGND VGND VPWR VPWR _03801_ sky130_fd_sc_hd__nand2_1
XFILLER_89_782 VGND VGND VPWR VPWR sky130_fd_sc_hd__fill_2
XFILLER_0_163 VGND VGND VPWR VPWR sky130_fd_sc_hd__fill_1
XFILLER_0_141 VGND VGND VPWR VPWR sky130_fd_sc_hd__fill_2
X_11064_ _03723_ _03724_ VGND VGND VPWR VPWR _03725_ sky130_fd_sc_hd__xnor2_1
X_10015_ _01610_ _02581_ _02496_ VGND VGND VPWR VPWR _02583_ sky130_fd_sc_hd__o21a_1
XFILLER_76_421 VGND VGND VPWR VPWR sky130_fd_sc_hd__decap_6
XFILLER_49_635 VGND VGND VPWR VPWR sky130_fd_sc_hd__fill_2
XFILLER_48_112 VGND VGND VPWR VPWR sky130_fd_sc_hd__decap_8
XFILLER_0_174 VGND VGND VPWR VPWR sky130_fd_sc_hd__decap_4
XFILLER_36_318 VGND VGND VPWR VPWR sky130_fd_sc_hd__fill_1
XFILLER_63_137 VGND VGND VPWR VPWR sky130_fd_sc_hd__fill_2
XFILLER_36_329 VPWR VGND VPWR VGND sky130_ef_sc_hd__decap_12
X_11966_ net645 net387 net369 net656 VGND VGND VPWR VPWR _04705_ sky130_fd_sc_hd__a22o_1
X_10917_ _03561_ _03562_ VGND VGND VPWR VPWR _03564_ sky130_fd_sc_hd__xor2_1
X_13636_ clknet_3_6__leaf_clk _00005_ net716 VGND VGND VPWR VPWR net171 sky130_fd_sc_hd__dfrtp_1
X_11897_ _04627_ _04632_ VGND VGND VPWR VPWR _04633_ sky130_fd_sc_hd__xnor2_1
X_10848_ net650 net410 net315 VGND VGND VPWR VPWR _03490_ sky130_fd_sc_hd__and3_1
X_13567_ net246 _06373_ _06372_ VGND VGND VPWR VPWR _06453_ sky130_fd_sc_hd__o21a_1
X_10779_ _03363_ _03411_ VGND VGND VPWR VPWR _03414_ sky130_fd_sc_hd__xnor2_1
XTAP_TAPCELL_ROW_30_736 VGND VPWR sky130_fd_sc_hd__tapvpwrvgnd_1
X_13498_ _06377_ _06369_ VGND VGND VPWR VPWR _06379_ sky130_fd_sc_hd__and2b_1
X_12518_ _05293_ _05307_ VGND VGND VPWR VPWR _05309_ sky130_fd_sc_hd__xnor2_1
X_12449_ _05232_ VGND VGND VPWR VPWR _05233_ sky130_fd_sc_hd__inv_2
XFILLER_9_797 VPWR VGND VPWR VGND sky130_ef_sc_hd__decap_12
XFILLER_132_109 VPWR VGND VPWR VGND sky130_ef_sc_hd__decap_12
XFILLER_114_813 VGND VGND VPWR VPWR sky130_fd_sc_hd__decap_6
XFILLER_125_161 VGND VGND VPWR VPWR sky130_fd_sc_hd__fill_1
X_07990_ _00435_ _00465_ VGND VGND VPWR VPWR _00467_ sky130_fd_sc_hd__xnor2_1
XFILLER_113_389 VGND VGND VPWR VPWR sky130_fd_sc_hd__decap_3
X_06941_ net590 net581 net693 net697 VGND VGND VPWR VPWR _02695_ sky130_fd_sc_hd__and4_1
X_09660_ net540 net357 net360 net265 VGND VGND VPWR VPWR _02197_ sky130_fd_sc_hd__o2bb2a_1
XFILLER_79_281 VPWR VGND VPWR VGND sky130_ef_sc_hd__decap_12
X_08611_ net517 net508 net351 VGND VGND VPWR VPWR _01078_ sky130_fd_sc_hd__and3_1
XFILLER_95_785 VPWR VGND VPWR VGND sky130_ef_sc_hd__decap_12
XFILLER_94_251 VGND VGND VPWR VPWR sky130_fd_sc_hd__fill_1
X_06872_ net654 net268 net642 net710 VGND VGND VPWR VPWR _01943_ sky130_fd_sc_hd__and4_1
X_09591_ _02116_ _02119_ _02120_ VGND VGND VPWR VPWR _02122_ sky130_fd_sc_hd__nor3_4
XTAP_TAPCELL_ROW_38_847 VGND VPWR sky130_fd_sc_hd__tapvpwrvgnd_1
X_08542_ _01010_ VGND VGND VPWR VPWR _01011_ sky130_fd_sc_hd__inv_2
XTAP_TAPCELL_ROW_18_560 VGND VPWR sky130_fd_sc_hd__tapvpwrvgnd_1
X_08473_ _00923_ _00944_ VGND VGND VPWR VPWR _00946_ sky130_fd_sc_hd__xor2_1
X_07424_ _06652_ _06653_ VGND VGND VPWR VPWR _06654_ sky130_fd_sc_hd__nand2_1
XFILLER_50_321 VPWR VGND VPWR VGND sky130_ef_sc_hd__decap_12
XFILLER_11_708 VGND VGND VPWR VPWR sky130_fd_sc_hd__fill_2
XTAP_TAPCELL_ROW_118_2016 VGND VPWR sky130_fd_sc_hd__tapvpwrvgnd_1
XTAP_TAPCELL_ROW_118_2005 VGND VPWR sky130_fd_sc_hd__tapvpwrvgnd_1
XFILLER_10_229 VPWR VGND VPWR VGND sky130_ef_sc_hd__decap_12
X_07355_ net694 net563 net692 net570 VGND VGND VPWR VPWR _06585_ sky130_fd_sc_hd__a22o_1
XFILLER_136_404 VGND VGND VPWR VPWR sky130_fd_sc_hd__decap_3
X_07286_ _06410_ _06421_ _06432_ VGND VGND VPWR VPWR _06454_ sky130_fd_sc_hd__a21o_1
XFILLER_40_27 VGND VGND VPWR VPWR sky130_fd_sc_hd__fill_1
XFILLER_136_437 VPWR VGND VPWR VGND sky130_ef_sc_hd__decap_12
XTAP_TAPCELL_ROW_131_2205 VGND VPWR sky130_fd_sc_hd__tapvpwrvgnd_1
X_09025_ _01502_ _01503_ _01348_ _01351_ VGND VGND VPWR VPWR _01505_ sky130_fd_sc_hd__o211ai_2
XFILLER_108_128 VGND VGND VPWR VPWR sky130_fd_sc_hd__decap_8
XFILLER_116_161 VGND VGND VPWR VPWR sky130_fd_sc_hd__decap_3
XFILLER_104_301 VGND VGND VPWR VPWR sky130_fd_sc_hd__fill_1
XFILLER_132_698 VGND VGND VPWR VPWR sky130_fd_sc_hd__fill_2
XFILLER_131_175 VPWR VGND VPWR VGND sky130_ef_sc_hd__decap_12
XFILLER_131_164 VGND VGND VPWR VPWR sky130_fd_sc_hd__decap_4
X_09927_ _02472_ _02486_ VGND VGND VPWR VPWR _02487_ sky130_fd_sc_hd__xnor2_1
Xfanout710 net100 VGND VGND VPWR VPWR net710 sky130_fd_sc_hd__buf_2
XFILLER_49_69 VPWR VGND VPWR VGND sky130_ef_sc_hd__decap_12
XTAP_TAPCELL_ROW_129_2167 VGND VPWR sky130_fd_sc_hd__tapvpwrvgnd_1
XFILLER_86_752 VGND VGND VPWR VPWR sky130_fd_sc_hd__decap_4
XFILLER_58_421 VPWR VGND VPWR VGND sky130_ef_sc_hd__decap_12
XFILLER_58_410 VGND VGND VPWR VPWR sky130_fd_sc_hd__decap_8
X_09858_ net438 net429 net329 VGND VGND VPWR VPWR _02414_ sky130_fd_sc_hd__and3_1
XFILLER_100_562 VGND VGND VPWR VPWR sky130_fd_sc_hd__decap_3
X_09789_ _02192_ _02199_ _02335_ VGND VGND VPWR VPWR _02338_ sky130_fd_sc_hd__nand3_1
X_08809_ net517 net508 net350 net53 VGND VGND VPWR VPWR _01275_ sky130_fd_sc_hd__nand4_1
XFILLER_65_57 VPWR VGND VPWR VGND sky130_ef_sc_hd__decap_12
XFILLER_73_457 VGND VGND VPWR VPWR sky130_fd_sc_hd__fill_2
XFILLER_73_446 VGND VGND VPWR VPWR sky130_fd_sc_hd__fill_2
X_11820_ _04545_ _04549_ VGND VGND VPWR VPWR _04550_ sky130_fd_sc_hd__xnor2_1
XFILLER_54_660 VPWR VGND VPWR VGND sky130_ef_sc_hd__decap_12
XFILLER_42_811 VGND VGND VPWR VPWR sky130_fd_sc_hd__fill_1
X_11751_ _04468_ _04474_ VGND VGND VPWR VPWR _04475_ sky130_fd_sc_hd__and2b_1
XFILLER_81_490 VPWR VGND VPWR VGND sky130_ef_sc_hd__decap_12
XFILLER_14_557 VPWR VGND VPWR VGND sky130_ef_sc_hd__decap_12
XFILLER_26_395 VGND VGND VPWR VPWR sky130_fd_sc_hd__fill_1
X_10702_ _03326_ _03327_ _03328_ VGND VGND VPWR VPWR _03330_ sky130_fd_sc_hd__a21o_1
XFILLER_41_343 VGND VGND VPWR VPWR sky130_fd_sc_hd__decap_6
X_11682_ _04398_ _04399_ VGND VGND VPWR VPWR _04400_ sky130_fd_sc_hd__nand2_1
X_13421_ _06157_ _06159_ _06293_ VGND VGND VPWR VPWR _06295_ sky130_fd_sc_hd__and3_1
X_10633_ net494 net296 VGND VGND VPWR VPWR _03254_ sky130_fd_sc_hd__nand2_1
X_13352_ net262 net320 _06113_ _06117_ VGND VGND VPWR VPWR _06219_ sky130_fd_sc_hd__o31a_1
XFILLER_6_701 VPWR VGND VPWR VGND sky130_ef_sc_hd__decap_12
X_10564_ _03176_ _03177_ _03178_ VGND VGND VPWR VPWR _03179_ sky130_fd_sc_hd__and3_4
X_12303_ net556 net660 VGND VGND VPWR VPWR _05073_ sky130_fd_sc_hd__nand2_1
X_13283_ _06102_ _06143_ VGND VGND VPWR VPWR _06144_ sky130_fd_sc_hd__nand2_1
XFILLER_5_233 VGND VGND VPWR VPWR sky130_fd_sc_hd__fill_2
X_10495_ _03101_ _03102_ VGND VGND VPWR VPWR _03103_ sky130_fd_sc_hd__or2_1
XFILLER_108_695 VGND VGND VPWR VPWR sky130_fd_sc_hd__decap_4
XFILLER_107_172 VPWR VGND VPWR VGND sky130_ef_sc_hd__decap_12
X_12234_ net430 net393 net391 net439 VGND VGND VPWR VPWR _04998_ sky130_fd_sc_hd__a22oi_1
XFILLER_135_492 VPWR VGND VPWR VGND sky130_ef_sc_hd__decap_12
X_12165_ _04912_ _04919_ _04722_ _04732_ VGND VGND VPWR VPWR _04923_ sky130_fd_sc_hd__o211ai_2
XFILLER_122_153 VGND VGND VPWR VPWR sky130_fd_sc_hd__decap_3
XFILLER_110_304 VGND VGND VPWR VPWR sky130_fd_sc_hd__decap_4
XTAP_TAPCELL_ROW_71_1329 VGND VPWR sky130_fd_sc_hd__tapvpwrvgnd_1
X_11116_ net521 net287 _03616_ _03615_ VGND VGND VPWR VPWR _03782_ sky130_fd_sc_hd__a31o_1
X_12096_ _04845_ _04846_ VGND VGND VPWR VPWR _04847_ sky130_fd_sc_hd__or2_1
XFILLER_110_359 VGND VGND VPWR VPWR sky130_fd_sc_hd__fill_1
XFILLER_77_752 VGND VGND VPWR VPWR sky130_fd_sc_hd__decap_3
X_11047_ _03361_ _03705_ VGND VGND VPWR VPWR _03707_ sky130_fd_sc_hd__xnor2_1
XFILLER_92_722 VGND VGND VPWR VPWR sky130_fd_sc_hd__fill_1
Xinput9 w00[7] VGND VGND VPWR VPWR net9 sky130_fd_sc_hd__buf_1
XFILLER_64_424 VGND VGND VPWR VPWR sky130_fd_sc_hd__decap_8
XFILLER_91_232 VPWR VGND VPWR VGND sky130_ef_sc_hd__decap_12
XFILLER_91_265 VGND VGND VPWR VPWR sky130_fd_sc_hd__decap_8
XTAP_TAPCELL_ROW_86_1550 VGND VPWR sky130_fd_sc_hd__tapvpwrvgnd_1
X_12998_ _05681_ _05682_ _05684_ VGND VGND VPWR VPWR _05833_ sky130_fd_sc_hd__o21bai_1
XFILLER_45_671 VGND VGND VPWR VPWR sky130_fd_sc_hd__fill_1
XTAP_TAPCELL_ROW_35_806 VGND VPWR sky130_fd_sc_hd__tapvpwrvgnd_1
X_11949_ _04683_ _04685_ _04682_ VGND VGND VPWR VPWR _04688_ sky130_fd_sc_hd__a21oi_1
XFILLER_20_505 VGND VGND VPWR VPWR sky130_fd_sc_hd__decap_8
XFILLER_32_365 VPWR VGND VPWR VGND sky130_ef_sc_hd__decap_12
X_13619_ _06424_ _06437_ _06423_ VGND VGND VPWR VPWR _06510_ sky130_fd_sc_hd__a21oi_1
X_07140_ net670 net444 VGND VGND VPWR VPWR _04860_ sky130_fd_sc_hd__nand2_1
XFILLER_9_561 VPWR VGND VPWR VGND sky130_ef_sc_hd__decap_12
XFILLER_13_590 VGND VGND VPWR VPWR sky130_fd_sc_hd__decap_6
X_07071_ _04057_ net236 _04014_ _04024_ VGND VGND VPWR VPWR _04112_ sky130_fd_sc_hd__o211a_1
XFILLER_126_492 VPWR VGND VPWR VGND sky130_ef_sc_hd__decap_12
XFILLER_102_805 VGND VGND VPWR VPWR sky130_fd_sc_hd__decap_6
XFILLER_99_365 VGND VGND VPWR VPWR sky130_fd_sc_hd__decap_8
XFILLER_87_527 VPWR VGND VPWR VGND sky130_ef_sc_hd__decap_12
X_09712_ _02239_ _02253_ VGND VGND VPWR VPWR _02254_ sky130_fd_sc_hd__xnor2_1
XFILLER_113_186 VPWR VGND VPWR VGND sky130_ef_sc_hd__decap_12
X_07973_ _00308_ _00449_ VGND VGND VPWR VPWR _00450_ sky130_fd_sc_hd__xnor2_2
X_06924_ _01508_ _01725_ _02151_ VGND VGND VPWR VPWR _02510_ sky130_fd_sc_hd__o21ai_1
XFILLER_19_39 VPWR VGND VPWR VGND sky130_ef_sc_hd__decap_12
X_09643_ _02175_ _02176_ _02177_ VGND VGND VPWR VPWR _02179_ sky130_fd_sc_hd__nand3_1
XFILLER_82_210 VPWR VGND VPWR VGND sky130_ef_sc_hd__decap_12
XFILLER_67_262 VGND VGND VPWR VPWR sky130_fd_sc_hd__decap_4
X_06855_ _01747_ VGND VGND VPWR VPWR _01758_ sky130_fd_sc_hd__inv_2
X_09574_ _02099_ _02100_ VGND VGND VPWR VPWR _02103_ sky130_fd_sc_hd__xor2_1
XTAP_TAPCELL_ROW_124_2097 VGND VPWR sky130_fd_sc_hd__tapvpwrvgnd_1
XFILLER_24_811 VGND VGND VPWR VPWR sky130_fd_sc_hd__fill_1
XFILLER_35_27 VPWR VGND VPWR VGND sky130_ef_sc_hd__decap_12
X_08525_ _00966_ _00996_ VGND VGND VPWR VPWR _00047_ sky130_fd_sc_hd__xnor2_1
XFILLER_23_310 VGND VGND VPWR VPWR sky130_fd_sc_hd__decap_6
XFILLER_35_181 VPWR VGND VPWR VGND sky130_ef_sc_hd__decap_12
X_08456_ net252 _00755_ VGND VGND VPWR VPWR _00929_ sky130_fd_sc_hd__nand2_1
X_07407_ _06634_ _06635_ VGND VGND VPWR VPWR _06637_ sky130_fd_sc_hd__or2_1
X_08387_ _00755_ _00757_ net252 VGND VGND VPWR VPWR _00861_ sky130_fd_sc_hd__o21ai_1
X_07338_ _04112_ _05483_ _06566_ _06567_ VGND VGND VPWR VPWR _06569_ sky130_fd_sc_hd__a22o_1
XFILLER_50_195 VGND VGND VPWR VPWR sky130_fd_sc_hd__fill_1
X_07269_ _05974_ _06258_ VGND VGND VPWR VPWR _06269_ sky130_fd_sc_hd__nor2_1
XTAP_TAPCELL_ROW_21_599 VGND VPWR sky130_fd_sc_hd__tapvpwrvgnd_1
XFILLER_124_418 VGND VGND VPWR VPWR sky130_fd_sc_hd__fill_2
X_09008_ _01483_ _01484_ _01485_ VGND VGND VPWR VPWR _01487_ sky130_fd_sc_hd__nand3_1
X_10280_ _02820_ _02867_ VGND VGND VPWR VPWR _02869_ sky130_fd_sc_hd__xnor2_1
XFILLER_117_492 VPWR VGND VPWR VGND sky130_ef_sc_hd__decap_12
XTAP_TAPCELL_ROW_111_1908 VGND VPWR sky130_fd_sc_hd__tapvpwrvgnd_1
XFILLER_116_41 VPWR VGND VPWR VGND sky130_ef_sc_hd__decap_12
Xfanout540 net542 VGND VGND VPWR VPWR net540 sky130_fd_sc_hd__clkbuf_2
XFILLER_120_624 VGND VGND VPWR VPWR sky130_fd_sc_hd__decap_4
XFILLER_104_197 VGND VGND VPWR VPWR sky130_fd_sc_hd__decap_8
XFILLER_59_741 VGND VGND VPWR VPWR sky130_fd_sc_hd__decap_8
Xfanout551 net143 VGND VGND VPWR VPWR net551 sky130_fd_sc_hd__buf_4
Xfanout573 net576 VGND VGND VPWR VPWR net573 sky130_fd_sc_hd__clkbuf_2
Xfanout584 net587 VGND VGND VPWR VPWR net584 sky130_fd_sc_hd__dlymetal6s2s_1
XFILLER_59_763 VGND VGND VPWR VPWR sky130_fd_sc_hd__fill_1
XFILLER_58_251 VGND VGND VPWR VPWR sky130_fd_sc_hd__fill_1
Xfanout562 net563 VGND VGND VPWR VPWR net562 sky130_fd_sc_hd__buf_4
Xfanout595 net597 VGND VGND VPWR VPWR net595 sky130_fd_sc_hd__buf_2
X_12921_ _05579_ _05582_ _05578_ VGND VGND VPWR VPWR _05748_ sky130_fd_sc_hd__o21ba_1
XFILLER_58_284 VPWR VGND VPWR VGND sky130_ef_sc_hd__decap_12
XFILLER_100_392 VGND VGND VPWR VPWR sky130_fd_sc_hd__fill_1
XFILLER_74_755 VGND VGND VPWR VPWR sky130_fd_sc_hd__fill_1
XFILLER_73_232 VGND VGND VPWR VPWR sky130_fd_sc_hd__fill_2
XFILLER_18_148 VGND VGND VPWR VPWR sky130_fd_sc_hd__decap_3
X_12852_ _05670_ _05671_ VGND VGND VPWR VPWR _05673_ sky130_fd_sc_hd__xnor2_1
XFILLER_74_799 VPWR VGND VPWR VGND sky130_ef_sc_hd__decap_12
XFILLER_92_77 VGND VGND VPWR VPWR sky130_fd_sc_hd__decap_6
X_12783_ _05435_ _05437_ _05434_ VGND VGND VPWR VPWR _05597_ sky130_fd_sc_hd__a21o_1
XTAP_TAPCELL_ROW_68_1291 VGND VPWR sky130_fd_sc_hd__tapvpwrvgnd_1
XTAP_TAPCELL_ROW_68_1280 VGND VPWR sky130_fd_sc_hd__tapvpwrvgnd_1
XFILLER_61_449 VGND VGND VPWR VPWR sky130_fd_sc_hd__decap_4
X_11803_ _04529_ _04530_ VGND VGND VPWR VPWR _04532_ sky130_fd_sc_hd__xor2_1
XFILLER_14_365 VPWR VGND VPWR VGND sky130_ef_sc_hd__decap_12
X_11734_ _04454_ _04455_ VGND VGND VPWR VPWR _04456_ sky130_fd_sc_hd__nor2_1
XTAP_TAPCELL_ROW_81_1480 VGND VPWR sky130_fd_sc_hd__tapvpwrvgnd_1
X_11665_ _04262_ _04269_ _04271_ VGND VGND VPWR VPWR _04381_ sky130_fd_sc_hd__a21bo_1
X_13404_ _06275_ _06249_ VGND VGND VPWR VPWR _06276_ sky130_fd_sc_hd__and2b_1
X_10616_ _03232_ _03233_ VGND VGND VPWR VPWR _03235_ sky130_fd_sc_hd__xor2_1
XFILLER_128_757 VPWR VGND VPWR VGND sky130_ef_sc_hd__decap_12
XFILLER_128_735 VGND VGND VPWR VPWR sky130_fd_sc_hd__decap_4
X_11596_ _04037_ _04186_ _04184_ VGND VGND VPWR VPWR _04305_ sky130_fd_sc_hd__o21a_1
XTAP_TAPCELL_ROW_40_875 VGND VPWR sky130_fd_sc_hd__tapvpwrvgnd_1
XTAP_TAPCELL_ROW_40_886 VGND VPWR sky130_fd_sc_hd__tapvpwrvgnd_1
X_13335_ _06199_ _06194_ VGND VGND VPWR VPWR _06200_ sky130_fd_sc_hd__and2b_1
XFILLER_41_81 VPWR VGND VPWR VGND sky130_ef_sc_hd__decap_12
X_10547_ net638 net322 VGND VGND VPWR VPWR _03160_ sky130_fd_sc_hd__nand2_1
XFILLER_127_278 VGND VGND VPWR VPWR sky130_fd_sc_hd__fill_2
X_13266_ _06123_ _06124_ VGND VGND VPWR VPWR _06125_ sky130_fd_sc_hd__xnor2_1
XFILLER_51_7 VPWR VGND VPWR VGND sky130_ef_sc_hd__decap_12
X_10478_ _02906_ _03082_ VGND VGND VPWR VPWR _03085_ sky130_fd_sc_hd__or2_1
X_12217_ _04976_ _04977_ _04978_ VGND VGND VPWR VPWR _04979_ sky130_fd_sc_hd__and3_1
XFILLER_111_602 VGND VGND VPWR VPWR sky130_fd_sc_hd__decap_8
X_13197_ _06047_ _06048_ VGND VGND VPWR VPWR _06049_ sky130_fd_sc_hd__nand2_1
XFILLER_69_505 VPWR VGND VPWR VGND sky130_ef_sc_hd__decap_12
XFILLER_123_495 VGND VGND VPWR VPWR sky130_fd_sc_hd__decap_8
XFILLER_111_624 VPWR VGND VPWR VGND sky130_ef_sc_hd__decap_12
XFILLER_96_313 VGND VGND VPWR VPWR sky130_fd_sc_hd__fill_1
X_12148_ _04900_ _04901_ _04825_ VGND VGND VPWR VPWR _04905_ sky130_fd_sc_hd__o21ai_2
XFILLER_2_781 VPWR VGND VPWR VGND sky130_ef_sc_hd__decap_12
XFILLER_111_668 VGND VGND VPWR VPWR sky130_fd_sc_hd__fill_1
XFILLER_96_368 VPWR VGND VPWR VGND sky130_ef_sc_hd__decap_12
X_12079_ net462 net454 net390 net388 VGND VGND VPWR VPWR _04829_ sky130_fd_sc_hd__and4_1
XFILLER_2_53 VPWR VGND VPWR VGND sky130_ef_sc_hd__decap_12
XPHY_EDGE_ROW_10_Right_10 VGND VGND VPWR VPWR sky130_fd_sc_hd__decap_3
XFILLER_110_189 VGND VGND VPWR VPWR sky130_fd_sc_hd__decap_6
XFILLER_77_571 VGND VGND VPWR VPWR sky130_fd_sc_hd__decap_6
XFILLER_92_530 VGND VGND VPWR VPWR sky130_fd_sc_hd__fill_2
XFILLER_2_97 VPWR VGND VPWR VGND sky130_ef_sc_hd__decap_12
XFILLER_92_585 VGND VGND VPWR VPWR sky130_fd_sc_hd__decap_3
XTAP_TAPCELL_ROW_48_997 VGND VPWR sky130_fd_sc_hd__tapvpwrvgnd_1
X_09290_ net445 net331 _01790_ _01792_ VGND VGND VPWR VPWR _01794_ sky130_fd_sc_hd__nand4_1
X_08310_ _00783_ _00784_ VGND VGND VPWR VPWR _00785_ sky130_fd_sc_hd__nor2_1
XFILLER_33_641 VGND VGND VPWR VPWR sky130_fd_sc_hd__decap_6
XANTENNA_14 net261 VGND VGND VPWR VPWR sky130_fd_sc_hd__diode_2
X_08241_ _00713_ _00715_ VGND VGND VPWR VPWR _00716_ sky130_fd_sc_hd__or2_1
XANTENNA_25 net482 VGND VGND VPWR VPWR sky130_fd_sc_hd__diode_2
XTAP_TAPCELL_ROW_99_1730 VGND VPWR sky130_fd_sc_hd__tapvpwrvgnd_1
XFILLER_32_195 VGND VGND VPWR VPWR sky130_fd_sc_hd__fill_1
XFILLER_119_735 VGND VGND VPWR VPWR sky130_fd_sc_hd__decap_8
XFILLER_118_223 VGND VGND VPWR VPWR sky130_fd_sc_hd__fill_1
XFILLER_118_212 VGND VGND VPWR VPWR sky130_fd_sc_hd__decap_4
XTAP_TAPCELL_ROW_99_1741 VGND VPWR sky130_fd_sc_hd__tapvpwrvgnd_1
X_08172_ net417 _00646_ VGND VGND VPWR VPWR _00648_ sky130_fd_sc_hd__and2_1
XFILLER_119_757 VGND VGND VPWR VPWR sky130_fd_sc_hd__fill_1
X_07123_ _04569_ _04665_ VGND VGND VPWR VPWR _04675_ sky130_fd_sc_hd__xnor2_1
XFILLER_134_749 VGND VGND VPWR VPWR sky130_fd_sc_hd__decap_6
XFILLER_133_215 VGND VGND VPWR VPWR sky130_fd_sc_hd__decap_8
X_07054_ _03795_ _03839_ _03828_ VGND VGND VPWR VPWR _03926_ sky130_fd_sc_hd__o21ai_1
XFILLER_114_473 VGND VGND VPWR VPWR sky130_fd_sc_hd__decap_3
Xoutput165 net165 VGND VGND VPWR VPWR y0[12] sky130_fd_sc_hd__buf_2
Xoutput176 net176 VGND VGND VPWR VPWR y0[7] sky130_fd_sc_hd__buf_2
XFILLER_0_729 VGND VGND VPWR VPWR sky130_fd_sc_hd__decap_8
Xoutput187 net187 VGND VGND VPWR VPWR y1[1] sky130_fd_sc_hd__buf_2
XFILLER_87_335 VGND VGND VPWR VPWR sky130_fd_sc_hd__fill_1
XFILLER_87_313 VGND VGND VPWR VPWR sky130_fd_sc_hd__decap_8
Xoutput198 net198 VGND VGND VPWR VPWR y2[11] sky130_fd_sc_hd__buf_2
XFILLER_75_519 VGND VGND VPWR VPWR sky130_fd_sc_hd__fill_2
X_07956_ _00431_ _00432_ VGND VGND VPWR VPWR _00433_ sky130_fd_sc_hd__nor2_1
XTAP_TAPCELL_ROW_126_2126 VGND VPWR sky130_fd_sc_hd__tapvpwrvgnd_1
XFILLER_101_167 VGND VGND VPWR VPWR sky130_fd_sc_hd__fill_1
XFILLER_46_15 VPWR VGND VPWR VGND sky130_ef_sc_hd__decap_12
X_06907_ _01846_ _02304_ VGND VGND VPWR VPWR _02325_ sky130_fd_sc_hd__nor2_1
XPHY_EDGE_ROW_106_Right_106 VGND VGND VPWR VPWR sky130_fd_sc_hd__decap_3
XFILLER_95_390 VGND VGND VPWR VPWR sky130_fd_sc_hd__fill_2
X_07887_ _00230_ _00238_ _00237_ VGND VGND VPWR VPWR _00365_ sky130_fd_sc_hd__o21ai_2
XFILLER_55_243 VGND VGND VPWR VPWR sky130_fd_sc_hd__decap_3
XFILLER_28_457 VGND VGND VPWR VPWR sky130_fd_sc_hd__fill_1
X_09626_ _01950_ _02006_ _02005_ VGND VGND VPWR VPWR _02160_ sky130_fd_sc_hd__a21bo_1
X_06838_ _01518_ _01540_ _01562_ VGND VGND VPWR VPWR _01573_ sky130_fd_sc_hd__or3_1
XFILLER_56_777 VGND VGND VPWR VPWR sky130_fd_sc_hd__fill_1
X_09557_ net496 net344 _02082_ VGND VGND VPWR VPWR _02084_ sky130_fd_sc_hd__nand3_1
XTAP_TAPCELL_ROW_108_1870 VGND VPWR sky130_fd_sc_hd__tapvpwrvgnd_1
X_09488_ _02008_ _02007_ VGND VGND VPWR VPWR _02010_ sky130_fd_sc_hd__and2b_1
XFILLER_102_65 VPWR VGND VPWR VGND sky130_ef_sc_hd__decap_12
X_08508_ _00978_ _00979_ VGND VGND VPWR VPWR _00980_ sky130_fd_sc_hd__xnor2_1
XTAP_TAPCELL_ROW_26_669 VGND VPWR sky130_fd_sc_hd__tapvpwrvgnd_1
XFILLER_62_69 VGND VGND VPWR VPWR sky130_fd_sc_hd__fill_1
X_08439_ _00828_ _00830_ _00833_ _00834_ VGND VGND VPWR VPWR _00912_ sky130_fd_sc_hd__nor4_1
XFILLER_127_3 VPWR VGND VPWR VGND sky130_ef_sc_hd__decap_12
X_11450_ _03951_ _04000_ _03999_ VGND VGND VPWR VPWR _04148_ sky130_fd_sc_hd__a21oi_1
XTAP_TAPCELL_ROW_137_2288 VGND VPWR sky130_fd_sc_hd__tapvpwrvgnd_1
X_11381_ _04070_ _04071_ VGND VGND VPWR VPWR _04072_ sky130_fd_sc_hd__or2_1
X_10401_ _02998_ _02999_ _02985_ VGND VGND VPWR VPWR _03001_ sky130_fd_sc_hd__a21o_1
XFILLER_125_738 VGND VGND VPWR VPWR sky130_fd_sc_hd__decap_3
X_13120_ _05935_ _05964_ VGND VGND VPWR VPWR _05966_ sky130_fd_sc_hd__xnor2_1
X_10332_ _02921_ _02923_ VGND VGND VPWR VPWR _02925_ sky130_fd_sc_hd__nor2_1
XFILLER_3_501 VGND VGND VPWR VPWR sky130_fd_sc_hd__decap_3
XFILLER_11_51 VGND VGND VPWR VPWR sky130_fd_sc_hd__decap_4
XFILLER_127_51 VGND VGND VPWR VPWR sky130_fd_sc_hd__decap_4
X_13051_ _05774_ _05776_ _05888_ VGND VGND VPWR VPWR _05890_ sky130_fd_sc_hd__and3_1
XFILLER_3_523 VGND VGND VPWR VPWR sky130_fd_sc_hd__fill_1
XFILLER_105_462 VGND VGND VPWR VPWR sky130_fd_sc_hd__decap_8
X_12002_ _04743_ _04744_ VGND VGND VPWR VPWR _04745_ sky130_fd_sc_hd__nand2_1
XFILLER_79_803 VGND VGND VPWR VPWR sky130_fd_sc_hd__fill_1
X_10263_ net450 net283 net281 net458 VGND VGND VPWR VPWR _02850_ sky130_fd_sc_hd__a22oi_1
XFILLER_132_281 VGND VGND VPWR VPWR sky130_fd_sc_hd__decap_3
X_10194_ _02685_ _02691_ _02692_ _02686_ VGND VGND VPWR VPWR _02778_ sky130_fd_sc_hd__o31a_1
XFILLER_87_55 VGND VGND VPWR VPWR sky130_fd_sc_hd__fill_1
Xfanout370 net39 VGND VGND VPWR VPWR net370 sky130_fd_sc_hd__clkbuf_4
XFILLER_93_327 VGND VGND VPWR VPWR sky130_fd_sc_hd__decap_4
Xfanout381 net32 VGND VGND VPWR VPWR net381 sky130_fd_sc_hd__clkbuf_4
Xfanout392 net27 VGND VGND VPWR VPWR net392 sky130_fd_sc_hd__dlymetal6s2s_1
XTAP_TAPCELL_ROW_6_383 VGND VPWR sky130_fd_sc_hd__tapvpwrvgnd_1
XFILLER_19_446 VGND VGND VPWR VPWR sky130_fd_sc_hd__fill_2
X_12904_ _05728_ _05729_ VGND VGND VPWR VPWR _05730_ sky130_fd_sc_hd__nor2_1
X_12835_ _05650_ _05651_ VGND VGND VPWR VPWR _05654_ sky130_fd_sc_hd__xnor2_1
XFILLER_62_736 VPWR VGND VPWR VGND sky130_ef_sc_hd__decap_12
XTAP_TAPCELL_ROW_45_945 VGND VPWR sky130_fd_sc_hd__tapvpwrvgnd_1
XTAP_TAPCELL_ROW_45_956 VGND VPWR sky130_fd_sc_hd__tapvpwrvgnd_1
X_12766_ net564 net555 net501 net423 VGND VGND VPWR VPWR _05578_ sky130_fd_sc_hd__and4_1
XFILLER_15_696 VPWR VGND VPWR VGND sky130_ef_sc_hd__decap_12
X_12697_ _05500_ _05501_ _05502_ VGND VGND VPWR VPWR _05504_ sky130_fd_sc_hd__a21o_1
XFILLER_42_493 VGND VGND VPWR VPWR sky130_fd_sc_hd__fill_1
XFILLER_14_195 VGND VGND VPWR VPWR sky130_fd_sc_hd__fill_1
X_11717_ _03455_ _04435_ VGND VGND VPWR VPWR _04437_ sky130_fd_sc_hd__nor2_1
XFILLER_30_655 VGND VGND VPWR VPWR sky130_fd_sc_hd__fill_2
Xinput12 w01[2] VGND VGND VPWR VPWR net12 sky130_fd_sc_hd__buf_1
X_11648_ _04361_ _04360_ VGND VGND VPWR VPWR _04363_ sky130_fd_sc_hd__nand2b_1
Xinput34 w10[0] VGND VGND VPWR VPWR net34 sky130_fd_sc_hd__buf_1
Xinput45 w11[3] VGND VGND VPWR VPWR net45 sky130_fd_sc_hd__buf_1
XFILLER_128_543 VPWR VGND VPWR VGND sky130_ef_sc_hd__decap_12
Xinput23 w02[5] VGND VGND VPWR VPWR net23 sky130_fd_sc_hd__clkbuf_2
X_11579_ _04170_ _04287_ VGND VGND VPWR VPWR _04288_ sky130_fd_sc_hd__xnor2_1
Xinput56 w12[6] VGND VGND VPWR VPWR net56 sky130_fd_sc_hd__buf_1
X_13318_ net422 net408 net539 net533 VGND VGND VPWR VPWR _06182_ sky130_fd_sc_hd__and4b_1
Xinput89 w22[7] VGND VGND VPWR VPWR net89 sky130_fd_sc_hd__buf_1
Xinput78 w21[4] VGND VGND VPWR VPWR net78 sky130_fd_sc_hd__clkbuf_1
Xinput67 w20[1] VGND VGND VPWR VPWR net67 sky130_fd_sc_hd__buf_1
XFILLER_115_237 VPWR VGND VPWR VGND sky130_ef_sc_hd__decap_12
XTAP_TAPCELL_ROW_94_1660 VGND VPWR sky130_fd_sc_hd__tapvpwrvgnd_1
XFILLER_124_771 VGND VGND VPWR VPWR sky130_fd_sc_hd__decap_3
X_13249_ net284 _00259_ _05988_ _05695_ VGND VGND VPWR VPWR _06107_ sky130_fd_sc_hd__a31o_1
XFILLER_42_3 VPWR VGND VPWR VGND sky130_ef_sc_hd__decap_12
XFILLER_130_218 VPWR VGND VPWR VGND sky130_ef_sc_hd__decap_12
XFILLER_123_270 VGND VGND VPWR VPWR sky130_fd_sc_hd__decap_8
XFILLER_96_110 VPWR VGND VPWR VGND sky130_ef_sc_hd__decap_12
XFILLER_69_313 VPWR VGND VPWR VGND sky130_ef_sc_hd__decap_12
X_08790_ _01254_ _01255_ VGND VGND VPWR VPWR _01256_ sky130_fd_sc_hd__and2b_1
X_07810_ _00144_ _00287_ VGND VGND VPWR VPWR _00289_ sky130_fd_sc_hd__or2_1
XFILLER_111_487 VPWR VGND VPWR VGND sky130_ef_sc_hd__decap_12
XFILLER_97_688 VGND VGND VPWR VPWR sky130_fd_sc_hd__fill_1
X_07741_ _00207_ _00219_ VGND VGND VPWR VPWR _00220_ sky130_fd_sc_hd__xnor2_1
XFILLER_77_390 VGND VGND VPWR VPWR sky130_fd_sc_hd__fill_2
XFILLER_65_574 VGND VGND VPWR VPWR sky130_fd_sc_hd__decap_3
X_07672_ _06782_ _06815_ _06814_ VGND VGND VPWR VPWR _00151_ sky130_fd_sc_hd__a21o_1
XFILLER_25_416 VGND VGND VPWR VPWR sky130_fd_sc_hd__decap_4
X_09411_ _01923_ _01922_ _01921_ VGND VGND VPWR VPWR _01925_ sky130_fd_sc_hd__and3b_1
XFILLER_92_382 VGND VGND VPWR VPWR sky130_fd_sc_hd__decap_4
XFILLER_80_533 VGND VGND VPWR VPWR sky130_fd_sc_hd__decap_8
XFILLER_16_29 VPWR VGND VPWR VGND sky130_ef_sc_hd__decap_12
XFILLER_25_449 VGND VGND VPWR VPWR sky130_fd_sc_hd__decap_3
X_09342_ _01848_ _01849_ _01690_ VGND VGND VPWR VPWR _01851_ sky130_fd_sc_hd__a21o_1
XTAP_TAPCELL_ROW_121_2056 VGND VPWR sky130_fd_sc_hd__tapvpwrvgnd_1
XFILLER_52_246 VGND VGND VPWR VPWR sky130_fd_sc_hd__decap_6
XTAP_TAPCELL_ROW_23_628 VGND VPWR sky130_fd_sc_hd__tapvpwrvgnd_1
XTAP_TAPCELL_ROW_23_639 VGND VPWR sky130_fd_sc_hd__tapvpwrvgnd_1
X_09273_ _01774_ _01773_ VGND VGND VPWR VPWR _01775_ sky130_fd_sc_hd__and2b_1
XFILLER_138_329 VGND VGND VPWR VPWR sky130_fd_sc_hd__decap_6
XFILLER_20_154 VGND VGND VPWR VPWR sky130_fd_sc_hd__decap_3
X_08224_ _00567_ _00570_ _00697_ VGND VGND VPWR VPWR _00699_ sky130_fd_sc_hd__o21a_1
XFILLER_119_554 VGND VGND VPWR VPWR sky130_fd_sc_hd__decap_6
X_08155_ net706 net705 net603 net598 VGND VGND VPWR VPWR _00631_ sky130_fd_sc_hd__and4b_1
XFILLER_107_716 VGND VGND VPWR VPWR sky130_fd_sc_hd__fill_2
X_07106_ _04351_ _04482_ VGND VGND VPWR VPWR _04493_ sky130_fd_sc_hd__xnor2_1
XFILLER_4_309 VGND VGND VPWR VPWR sky130_fd_sc_hd__decap_3
XFILLER_134_557 VGND VGND VPWR VPWR sky130_fd_sc_hd__decap_8
XFILLER_106_237 VGND VGND VPWR VPWR sky130_fd_sc_hd__fill_1
XFILLER_106_226 VGND VGND VPWR VPWR sky130_fd_sc_hd__fill_1
X_08086_ net691 net689 net536 net534 VGND VGND VPWR VPWR _00562_ sky130_fd_sc_hd__and4b_1
XFILLER_121_207 VPWR VGND VPWR VGND sky130_ef_sc_hd__decap_12
X_07037_ _03631_ _03642_ _03708_ VGND VGND VPWR VPWR _03740_ sky130_fd_sc_hd__a21oi_1
XFILLER_102_421 VPWR VGND VPWR VGND sky130_ef_sc_hd__decap_12
XTAP_TAPCELL_ROW_50_1018 VGND VPWR sky130_fd_sc_hd__tapvpwrvgnd_1
XFILLER_0_559 VGND VGND VPWR VPWR sky130_fd_sc_hd__fill_1
X_08988_ net472 net607 net377 net330 VGND VGND VPWR VPWR _01465_ sky130_fd_sc_hd__and4_1
XFILLER_88_699 VGND VGND VPWR VPWR sky130_fd_sc_hd__fill_1
XFILLER_57_69 VGND VGND VPWR VPWR sky130_fd_sc_hd__fill_2
XTAP_TAPCELL_ROW_50_1029 VGND VPWR sky130_fd_sc_hd__tapvpwrvgnd_1
XFILLER_91_809 VPWR VGND VPWR VGND sky130_ef_sc_hd__decap_12
X_07939_ _00415_ _00416_ VGND VGND VPWR VPWR _00417_ sky130_fd_sc_hd__nor2_1
XTAP_TAPCELL_ROW_3_342 VGND VPWR sky130_fd_sc_hd__tapvpwrvgnd_1
XFILLER_28_221 VGND VGND VPWR VPWR sky130_fd_sc_hd__decap_3
XFILLER_56_552 VPWR VGND VPWR VGND sky130_ef_sc_hd__decap_12
X_10950_ _03600_ VGND VGND VPWR VPWR _03601_ sky130_fd_sc_hd__inv_2
XFILLER_28_265 VPWR VGND VPWR VGND sky130_ef_sc_hd__decap_12
XFILLER_29_777 VGND VGND VPWR VPWR sky130_fd_sc_hd__decap_6
XTAP_TAPCELL_ROW_106_1829 VGND VPWR sky130_fd_sc_hd__tapvpwrvgnd_1
X_09609_ net620 net368 net367 net629 VGND VGND VPWR VPWR _02142_ sky130_fd_sc_hd__a22oi_1
XFILLER_83_393 VGND VGND VPWR VPWR sky130_fd_sc_hd__fill_2
X_10881_ _03348_ _03350_ VGND VGND VPWR VPWR _03526_ sky130_fd_sc_hd__nor2_1
X_12620_ _05418_ _05419_ VGND VGND VPWR VPWR _05420_ sky130_fd_sc_hd__nand2_1
XFILLER_73_57 VPWR VGND VPWR VGND sky130_ef_sc_hd__decap_12
XFILLER_71_544 VGND VGND VPWR VPWR sky130_fd_sc_hd__fill_2
XFILLER_44_769 VPWR VGND VPWR VGND sky130_ef_sc_hd__decap_12
XTAP_TAPCELL_ROW_42_904 VGND VPWR sky130_fd_sc_hd__tapvpwrvgnd_1
XFILLER_31_408 VPWR VGND VPWR VGND sky130_ef_sc_hd__decap_12
XTAP_TAPCELL_ROW_42_915 VGND VPWR sky130_fd_sc_hd__tapvpwrvgnd_1
X_12551_ _05342_ _05343_ _05338_ VGND VGND VPWR VPWR _05345_ sky130_fd_sc_hd__a21o_1
X_12482_ _05251_ _05268_ VGND VGND VPWR VPWR _05269_ sky130_fd_sc_hd__xnor2_1
X_11502_ _04187_ _04203_ VGND VGND VPWR VPWR _04204_ sky130_fd_sc_hd__xnor2_1
XFILLER_12_699 VGND VGND VPWR VPWR sky130_fd_sc_hd__fill_1
X_11433_ net602 net317 VGND VGND VPWR VPWR _04129_ sky130_fd_sc_hd__nand2_1
XFILLER_7_169 VGND VGND VPWR VPWR sky130_fd_sc_hd__decap_8
XFILLER_125_557 VGND VGND VPWR VPWR sky130_fd_sc_hd__decap_3
XFILLER_125_524 VGND VGND VPWR VPWR sky130_fd_sc_hd__fill_2
XFILLER_4_821 VGND VGND VPWR VPWR sky130_fd_sc_hd__decap_3
X_11364_ _03901_ _04051_ VGND VGND VPWR VPWR _04053_ sky130_fd_sc_hd__xnor2_1
XFILLER_125_579 VGND VGND VPWR VPWR sky130_fd_sc_hd__decap_3
XFILLER_98_419 VGND VGND VPWR VPWR sky130_fd_sc_hd__fill_1
XFILLER_98_65 VPWR VGND VPWR VGND sky130_ef_sc_hd__decap_12
X_13103_ _05628_ _05790_ _05944_ VGND VGND VPWR VPWR _05947_ sky130_fd_sc_hd__or3_1
X_10315_ net561 net553 net313 net312 VGND VGND VPWR VPWR _02906_ sky130_fd_sc_hd__and4_1
X_11295_ _03972_ _03977_ VGND VGND VPWR VPWR _03978_ sky130_fd_sc_hd__and2b_1
XFILLER_106_793 VPWR VGND VPWR VGND sky130_ef_sc_hd__decap_12
X_13034_ _05737_ _05871_ VGND VGND VPWR VPWR _05872_ sky130_fd_sc_hd__xnor2_1
X_10246_ _02830_ _02831_ VGND VGND VPWR VPWR _02832_ sky130_fd_sc_hd__nand2_1
XFILLER_67_817 VGND VGND VPWR VPWR sky130_fd_sc_hd__decap_3
X_10177_ _02679_ _02756_ _02755_ VGND VGND VPWR VPWR _02759_ sky130_fd_sc_hd__o21a_1
XFILLER_121_785 VPWR VGND VPWR VGND sky130_ef_sc_hd__decap_12
XFILLER_120_273 VPWR VGND VPWR VGND sky130_ef_sc_hd__decap_12
XFILLER_94_669 VPWR VGND VPWR VGND sky130_ef_sc_hd__decap_12
XFILLER_74_360 VGND VGND VPWR VPWR sky130_fd_sc_hd__decap_4
XFILLER_47_585 VPWR VGND VPWR VGND sky130_ef_sc_hd__decap_12
XFILLER_35_736 VPWR VGND VPWR VGND sky130_ef_sc_hd__decap_12
XFILLER_50_717 VGND VGND VPWR VPWR sky130_fd_sc_hd__fill_1
XFILLER_22_408 VGND VGND VPWR VPWR sky130_fd_sc_hd__fill_2
X_12818_ net495 net398 _05462_ _05460_ VGND VGND VPWR VPWR _05636_ sky130_fd_sc_hd__a31o_1
X_12749_ _05556_ _05557_ _05381_ _05383_ VGND VGND VPWR VPWR _05561_ sky130_fd_sc_hd__a211oi_1
XFILLER_8_41 VPWR VGND VPWR VGND sky130_ef_sc_hd__decap_12
XFILLER_30_474 VGND VGND VPWR VPWR sky130_fd_sc_hd__fill_2
XFILLER_8_85 VGND VGND VPWR VPWR sky130_fd_sc_hd__decap_3
XFILLER_128_362 VGND VGND VPWR VPWR sky130_fd_sc_hd__fill_2
XFILLER_131_505 VPWR VGND VPWR VGND sky130_ef_sc_hd__decap_12
X_09960_ _02519_ _02520_ VGND VGND VPWR VPWR _02524_ sky130_fd_sc_hd__or2_1
X_08911_ _01378_ _01379_ VGND VGND VPWR VPWR _01380_ sky130_fd_sc_hd__nand2_1
X_09891_ _02177_ _02448_ VGND VGND VPWR VPWR _02449_ sky130_fd_sc_hd__nor2_1
XFILLER_97_441 VGND VGND VPWR VPWR sky130_fd_sc_hd__decap_6
X_08842_ _01298_ _01307_ VGND VGND VPWR VPWR _01308_ sky130_fd_sc_hd__xnor2_1
XFILLER_111_251 VGND VGND VPWR VPWR sky130_fd_sc_hd__decap_4
XFILLER_85_625 VGND VGND VPWR VPWR sky130_fd_sc_hd__fill_1
X_08773_ _01232_ _01236_ _01059_ _01070_ VGND VGND VPWR VPWR _01240_ sky130_fd_sc_hd__a211o_1
XFILLER_73_809 VPWR VGND VPWR VGND sky130_ef_sc_hd__decap_12
XFILLER_38_530 VGND VGND VPWR VPWR sky130_fd_sc_hd__fill_2
XFILLER_84_168 VPWR VGND VPWR VGND sky130_ef_sc_hd__decap_12
X_07724_ net682 net493 _06790_ _06789_ VGND VGND VPWR VPWR _00203_ sky130_fd_sc_hd__a31o_1
XTAP_TAPCELL_ROW_0_301 VGND VPWR sky130_fd_sc_hd__tapvpwrvgnd_1
XFILLER_27_39 VPWR VGND VPWR VGND sky130_ef_sc_hd__decap_12
XFILLER_26_714 VGND VGND VPWR VPWR sky130_fd_sc_hd__fill_2
XTAP_TAPCELL_ROW_28_709 VGND VPWR sky130_fd_sc_hd__tapvpwrvgnd_1
XFILLER_38_541 VGND VGND VPWR VPWR sky130_fd_sc_hd__fill_1
X_07655_ _06720_ _06722_ _00133_ _00134_ VGND VGND VPWR VPWR _00135_ sky130_fd_sc_hd__o211a_1
XFILLER_25_202 VGND VGND VPWR VPWR sky130_fd_sc_hd__decap_6
X_07586_ _06783_ _06813_ VGND VGND VPWR VPWR _06815_ sky130_fd_sc_hd__xnor2_1
XFILLER_53_577 VPWR VGND VPWR VGND sky130_ef_sc_hd__decap_12
XFILLER_43_27 VPWR VGND VPWR VGND sky130_ef_sc_hd__decap_12
XFILLER_25_268 VGND VGND VPWR VPWR sky130_fd_sc_hd__decap_3
XFILLER_40_205 VGND VGND VPWR VPWR sky130_fd_sc_hd__decap_8
X_09325_ _01814_ _01830_ _01831_ VGND VGND VPWR VPWR _01832_ sky130_fd_sc_hd__nand3_1
X_09256_ net496 net347 VGND VGND VPWR VPWR _01756_ sky130_fd_sc_hd__nand2_1
XTAP_TAPCELL_ROW_101_1759 VGND VPWR sky130_fd_sc_hd__tapvpwrvgnd_1
XFILLER_138_137 VGND VGND VPWR VPWR sky130_fd_sc_hd__decap_3
X_08207_ _00682_ VGND VGND VPWR VPWR _00683_ sky130_fd_sc_hd__inv_2
XTAP_TAPCELL_ROW_134_2247 VGND VPWR sky130_fd_sc_hd__tapvpwrvgnd_1
XTAP_TAPCELL_ROW_134_2236 VGND VPWR sky130_fd_sc_hd__tapvpwrvgnd_1
X_09187_ _01504_ _01506_ _01679_ VGND VGND VPWR VPWR _01681_ sky130_fd_sc_hd__and3_1
XFILLER_5_629 VPWR VGND VPWR VGND sky130_ef_sc_hd__decap_12
XFILLER_111_6 VPWR VGND VPWR VGND sky130_ef_sc_hd__decap_12
X_08138_ _00486_ _00492_ _00491_ VGND VGND VPWR VPWR _00614_ sky130_fd_sc_hd__a21oi_1
XFILLER_4_128 VPWR VGND VPWR VGND sky130_ef_sc_hd__decap_12
XFILLER_134_365 VGND VGND VPWR VPWR sky130_fd_sc_hd__decap_8
XTAP_TAPCELL_ROW_116_1980 VGND VPWR sky130_fd_sc_hd__tapvpwrvgnd_1
XFILLER_108_53 VPWR VGND VPWR VGND sky130_ef_sc_hd__decap_12
X_08069_ _00334_ _00414_ _00413_ VGND VGND VPWR VPWR _00546_ sky130_fd_sc_hd__a21boi_2
XTAP_TAPCELL_ROW_8_412 VGND VPWR sky130_fd_sc_hd__tapvpwrvgnd_1
X_10100_ _02458_ _02676_ VGND VGND VPWR VPWR _02677_ sky130_fd_sc_hd__xnor2_1
X_11080_ _03596_ _03599_ _03595_ VGND VGND VPWR VPWR _03743_ sky130_fd_sc_hd__a21o_1
X_10031_ _02596_ _02600_ VGND VGND VPWR VPWR _02601_ sky130_fd_sc_hd__xor2_1
XFILLER_103_741 VPWR VGND VPWR VGND sky130_ef_sc_hd__decap_12
XFILLER_103_785 VPWR VGND VPWR VGND sky130_ef_sc_hd__decap_12
XFILLER_49_817 VGND VGND VPWR VPWR sky130_fd_sc_hd__decap_3
XFILLER_124_41 VPWR VGND VPWR VGND sky130_ef_sc_hd__decap_12
XFILLER_102_284 VPWR VGND VPWR VGND sky130_ef_sc_hd__decap_12
XFILLER_76_669 VGND VGND VPWR VPWR sky130_fd_sc_hd__decap_3
XFILLER_75_135 VPWR VGND VPWR VGND sky130_ef_sc_hd__decap_12
XFILLER_75_113 VPWR VGND VPWR VGND sky130_ef_sc_hd__decap_12
XFILLER_124_85 VPWR VGND VPWR VGND sky130_ef_sc_hd__decap_12
XFILLER_91_617 VPWR VGND VPWR VGND sky130_ef_sc_hd__decap_12
X_11982_ _04720_ _04721_ VGND VGND VPWR VPWR _04723_ sky130_fd_sc_hd__xor2_1
XFILLER_44_533 VGND VGND VPWR VPWR sky130_fd_sc_hd__fill_1
XFILLER_44_500 VGND VGND VPWR VPWR sky130_fd_sc_hd__decap_6
XFILLER_90_149 VGND VGND VPWR VPWR sky130_fd_sc_hd__fill_1
X_10933_ _03568_ _03580_ VGND VGND VPWR VPWR _03582_ sky130_fd_sc_hd__xnor2_1
XFILLER_16_246 VGND VGND VPWR VPWR sky130_fd_sc_hd__decap_6
X_13652_ clknet_3_7__leaf_clk _00010_ net717 VGND VGND VPWR VPWR net187 sky130_fd_sc_hd__dfrtp_1
XFILLER_71_363 VGND VGND VPWR VPWR sky130_fd_sc_hd__fill_2
XTAP_TAPCELL_ROW_63_1209 VGND VPWR sky130_fd_sc_hd__tapvpwrvgnd_1
X_10864_ _03477_ _03506_ VGND VGND VPWR VPWR _03507_ sky130_fd_sc_hd__and2_1
XFILLER_32_728 VPWR VGND VPWR VGND sky130_ef_sc_hd__decap_12
X_12603_ _05228_ _05230_ _05227_ VGND VGND VPWR VPWR _05401_ sky130_fd_sc_hd__a21oi_1
X_13583_ _06386_ _06388_ _06469_ VGND VGND VPWR VPWR _06471_ sky130_fd_sc_hd__a21o_1
X_10795_ _03428_ _03429_ VGND VGND VPWR VPWR _03431_ sky130_fd_sc_hd__or2_1
X_12534_ net607 net386 net369 net615 VGND VGND VPWR VPWR _05326_ sky130_fd_sc_hd__a22o_1
XFILLER_8_445 VGND VGND VPWR VPWR sky130_fd_sc_hd__decap_8
XFILLER_138_671 VGND VGND VPWR VPWR sky130_fd_sc_hd__fill_1
XFILLER_126_811 VGND VGND VPWR VPWR sky130_fd_sc_hd__fill_1
X_12465_ _05248_ _05249_ VGND VGND VPWR VPWR _05250_ sky130_fd_sc_hd__nand2_1
XTAP_TAPCELL_ROW_78_1430 VGND VPWR sky130_fd_sc_hd__tapvpwrvgnd_1
XFILLER_8_489 VGND VGND VPWR VPWR sky130_fd_sc_hd__fill_1
XFILLER_8_467 VGND VGND VPWR VPWR sky130_fd_sc_hd__decap_8
X_12396_ net624 net4 net5 net633 VGND VGND VPWR VPWR _05175_ sky130_fd_sc_hd__a22o_1
X_11416_ _04108_ _04109_ VGND VGND VPWR VPWR _04110_ sky130_fd_sc_hd__xnor2_1
XFILLER_4_651 VPWR VGND VPWR VGND sky130_ef_sc_hd__decap_12
X_11347_ _04032_ _04033_ VGND VGND VPWR VPWR _04034_ sky130_fd_sc_hd__nand2_1
XFILLER_4_684 VGND VGND VPWR VPWR sky130_fd_sc_hd__decap_4
XFILLER_79_441 VGND VGND VPWR VPWR sky130_fd_sc_hd__decap_6
X_11278_ _03958_ VGND VGND VPWR VPWR _03960_ sky130_fd_sc_hd__inv_2
X_13017_ _05850_ _05851_ VGND VGND VPWR VPWR _05853_ sky130_fd_sc_hd__xnor2_1
XFILLER_67_614 VGND VGND VPWR VPWR sky130_fd_sc_hd__fill_2
X_10229_ net458 net283 _02813_ VGND VGND VPWR VPWR _02814_ sky130_fd_sc_hd__and3_1
XFILLER_94_477 VPWR VGND VPWR VGND sky130_ef_sc_hd__decap_12
XFILLER_54_319 VPWR VGND VPWR VGND sky130_ef_sc_hd__decap_12
XTAP_TAPCELL_ROW_89_1592 VGND VPWR sky130_fd_sc_hd__tapvpwrvgnd_1
XFILLER_81_116 VPWR VGND VPWR VGND sky130_ef_sc_hd__decap_12
XFILLER_63_820 VGND VGND VPWR VPWR sky130_fd_sc_hd__decap_4
XFILLER_35_500 VGND VGND VPWR VPWR sky130_fd_sc_hd__decap_4
XFILLER_90_650 VGND VGND VPWR VPWR sky130_fd_sc_hd__decap_8
XFILLER_47_393 VGND VGND VPWR VPWR sky130_fd_sc_hd__fill_1
X_07440_ _06367_ _06400_ _06389_ VGND VGND VPWR VPWR _06670_ sky130_fd_sc_hd__o21bai_1
XPHY_EDGE_ROW_8_Right_8 VGND VGND VPWR VPWR sky130_fd_sc_hd__decap_3
XFILLER_23_739 VGND VGND VPWR VPWR sky130_fd_sc_hd__decap_3
XFILLER_35_588 VGND VGND VPWR VPWR sky130_fd_sc_hd__decap_4
X_07371_ _06583_ _06600_ VGND VGND VPWR VPWR _06601_ sky130_fd_sc_hd__xnor2_1
X_09110_ _01424_ _01595_ _01596_ VGND VGND VPWR VPWR _01597_ sky130_fd_sc_hd__or3_1
XTAP_TAPCELL_ROW_33_778 VGND VPWR sky130_fd_sc_hd__tapvpwrvgnd_1
X_09041_ net541 net363 VGND VGND VPWR VPWR _01522_ sky130_fd_sc_hd__nand2_1
XFILLER_31_783 VGND VGND VPWR VPWR sky130_fd_sc_hd__fill_1
XTAP_TAPCELL_ROW_13_491 VGND VPWR sky130_fd_sc_hd__tapvpwrvgnd_1
XFILLER_116_321 VGND VGND VPWR VPWR sky130_fd_sc_hd__decap_4
XFILLER_89_216 VGND VGND VPWR VPWR sky130_fd_sc_hd__decap_8
X_09943_ _02495_ _02504_ VGND VGND VPWR VPWR _02505_ sky130_fd_sc_hd__xor2_1
XPHY_EDGE_ROW_39_Right_39 VGND VGND VPWR VPWR sky130_fd_sc_hd__decap_3
X_09874_ _02427_ _02428_ VGND VGND VPWR VPWR _02430_ sky130_fd_sc_hd__xnor2_1
XFILLER_38_27 VGND VGND VPWR VPWR sky130_fd_sc_hd__fill_1
X_08825_ _01283_ _01289_ VGND VGND VPWR VPWR _01291_ sky130_fd_sc_hd__xnor2_1
XFILLER_97_293 VPWR VGND VPWR VGND sky130_ef_sc_hd__decap_12
XFILLER_58_636 VGND VGND VPWR VPWR sky130_fd_sc_hd__decap_8
XFILLER_57_113 VGND VGND VPWR VPWR sky130_fd_sc_hd__decap_8
XFILLER_73_617 VPWR VGND VPWR VGND sky130_ef_sc_hd__decap_12
X_08756_ _01213_ _01214_ _01217_ net238 VGND VGND VPWR VPWR _01223_ sky130_fd_sc_hd__a211o_1
XFILLER_85_499 VGND VGND VPWR VPWR sky130_fd_sc_hd__decap_4
XFILLER_66_680 VPWR VGND VPWR VGND sky130_ef_sc_hd__decap_12
X_08687_ _01148_ _01153_ VGND VGND VPWR VPWR _01154_ sky130_fd_sc_hd__nand2_1
XFILLER_54_15 VPWR VGND VPWR VGND sky130_ef_sc_hd__decap_12
X_07707_ _00151_ _00185_ VGND VGND VPWR VPWR _00186_ sky130_fd_sc_hd__nand2_1
X_07638_ _06700_ _06702_ _00116_ _00117_ VGND VGND VPWR VPWR _00118_ sky130_fd_sc_hd__o211a_1
XFILLER_41_514 VGND VGND VPWR VPWR sky130_fd_sc_hd__fill_1
XFILLER_41_503 VGND VGND VPWR VPWR sky130_fd_sc_hd__fill_1
XFILLER_13_216 VGND VGND VPWR VPWR sky130_fd_sc_hd__fill_1
X_07569_ _06641_ _06644_ VGND VGND VPWR VPWR _06798_ sky130_fd_sc_hd__nand2_1
XPHY_EDGE_ROW_48_Right_48 VGND VGND VPWR VPWR sky130_fd_sc_hd__decap_3
XFILLER_110_65 VPWR VGND VPWR VGND sky130_ef_sc_hd__decap_12
X_09308_ _01805_ _01812_ VGND VGND VPWR VPWR _01814_ sky130_fd_sc_hd__xor2_1
XFILLER_22_750 VGND VGND VPWR VPWR sky130_fd_sc_hd__decap_6
X_10580_ net233 _03195_ _03048_ _03051_ VGND VGND VPWR VPWR _03197_ sky130_fd_sc_hd__o211ai_2
X_09239_ _01737_ _01735_ VGND VGND VPWR VPWR _01738_ sky130_fd_sc_hd__nand2b_1
XFILLER_108_811 VGND VGND VPWR VPWR sky130_fd_sc_hd__fill_1
XFILLER_126_118 VPWR VGND VPWR VGND sky130_ef_sc_hd__decap_12
XFILLER_119_181 VGND VGND VPWR VPWR sky130_fd_sc_hd__decap_6
X_12250_ net470 net383 _04848_ VGND VGND VPWR VPWR _05016_ sky130_fd_sc_hd__and3_1
XFILLER_123_803 VGND VGND VPWR VPWR sky130_fd_sc_hd__fill_1
XFILLER_107_343 VPWR VGND VPWR VGND sky130_ef_sc_hd__decap_12
X_12181_ _04934_ _04940_ VGND VGND VPWR VPWR _00034_ sky130_fd_sc_hd__xor2_1
XFILLER_79_45 VGND VGND VPWR VPWR sky130_fd_sc_hd__decap_8
X_11201_ _03758_ _03760_ _03874_ VGND VGND VPWR VPWR _03875_ sky130_fd_sc_hd__a21oi_1
XPHY_EDGE_ROW_57_Right_57 VGND VGND VPWR VPWR sky130_fd_sc_hd__decap_3
X_11132_ _03763_ _03799_ VGND VGND VPWR VPWR _03800_ sky130_fd_sc_hd__xor2_1
XFILLER_96_709 VGND VGND VPWR VPWR sky130_fd_sc_hd__decap_8
XTAP_TAPCELL_ROW_73_1360 VGND VPWR sky130_fd_sc_hd__tapvpwrvgnd_1
XFILLER_135_51 VGND VGND VPWR VPWR sky130_fd_sc_hd__decap_4
XFILLER_76_400 VGND VGND VPWR VPWR sky130_fd_sc_hd__fill_2
X_11063_ net544 net307 VGND VGND VPWR VPWR _03724_ sky130_fd_sc_hd__nand2_1
X_10014_ _01610_ _02581_ VGND VGND VPWR VPWR _02582_ sky130_fd_sc_hd__nand2_1
XFILLER_95_55 VGND VGND VPWR VPWR sky130_fd_sc_hd__fill_1
XFILLER_49_647 VGND VGND VPWR VPWR sky130_fd_sc_hd__decap_6
XFILLER_0_197 VGND VGND VPWR VPWR sky130_fd_sc_hd__fill_2
XFILLER_76_477 VPWR VGND VPWR VGND sky130_ef_sc_hd__decap_12
XFILLER_37_809 VPWR VGND VPWR VGND sky130_ef_sc_hd__decap_12
X_11965_ net656 net645 net387 net369 VGND VGND VPWR VPWR _04704_ sky130_fd_sc_hd__and4_1
XPHY_EDGE_ROW_66_Right_66 VGND VGND VPWR VPWR sky130_fd_sc_hd__decap_3
X_10916_ _03561_ _03562_ VGND VGND VPWR VPWR _03563_ sky130_fd_sc_hd__nand2b_1
X_13635_ clknet_3_6__leaf_clk _00004_ net716 VGND VGND VPWR VPWR net170 sky130_fd_sc_hd__dfrtp_1
X_11896_ _04628_ _04631_ VGND VGND VPWR VPWR _04632_ sky130_fd_sc_hd__xnor2_1
X_10847_ net650 net315 net410 VGND VGND VPWR VPWR _03488_ sky130_fd_sc_hd__a21oi_1
X_13566_ _06447_ _06450_ VGND VGND VPWR VPWR _06452_ sky130_fd_sc_hd__xnor2_1
XFILLER_9_743 VPWR VGND VPWR VGND sky130_ef_sc_hd__decap_12
X_10778_ _03363_ _03411_ VGND VGND VPWR VPWR _03413_ sky130_fd_sc_hd__nand2_1
XFILLER_13_783 VGND VGND VPWR VPWR sky130_fd_sc_hd__fill_1
XTAP_TAPCELL_ROW_30_737 VGND VPWR sky130_fd_sc_hd__tapvpwrvgnd_1
X_13497_ _06375_ _06376_ VGND VGND VPWR VPWR _06377_ sky130_fd_sc_hd__or2_1
X_12517_ _05303_ _05305_ VGND VGND VPWR VPWR _05307_ sky130_fd_sc_hd__xor2_1
XFILLER_74_6 VPWR VGND VPWR VGND sky130_ef_sc_hd__decap_12
XFILLER_8_253 VPWR VGND VPWR VGND sky130_ef_sc_hd__decap_12
X_12448_ _05229_ _05230_ VGND VGND VPWR VPWR _05232_ sky130_fd_sc_hd__xnor2_1
XTAP_TAPCELL_ROW_10_450 VGND VPWR sky130_fd_sc_hd__tapvpwrvgnd_1
XFILLER_126_652 VGND VGND VPWR VPWR sky130_fd_sc_hd__decap_6
XFILLER_99_503 VGND VGND VPWR VPWR sky130_fd_sc_hd__fill_1
XPHY_EDGE_ROW_75_Right_75 VGND VGND VPWR VPWR sky130_fd_sc_hd__decap_3
X_12379_ _05001_ _05004_ _05003_ VGND VGND VPWR VPWR _05157_ sky130_fd_sc_hd__o21bai_1
XFILLER_99_569 VGND VGND VPWR VPWR sky130_fd_sc_hd__fill_1
XFILLER_87_709 VGND VGND VPWR VPWR sky130_fd_sc_hd__fill_2
X_06940_ _02608_ _02652_ _02663_ VGND VGND VPWR VPWR _02684_ sky130_fd_sc_hd__or3_1
XFILLER_95_742 VPWR VGND VPWR VGND sky130_ef_sc_hd__decap_12
XFILLER_79_293 VPWR VGND VPWR VGND sky130_ef_sc_hd__decap_12
X_06871_ net98 net638 VGND VGND VPWR VPWR _01932_ sky130_fd_sc_hd__nand2_1
XFILLER_67_433 VGND VGND VPWR VPWR sky130_fd_sc_hd__decap_3
XFILLER_67_422 VGND VGND VPWR VPWR sky130_fd_sc_hd__fill_1
XFILLER_39_113 VGND VGND VPWR VPWR sky130_fd_sc_hd__decap_4
X_08610_ net507 net352 net351 net516 VGND VGND VPWR VPWR _01077_ sky130_fd_sc_hd__a22oi_1
XFILLER_55_617 VPWR VGND VPWR VGND sky130_ef_sc_hd__decap_12
X_09590_ _02119_ _02120_ VGND VGND VPWR VPWR _02121_ sky130_fd_sc_hd__or2_1
XFILLER_95_797 VGND VGND VPWR VPWR sky130_fd_sc_hd__decap_6
XPHY_EDGE_ROW_84_Right_84 VGND VGND VPWR VPWR sky130_fd_sc_hd__decap_3
XPHY_EDGE_ROW_19_Left_158 VGND VGND VPWR VPWR sky130_fd_sc_hd__decap_3
X_08541_ _01007_ _01008_ VGND VGND VPWR VPWR _01010_ sky130_fd_sc_hd__xor2_1
XTAP_TAPCELL_ROW_38_848 VGND VPWR sky130_fd_sc_hd__tapvpwrvgnd_1
XFILLER_62_160 VGND VGND VPWR VPWR sky130_fd_sc_hd__fill_2
XTAP_TAPCELL_ROW_18_561 VGND VPWR sky130_fd_sc_hd__tapvpwrvgnd_1
X_08472_ _00944_ VGND VGND VPWR VPWR _00945_ sky130_fd_sc_hd__inv_2
X_07423_ _06650_ _06651_ _06639_ VGND VGND VPWR VPWR _06653_ sky130_fd_sc_hd__a21o_1
XFILLER_24_29 VPWR VGND VPWR VGND sky130_ef_sc_hd__decap_12
XFILLER_23_558 VGND VGND VPWR VPWR sky130_fd_sc_hd__fill_2
XFILLER_23_569 VGND VGND VPWR VPWR sky130_fd_sc_hd__fill_1
XTAP_TAPCELL_ROW_118_2017 VGND VPWR sky130_fd_sc_hd__tapvpwrvgnd_1
XTAP_TAPCELL_ROW_118_2006 VGND VPWR sky130_fd_sc_hd__tapvpwrvgnd_1
XFILLER_10_219 VGND VGND VPWR VPWR sky130_fd_sc_hd__fill_1
X_07354_ net568 net694 net562 net692 VGND VGND VPWR VPWR _06584_ sky130_fd_sc_hd__and4_1
X_07285_ _06410_ _06421_ _06432_ VGND VGND VPWR VPWR _06443_ sky130_fd_sc_hd__nand3_1
XFILLER_136_449 VGND VGND VPWR VPWR sky130_fd_sc_hd__decap_8
X_09024_ _01351_ _01348_ _01502_ _01503_ VGND VGND VPWR VPWR _01504_ sky130_fd_sc_hd__a211o_4
XPHY_EDGE_ROW_93_Right_93 VGND VGND VPWR VPWR sky130_fd_sc_hd__decap_3
XPHY_EDGE_ROW_28_Left_167 VGND VGND VPWR VPWR sky130_fd_sc_hd__decap_3
XFILLER_117_663 VGND VGND VPWR VPWR sky130_fd_sc_hd__fill_1
XFILLER_2_429 VGND VGND VPWR VPWR sky130_fd_sc_hd__decap_3
XFILLER_116_195 VGND VGND VPWR VPWR sky130_fd_sc_hd__fill_1
XFILLER_49_15 VPWR VGND VPWR VGND sky130_ef_sc_hd__decap_12
Xfanout700 net108 VGND VGND VPWR VPWR net700 sky130_fd_sc_hd__clkbuf_2
X_09926_ _02484_ _02485_ VGND VGND VPWR VPWR _02486_ sky130_fd_sc_hd__or2_1
Xfanout711 net10 VGND VGND VPWR VPWR net711 sky130_fd_sc_hd__buf_2
XFILLER_58_433 VPWR VGND VPWR VGND sky130_ef_sc_hd__decap_12
XTAP_TAPCELL_ROW_55_1090 VGND VPWR sky130_fd_sc_hd__tapvpwrvgnd_1
XTAP_TAPCELL_ROW_129_2168 VGND VPWR sky130_fd_sc_hd__tapvpwrvgnd_1
X_09857_ _02283_ _02291_ _02290_ VGND VGND VPWR VPWR _02412_ sky130_fd_sc_hd__a21oi_1
XFILLER_86_764 VGND VGND VPWR VPWR sky130_fd_sc_hd__decap_8
XFILLER_85_252 VPWR VGND VPWR VGND sky130_ef_sc_hd__decap_12
XFILLER_19_809 VPWR VGND VPWR VGND sky130_ef_sc_hd__decap_12
XPHY_EDGE_ROW_37_Left_176 VGND VGND VPWR VPWR sky130_fd_sc_hd__decap_3
X_09788_ _02192_ _02199_ _02335_ VGND VGND VPWR VPWR _02337_ sky130_fd_sc_hd__a21o_1
X_08808_ net497 net51 VGND VGND VPWR VPWR _01274_ sky130_fd_sc_hd__nand2_1
XFILLER_58_477 VGND VGND VPWR VPWR sky130_fd_sc_hd__fill_1
XFILLER_45_105 VGND VGND VPWR VPWR sky130_fd_sc_hd__decap_6
X_08739_ _01044_ _01158_ VGND VGND VPWR VPWR _01206_ sky130_fd_sc_hd__nor2_1
XFILLER_65_69 VGND VGND VPWR VPWR sky130_fd_sc_hd__decap_4
XFILLER_54_672 VPWR VGND VPWR VGND sky130_ef_sc_hd__decap_12
XFILLER_14_514 VPWR VGND VPWR VGND sky130_ef_sc_hd__decap_12
X_11750_ _03617_ _04472_ VGND VGND VPWR VPWR _04474_ sky130_fd_sc_hd__xnor2_1
XFILLER_81_13 VPWR VGND VPWR VGND sky130_ef_sc_hd__decap_12
X_10701_ _03326_ _03327_ _03328_ VGND VGND VPWR VPWR _03329_ sky130_fd_sc_hd__nand3_1
XFILLER_81_57 VPWR VGND VPWR VGND sky130_ef_sc_hd__decap_12
XFILLER_14_569 VGND VGND VPWR VPWR sky130_fd_sc_hd__decap_6
X_11681_ _04224_ _04226_ _04397_ VGND VGND VPWR VPWR _04399_ sky130_fd_sc_hd__or3_1
X_13420_ _06157_ _06159_ _06293_ VGND VGND VPWR VPWR _06294_ sky130_fd_sc_hd__a21oi_2
XFILLER_81_79 VGND VGND VPWR VPWR sky130_fd_sc_hd__decap_3
XFILLER_41_399 VGND VGND VPWR VPWR sky130_fd_sc_hd__decap_6
X_10632_ _03108_ _03250_ _03252_ VGND VGND VPWR VPWR _03253_ sky130_fd_sc_hd__o21a_1
X_13351_ _06217_ VGND VGND VPWR VPWR _06218_ sky130_fd_sc_hd__inv_2
XPHY_EDGE_ROW_46_Left_185 VGND VGND VPWR VPWR sky130_fd_sc_hd__decap_3
XFILLER_10_731 VGND VGND VPWR VPWR sky130_fd_sc_hd__fill_1
XFILLER_14_73 VGND VGND VPWR VPWR sky130_fd_sc_hd__fill_1
X_10563_ net468 net277 _03012_ _03010_ VGND VGND VPWR VPWR _03178_ sky130_fd_sc_hd__a31o_1
XFILLER_127_449 VGND VGND VPWR VPWR sky130_fd_sc_hd__decap_6
XFILLER_127_427 VPWR VGND VPWR VGND sky130_ef_sc_hd__decap_12
X_12302_ _04845_ _04993_ _04995_ VGND VGND VPWR VPWR _05072_ sky130_fd_sc_hd__a21o_1
X_13282_ _06141_ _06142_ VGND VGND VPWR VPWR _06143_ sky130_fd_sc_hd__xnor2_1
XFILLER_6_757 VPWR VGND VPWR VGND sky130_ef_sc_hd__decap_12
XFILLER_5_223 VGND VGND VPWR VPWR sky130_fd_sc_hd__fill_1
X_10494_ _02958_ _03100_ VGND VGND VPWR VPWR _03102_ sky130_fd_sc_hd__nor2_1
X_12233_ _04995_ _04996_ VGND VGND VPWR VPWR _04997_ sky130_fd_sc_hd__or2_1
XFILLER_30_72 VGND VGND VPWR VPWR sky130_fd_sc_hd__decap_8
XFILLER_107_184 VGND VGND VPWR VPWR sky130_fd_sc_hd__fill_2
X_12164_ _04803_ _04921_ VGND VGND VPWR VPWR _04922_ sky130_fd_sc_hd__and2_1
XFILLER_69_709 VPWR VGND VPWR VGND sky130_ef_sc_hd__decap_12
X_12095_ _04842_ _04844_ VGND VGND VPWR VPWR _04846_ sky130_fd_sc_hd__nor2_1
X_11115_ _03769_ _03780_ VGND VGND VPWR VPWR _03781_ sky130_fd_sc_hd__xor2_1
XPHY_EDGE_ROW_55_Left_194 VGND VGND VPWR VPWR sky130_fd_sc_hd__decap_3
XFILLER_49_411 VPWR VGND VPWR VGND sky130_ef_sc_hd__decap_12
X_11046_ _03523_ _03701_ _03703_ _03361_ VGND VGND VPWR VPWR _03706_ sky130_fd_sc_hd__a211o_1
XFILLER_92_701 VGND VGND VPWR VPWR sky130_fd_sc_hd__decap_8
XFILLER_76_241 VGND VGND VPWR VPWR sky130_fd_sc_hd__decap_4
XFILLER_39_81 VPWR VGND VPWR VGND sky130_ef_sc_hd__decap_12
XFILLER_91_244 VGND VGND VPWR VPWR sky130_fd_sc_hd__fill_2
XFILLER_91_222 VGND VGND VPWR VPWR sky130_fd_sc_hd__fill_2
XTAP_TAPCELL_ROW_86_1540 VGND VPWR sky130_fd_sc_hd__tapvpwrvgnd_1
XTAP_TAPCELL_ROW_86_1551 VGND VPWR sky130_fd_sc_hd__tapvpwrvgnd_1
X_12997_ _05814_ _05830_ VGND VGND VPWR VPWR _05831_ sky130_fd_sc_hd__xor2_1
XFILLER_17_363 VPWR VGND VPWR VGND sky130_ef_sc_hd__decap_12
XTAP_TAPCELL_ROW_35_807 VGND VPWR sky130_fd_sc_hd__tapvpwrvgnd_1
X_11948_ _04682_ _04683_ _04685_ VGND VGND VPWR VPWR _04687_ sky130_fd_sc_hd__and3_1
XFILLER_44_171 VGND VGND VPWR VPWR sky130_fd_sc_hd__decap_8
XTAP_TAPCELL_ROW_15_520 VGND VPWR sky130_fd_sc_hd__tapvpwrvgnd_1
XFILLER_17_396 VGND VGND VPWR VPWR sky130_fd_sc_hd__decap_6
XFILLER_60_642 VGND VGND VPWR VPWR sky130_fd_sc_hd__fill_2
X_11879_ _04431_ _04614_ VGND VGND VPWR VPWR _04615_ sky130_fd_sc_hd__xnor2_1
X_13618_ _06502_ _06507_ VGND VGND VPWR VPWR _06509_ sky130_fd_sc_hd__xnor2_1
XFILLER_60_697 VGND VGND VPWR VPWR sky130_fd_sc_hd__decap_3
XFILLER_60_686 VGND VGND VPWR VPWR sky130_fd_sc_hd__fill_1
X_13549_ _06319_ _06322_ _06431_ VGND VGND VPWR VPWR _06434_ sky130_fd_sc_hd__or3_1
X_07070_ _04057_ _04090_ _04079_ VGND VGND VPWR VPWR _04101_ sky130_fd_sc_hd__nor3b_1
XFILLER_9_573 VGND VGND VPWR VPWR sky130_fd_sc_hd__decap_3
XFILLER_59_219 VGND VGND VPWR VPWR sky130_fd_sc_hd__decap_4
XFILLER_59_208 VGND VGND VPWR VPWR sky130_fd_sc_hd__decap_4
X_09711_ _02248_ _02250_ VGND VGND VPWR VPWR _02253_ sky130_fd_sc_hd__xor2_1
XFILLER_113_198 VGND VGND VPWR VPWR sky130_fd_sc_hd__fill_2
XFILLER_99_399 VGND VGND VPWR VPWR sky130_fd_sc_hd__fill_1
X_07972_ _00447_ _00448_ VGND VGND VPWR VPWR _00449_ sky130_fd_sc_hd__nor2_1
XFILLER_95_561 VGND VGND VPWR VPWR sky130_fd_sc_hd__decap_8
X_06923_ _02140_ _02466_ _02488_ VGND VGND VPWR VPWR _02499_ sky130_fd_sc_hd__a21o_1
X_09642_ _02176_ _02177_ _02175_ VGND VGND VPWR VPWR _02178_ sky130_fd_sc_hd__a21o_1
XFILLER_67_274 VGND VGND VPWR VPWR sky130_fd_sc_hd__decap_6
X_06854_ _01703_ _01714_ _01736_ VGND VGND VPWR VPWR _01747_ sky130_fd_sc_hd__a21o_1
X_09573_ _02099_ _02100_ VGND VGND VPWR VPWR _02102_ sky130_fd_sc_hd__and2_1
XFILLER_82_222 VPWR VGND VPWR VGND sky130_ef_sc_hd__decap_12
XFILLER_55_447 VGND VGND VPWR VPWR sky130_fd_sc_hd__fill_1
XFILLER_35_39 VPWR VGND VPWR VGND sky130_ef_sc_hd__decap_12
X_08524_ _00967_ _00995_ VGND VGND VPWR VPWR _00996_ sky130_fd_sc_hd__xnor2_1
XTAP_TAPCELL_ROW_124_2098 VGND VPWR sky130_fd_sc_hd__tapvpwrvgnd_1
XFILLER_50_141 VGND VGND VPWR VPWR sky130_fd_sc_hd__decap_8
X_08455_ _00598_ _00824_ _00482_ VGND VGND VPWR VPWR _00928_ sky130_fd_sc_hd__o21a_1
XFILLER_35_193 VPWR VGND VPWR VGND sky130_ef_sc_hd__decap_12
X_07406_ _06634_ _06635_ VGND VGND VPWR VPWR _06636_ sky130_fd_sc_hd__nand2_1
X_08386_ _00704_ _00706_ VGND VGND VPWR VPWR _00860_ sky130_fd_sc_hd__nand2_1
X_07337_ _04112_ _05483_ _06566_ _06567_ VGND VGND VPWR VPWR _06568_ sky130_fd_sc_hd__and4_1
XFILLER_109_449 VPWR VGND VPWR VGND sky130_ef_sc_hd__decap_12
X_07268_ _04969_ _06247_ VGND VGND VPWR VPWR _06258_ sky130_fd_sc_hd__xnor2_1
X_09007_ _01319_ _01327_ _01326_ VGND VGND VPWR VPWR _01485_ sky130_fd_sc_hd__a21bo_1
XTAP_TAPCELL_ROW_57_1130 VGND VPWR sky130_fd_sc_hd__tapvpwrvgnd_1
X_07199_ _05461_ _05472_ _05494_ VGND VGND VPWR VPWR _05505_ sky130_fd_sc_hd__nand3_1
XFILLER_3_727 VGND VGND VPWR VPWR sky130_fd_sc_hd__fill_1
XFILLER_3_705 VGND VGND VPWR VPWR sky130_fd_sc_hd__fill_1
XTAP_TAPCELL_ROW_111_1909 VGND VPWR sky130_fd_sc_hd__tapvpwrvgnd_1
XFILLER_105_655 VPWR VGND VPWR VGND sky130_ef_sc_hd__decap_12
XFILLER_104_110 VGND VGND VPWR VPWR sky130_fd_sc_hd__fill_1
Xfanout530 net146 VGND VGND VPWR VPWR net530 sky130_fd_sc_hd__clkbuf_2
XFILLER_116_53 VPWR VGND VPWR VGND sky130_ef_sc_hd__decap_12
Xfanout541 net542 VGND VGND VPWR VPWR net541 sky130_fd_sc_hd__clkbuf_4
XFILLER_78_539 VPWR VGND VPWR VGND sky130_ef_sc_hd__decap_12
X_09909_ _02463_ _02467_ VGND VGND VPWR VPWR _02468_ sky130_fd_sc_hd__xnor2_1
Xfanout574 net576 VGND VGND VPWR VPWR net574 sky130_fd_sc_hd__clkbuf_4
XFILLER_116_97 VGND VGND VPWR VPWR sky130_fd_sc_hd__decap_6
Xfanout563 net141 VGND VGND VPWR VPWR net563 sky130_fd_sc_hd__buf_4
Xfanout552 net559 VGND VGND VPWR VPWR net552 sky130_fd_sc_hd__clkbuf_4
Xfanout596 net597 VGND VGND VPWR VPWR net596 sky130_fd_sc_hd__clkbuf_2
Xfanout585 net587 VGND VGND VPWR VPWR net585 sky130_fd_sc_hd__buf_2
X_12920_ _05745_ _05746_ VGND VGND VPWR VPWR _05747_ sky130_fd_sc_hd__or2_1
XFILLER_86_561 VPWR VGND VPWR VGND sky130_ef_sc_hd__decap_12
XFILLER_46_403 VPWR VGND VPWR VGND sky130_ef_sc_hd__decap_12
XFILLER_132_41 VPWR VGND VPWR VGND sky130_ef_sc_hd__decap_12
X_12851_ _05670_ _05671_ VGND VGND VPWR VPWR _05672_ sky130_fd_sc_hd__or2_1
XFILLER_58_296 VGND VGND VPWR VPWR sky130_fd_sc_hd__decap_4
XFILLER_132_85 VPWR VGND VPWR VGND sky130_ef_sc_hd__decap_12
X_11802_ _04529_ _04530_ VGND VGND VPWR VPWR _04531_ sky130_fd_sc_hd__nor2_1
XFILLER_33_108 VGND VGND VPWR VPWR sky130_fd_sc_hd__decap_4
X_12782_ _05407_ _05595_ VGND VGND VPWR VPWR _05596_ sky130_fd_sc_hd__xnor2_1
XTAP_TAPCELL_ROW_68_1292 VGND VPWR sky130_fd_sc_hd__tapvpwrvgnd_1
XTAP_TAPCELL_ROW_68_1281 VGND VPWR sky130_fd_sc_hd__tapvpwrvgnd_1
XFILLER_54_491 VGND VGND VPWR VPWR sky130_fd_sc_hd__fill_2
XFILLER_33_119 VGND VGND VPWR VPWR sky130_fd_sc_hd__fill_1
XFILLER_42_664 VGND VGND VPWR VPWR sky130_fd_sc_hd__fill_2
X_11733_ _04356_ _04358_ _04369_ VGND VGND VPWR VPWR _04455_ sky130_fd_sc_hd__nor3_1
XTAP_TAPCELL_ROW_81_1470 VGND VPWR sky130_fd_sc_hd__tapvpwrvgnd_1
XFILLER_14_377 VGND VGND VPWR VPWR sky130_fd_sc_hd__decap_4
X_11664_ _04219_ _04234_ _04233_ VGND VGND VPWR VPWR _04380_ sky130_fd_sc_hd__a21o_1
X_13403_ _06250_ _06273_ VGND VGND VPWR VPWR _06275_ sky130_fd_sc_hd__xor2_1
XFILLER_41_196 VGND VGND VPWR VPWR sky130_fd_sc_hd__fill_2
X_10615_ _03232_ _03233_ VGND VGND VPWR VPWR _03234_ sky130_fd_sc_hd__nand2_1
X_11595_ _04303_ _04304_ VGND VGND VPWR VPWR _00015_ sky130_fd_sc_hd__nor2_1
XTAP_TAPCELL_ROW_40_876 VGND VPWR sky130_fd_sc_hd__tapvpwrvgnd_1
XFILLER_128_769 VPWR VGND VPWR VGND sky130_ef_sc_hd__decap_12
X_13334_ net246 _06197_ VGND VGND VPWR VPWR _06199_ sky130_fd_sc_hd__xor2_1
XFILLER_41_93 VGND VGND VPWR VPWR sky130_fd_sc_hd__decap_8
X_10546_ _03155_ _03158_ VGND VGND VPWR VPWR _03159_ sky130_fd_sc_hd__xnor2_1
XFILLER_115_408 VPWR VGND VPWR VGND sky130_ef_sc_hd__decap_12
X_13265_ _05992_ _06003_ _05991_ VGND VGND VPWR VPWR _06124_ sky130_fd_sc_hd__a21oi_1
XFILLER_6_587 VGND VGND VPWR VPWR sky130_fd_sc_hd__fill_1
X_10477_ _02906_ _03082_ VGND VGND VPWR VPWR _03083_ sky130_fd_sc_hd__nand2_1
X_12216_ net497 net407 _04809_ _04755_ net403 VGND VGND VPWR VPWR _04978_ sky130_fd_sc_hd__a32o_1
XFILLER_123_441 VGND VGND VPWR VPWR sky130_fd_sc_hd__fill_1
X_13196_ _05898_ _05905_ _06046_ VGND VGND VPWR VPWR _06048_ sky130_fd_sc_hd__nand3_1
XFILLER_69_517 VPWR VGND VPWR VGND sky130_ef_sc_hd__decap_12
XPHY_EDGE_ROW_63_Left_202 VGND VGND VPWR VPWR sky130_fd_sc_hd__decap_3
XFILLER_111_636 VGND VGND VPWR VPWR sky130_fd_sc_hd__decap_4
XFILLER_111_614 VGND VGND VPWR VPWR sky130_fd_sc_hd__fill_2
X_12147_ _04825_ _04900_ _04901_ VGND VGND VPWR VPWR _04903_ sky130_fd_sc_hd__or3_2
XFILLER_2_793 VPWR VGND VPWR VGND sky130_ef_sc_hd__decap_12
X_12078_ net446 net392 VGND VGND VPWR VPWR _04828_ sky130_fd_sc_hd__nand2_1
XFILLER_2_65 VPWR VGND VPWR VGND sky130_ef_sc_hd__decap_12
X_11029_ _03505_ _03507_ _03685_ _03687_ VGND VGND VPWR VPWR _03688_ sky130_fd_sc_hd__o211a_1
XFILLER_65_756 VGND VGND VPWR VPWR sky130_fd_sc_hd__fill_1
XFILLER_37_447 VGND VGND VPWR VPWR sky130_fd_sc_hd__fill_1
XFILLER_92_553 VGND VGND VPWR VPWR sky130_fd_sc_hd__fill_1
XFILLER_25_609 VGND VGND VPWR VPWR sky130_fd_sc_hd__decap_4
XPHY_EDGE_ROW_72_Left_211 VGND VGND VPWR VPWR sky130_fd_sc_hd__decap_3
XTAP_TAPCELL_ROW_48_998 VGND VPWR sky130_fd_sc_hd__tapvpwrvgnd_1
XFILLER_45_480 VGND VGND VPWR VPWR sky130_fd_sc_hd__fill_1
XFILLER_60_450 VPWR VGND VPWR VGND sky130_ef_sc_hd__decap_12
XFILLER_32_141 VPWR VGND VPWR VGND sky130_ef_sc_hd__decap_12
X_08240_ _00584_ _00586_ _00712_ VGND VGND VPWR VPWR _00715_ sky130_fd_sc_hd__and3_1
XANTENNA_15 net333 VGND VGND VPWR VPWR sky130_fd_sc_hd__diode_2
XANTENNA_26 net482 VGND VGND VPWR VPWR sky130_fd_sc_hd__diode_2
X_08171_ net663 net417 _00646_ VGND VGND VPWR VPWR _00647_ sky130_fd_sc_hd__a21o_1
XFILLER_20_325 VGND VGND VPWR VPWR sky130_fd_sc_hd__fill_1
XFILLER_119_725 VGND VGND VPWR VPWR sky130_fd_sc_hd__decap_3
XTAP_TAPCELL_ROW_99_1731 VGND VPWR sky130_fd_sc_hd__tapvpwrvgnd_1
X_07122_ _04645_ _04656_ VGND VGND VPWR VPWR _04665_ sky130_fd_sc_hd__and2b_1
XFILLER_20_369 VPWR VGND VPWR VGND sky130_ef_sc_hd__decap_12
XFILLER_106_419 VGND VGND VPWR VPWR sky130_fd_sc_hd__fill_1
X_07053_ _01627_ _02030_ _02041_ _02074_ VGND VGND VPWR VPWR _03915_ sky130_fd_sc_hd__o2bb2ai_1
XPHY_EDGE_ROW_81_Left_220 VGND VGND VPWR VPWR sky130_fd_sc_hd__decap_3
Xoutput166 net166 VGND VGND VPWR VPWR y0[13] sky130_fd_sc_hd__buf_2
XFILLER_102_603 VGND VGND VPWR VPWR sky130_fd_sc_hd__decap_4
Xoutput177 net177 VGND VGND VPWR VPWR y0[8] sky130_fd_sc_hd__buf_2
Xoutput188 net188 VGND VGND VPWR VPWR y1[2] sky130_fd_sc_hd__buf_2
XFILLER_114_485 VGND VGND VPWR VPWR sky130_fd_sc_hd__decap_3
XFILLER_101_113 VPWR VGND VPWR VGND sky130_ef_sc_hd__decap_12
Xoutput199 net199 VGND VGND VPWR VPWR y2[12] sky130_fd_sc_hd__buf_2
XTAP_TAPCELL_ROW_52_1060 VGND VPWR sky130_fd_sc_hd__tapvpwrvgnd_1
X_07955_ _00331_ _00333_ _00430_ VGND VGND VPWR VPWR _00432_ sky130_fd_sc_hd__and3_1
XTAP_TAPCELL_ROW_126_2127 VGND VPWR sky130_fd_sc_hd__tapvpwrvgnd_1
X_06906_ _01846_ _02304_ VGND VGND VPWR VPWR _02315_ sky130_fd_sc_hd__and2_1
X_09625_ _02108_ _02158_ VGND VGND VPWR VPWR _02159_ sky130_fd_sc_hd__xnor2_2
X_07886_ _00335_ _00363_ VGND VGND VPWR VPWR _00364_ sky130_fd_sc_hd__xor2_2
XFILLER_55_233 VGND VGND VPWR VPWR sky130_fd_sc_hd__fill_2
XFILLER_46_27 VGND VGND VPWR VPWR sky130_fd_sc_hd__fill_1
XTAP_TAPCELL_ROW_108_1860 VGND VPWR sky130_fd_sc_hd__tapvpwrvgnd_1
X_06837_ net592 net106 VGND VGND VPWR VPWR _01562_ sky130_fd_sc_hd__nand2_1
XFILLER_55_277 VGND VGND VPWR VPWR sky130_fd_sc_hd__decap_3
X_09556_ net496 net344 _02082_ VGND VGND VPWR VPWR _02083_ sky130_fd_sc_hd__a21o_1
XTAP_TAPCELL_ROW_108_1871 VGND VPWR sky130_fd_sc_hd__tapvpwrvgnd_1
XFILLER_83_597 VGND VGND VPWR VPWR sky130_fd_sc_hd__decap_6
XFILLER_70_214 VGND VGND VPWR VPWR sky130_fd_sc_hd__fill_2
XFILLER_55_288 VGND VGND VPWR VPWR sky130_fd_sc_hd__fill_1
X_09487_ _01781_ _01840_ _01839_ VGND VGND VPWR VPWR _02008_ sky130_fd_sc_hd__o21ba_1
XFILLER_102_77 VGND VGND VPWR VPWR sky130_fd_sc_hd__decap_6
X_08507_ _00976_ _00977_ VGND VGND VPWR VPWR _00979_ sky130_fd_sc_hd__xnor2_1
XFILLER_24_642 VGND VGND VPWR VPWR sky130_fd_sc_hd__fill_2
X_08438_ _00813_ _00816_ _00814_ VGND VGND VPWR VPWR _00911_ sky130_fd_sc_hd__o21ai_1
XFILLER_23_141 VPWR VGND VPWR VGND sky130_ef_sc_hd__decap_12
XFILLER_109_202 VPWR VGND VPWR VGND sky130_ef_sc_hd__decap_12
X_08369_ _00823_ _00841_ VGND VGND VPWR VPWR _00843_ sky130_fd_sc_hd__xnor2_1
XFILLER_11_358 VPWR VGND VPWR VGND sky130_ef_sc_hd__decap_12
XTAP_TAPCELL_ROW_137_2289 VGND VPWR sky130_fd_sc_hd__tapvpwrvgnd_1
XFILLER_137_544 VGND VGND VPWR VPWR sky130_fd_sc_hd__decap_8
X_11380_ net474 net290 net288 net483 VGND VGND VPWR VPWR _04071_ sky130_fd_sc_hd__a22oi_1
X_10400_ _02985_ _02998_ _02999_ VGND VGND VPWR VPWR _03000_ sky130_fd_sc_hd__nand3_1
XFILLER_109_279 VGND VGND VPWR VPWR sky130_fd_sc_hd__fill_1
X_10331_ _02921_ _02923_ VGND VGND VPWR VPWR _02924_ sky130_fd_sc_hd__and2_1
X_13050_ _05774_ _05776_ _05888_ VGND VGND VPWR VPWR _05889_ sky130_fd_sc_hd__a21oi_2
X_10262_ _02809_ _02847_ VGND VGND VPWR VPWR _02849_ sky130_fd_sc_hd__xor2_1
X_12001_ _04695_ _04742_ VGND VGND VPWR VPWR _04744_ sky130_fd_sc_hd__or2_1
XFILLER_2_3 VPWR VGND VPWR VGND sky130_ef_sc_hd__decap_12
XFILLER_133_783 VGND VGND VPWR VPWR sky130_fd_sc_hd__fill_1
X_10193_ _02726_ _02727_ _02725_ VGND VGND VPWR VPWR _02777_ sky130_fd_sc_hd__a21oi_1
XFILLER_105_474 VGND VGND VPWR VPWR sky130_fd_sc_hd__decap_6
Xfanout360 net46 VGND VGND VPWR VPWR net360 sky130_fd_sc_hd__clkbuf_2
XFILLER_120_477 VGND VGND VPWR VPWR sky130_fd_sc_hd__decap_6
Xfanout371 net39 VGND VGND VPWR VPWR net371 sky130_fd_sc_hd__clkbuf_2
Xfanout382 net32 VGND VGND VPWR VPWR net382 sky130_fd_sc_hd__dlymetal6s2s_1
Xfanout393 net26 VGND VGND VPWR VPWR net393 sky130_fd_sc_hd__clkbuf_4
XFILLER_59_561 VGND VGND VPWR VPWR sky130_fd_sc_hd__fill_2
XTAP_TAPCELL_ROW_6_384 VGND VPWR sky130_fd_sc_hd__tapvpwrvgnd_1
X_12903_ _05560_ _05562_ _05727_ VGND VGND VPWR VPWR _05729_ sky130_fd_sc_hd__a21oi_1
XFILLER_47_734 VPWR VGND VPWR VGND sky130_ef_sc_hd__decap_12
XFILLER_19_469 VGND VGND VPWR VPWR sky130_fd_sc_hd__decap_4
X_12834_ _05650_ _05651_ VGND VGND VPWR VPWR _05653_ sky130_fd_sc_hd__and2b_1
XFILLER_62_748 VGND VGND VPWR VPWR sky130_fd_sc_hd__fill_2
XFILLER_61_225 VPWR VGND VPWR VGND sky130_ef_sc_hd__decap_12
XTAP_TAPCELL_ROW_45_946 VGND VPWR sky130_fd_sc_hd__tapvpwrvgnd_1
X_12765_ _05452_ _05487_ _05486_ VGND VGND VPWR VPWR _05577_ sky130_fd_sc_hd__a21o_1
XTAP_TAPCELL_ROW_45_957 VGND VPWR sky130_fd_sc_hd__tapvpwrvgnd_1
XFILLER_70_781 VPWR VGND VPWR VGND sky130_ef_sc_hd__decap_12
XFILLER_14_141 VGND VGND VPWR VPWR sky130_fd_sc_hd__decap_4
X_11716_ _03455_ _04435_ VGND VGND VPWR VPWR _04436_ sky130_fd_sc_hd__nand2_1
XFILLER_30_601 VPWR VGND VPWR VGND sky130_ef_sc_hd__decap_12
X_12696_ _05500_ _05501_ _05502_ VGND VGND VPWR VPWR _05503_ sky130_fd_sc_hd__nand3_1
XFILLER_14_174 VGND VGND VPWR VPWR sky130_fd_sc_hd__decap_8
Xinput13 w01[3] VGND VGND VPWR VPWR net13 sky130_fd_sc_hd__buf_1
X_11647_ _04245_ _04257_ _04244_ VGND VGND VPWR VPWR _04361_ sky130_fd_sc_hd__o21a_1
Xinput46 w11[4] VGND VGND VPWR VPWR net46 sky130_fd_sc_hd__clkbuf_1
Xinput35 w10[1] VGND VGND VPWR VPWR net35 sky130_fd_sc_hd__buf_1
Xinput24 w02[6] VGND VGND VPWR VPWR net24 sky130_fd_sc_hd__buf_2
X_11578_ _04283_ _04284_ VGND VGND VPWR VPWR _04287_ sky130_fd_sc_hd__xor2_1
Xinput57 w12[7] VGND VGND VPWR VPWR net57 sky130_fd_sc_hd__clkbuf_1
XFILLER_128_566 VGND VGND VPWR VPWR sky130_fd_sc_hd__fill_1
X_13317_ net548 _00436_ _06043_ net408 VGND VGND VPWR VPWR _06180_ sky130_fd_sc_hd__o211ai_2
Xinput79 w21[5] VGND VGND VPWR VPWR net79 sky130_fd_sc_hd__buf_1
Xinput68 w20[2] VGND VGND VPWR VPWR net68 sky130_fd_sc_hd__clkbuf_2
X_10529_ _03137_ _03138_ _03140_ VGND VGND VPWR VPWR _03141_ sky130_fd_sc_hd__or3_1
XFILLER_115_249 VPWR VGND VPWR VGND sky130_ef_sc_hd__decap_12
XFILLER_6_384 VGND VGND VPWR VPWR sky130_fd_sc_hd__decap_8
XFILLER_108_290 VPWR VGND VPWR VGND sky130_ef_sc_hd__decap_12
XTAP_TAPCELL_ROW_94_1661 VGND VPWR sky130_fd_sc_hd__tapvpwrvgnd_1
X_13248_ _05844_ _06104_ VGND VGND VPWR VPWR _06106_ sky130_fd_sc_hd__xor2_1
XFILLER_124_794 VPWR VGND VPWR VGND sky130_ef_sc_hd__decap_12
X_13179_ _05750_ _05910_ _05909_ VGND VGND VPWR VPWR _06030_ sky130_fd_sc_hd__a21oi_1
XFILLER_97_634 VGND VGND VPWR VPWR sky130_fd_sc_hd__fill_1
XFILLER_69_325 VGND VGND VPWR VPWR sky130_fd_sc_hd__decap_8
XFILLER_35_3 VPWR VGND VPWR VGND sky130_ef_sc_hd__decap_12
XFILLER_96_122 VGND VGND VPWR VPWR sky130_fd_sc_hd__decap_4
XFILLER_69_358 VGND VGND VPWR VPWR sky130_fd_sc_hd__decap_4
X_07740_ _00215_ _00216_ VGND VGND VPWR VPWR _00219_ sky130_fd_sc_hd__xnor2_1
XFILLER_38_723 VGND VGND VPWR VPWR sky130_fd_sc_hd__decap_6
XFILLER_111_499 VGND VGND VPWR VPWR sky130_fd_sc_hd__decap_4
XFILLER_92_361 VGND VGND VPWR VPWR sky130_fd_sc_hd__decap_3
X_07671_ _06757_ _06777_ _06776_ VGND VGND VPWR VPWR _00150_ sky130_fd_sc_hd__a21bo_1
XFILLER_38_767 VPWR VGND VPWR VGND sky130_ef_sc_hd__decap_12
X_09410_ _01921_ _01922_ _01923_ VGND VGND VPWR VPWR _01924_ sky130_fd_sc_hd__a21bo_1
XFILLER_52_203 VPWR VGND VPWR VGND sky130_ef_sc_hd__decap_12
XFILLER_37_299 VGND VGND VPWR VPWR sky130_fd_sc_hd__fill_1
X_09341_ _01690_ _01848_ _01849_ VGND VGND VPWR VPWR _01850_ sky130_fd_sc_hd__nand3_1
XTAP_TAPCELL_ROW_121_2057 VGND VPWR sky130_fd_sc_hd__tapvpwrvgnd_1
XTAP_TAPCELL_ROW_23_629 VGND VPWR sky130_fd_sc_hd__tapvpwrvgnd_1
X_09272_ _01595_ _01597_ VGND VGND VPWR VPWR _01774_ sky130_fd_sc_hd__and2b_1
XTAP_TAPCELL_ROW_103_1790 VGND VPWR sky130_fd_sc_hd__tapvpwrvgnd_1
XFILLER_32_29 VPWR VGND VPWR VGND sky130_ef_sc_hd__decap_12
X_08223_ _00567_ _00570_ _00697_ VGND VGND VPWR VPWR _00698_ sky130_fd_sc_hd__nor3_1
X_08154_ net705 net603 net261 net706 VGND VGND VPWR VPWR _00630_ sky130_fd_sc_hd__o2bb2a_1
X_08085_ _00498_ _00500_ VGND VGND VPWR VPWR _00561_ sky130_fd_sc_hd__nor2_1
X_07105_ _04460_ _04471_ VGND VGND VPWR VPWR _04482_ sky130_fd_sc_hd__xnor2_1
XFILLER_119_599 VPWR VGND VPWR VGND sky130_ef_sc_hd__decap_12
X_07036_ _03718_ VGND VGND VPWR VPWR _03729_ sky130_fd_sc_hd__inv_2
XFILLER_121_219 VGND VGND VPWR VPWR sky130_fd_sc_hd__decap_4
XFILLER_0_505 VGND VGND VPWR VPWR sky130_fd_sc_hd__fill_2
XFILLER_102_433 VPWR VGND VPWR VGND sky130_ef_sc_hd__decap_12
XFILLER_57_15 VPWR VGND VPWR VGND sky130_ef_sc_hd__decap_12
XTAP_TAPCELL_ROW_50_1019 VGND VPWR sky130_fd_sc_hd__tapvpwrvgnd_1
X_08987_ net607 net377 net330 net472 VGND VGND VPWR VPWR _01463_ sky130_fd_sc_hd__a22oi_1
XFILLER_102_477 VPWR VGND VPWR VGND sky130_ef_sc_hd__decap_12
XFILLER_87_177 VPWR VGND VPWR VGND sky130_ef_sc_hd__decap_12
XFILLER_56_531 VGND VGND VPWR VPWR sky130_fd_sc_hd__fill_1
X_07938_ _00189_ _00278_ _00277_ VGND VGND VPWR VPWR _00416_ sky130_fd_sc_hd__a21oi_2
XTAP_TAPCELL_ROW_3_343 VGND VPWR sky130_fd_sc_hd__tapvpwrvgnd_1
XFILLER_90_309 VGND VGND VPWR VPWR sky130_fd_sc_hd__fill_1
XFILLER_71_501 VGND VGND VPWR VPWR sky130_fd_sc_hd__decap_3
XFILLER_56_564 VPWR VGND VPWR VGND sky130_ef_sc_hd__decap_12
X_07869_ _00345_ _00346_ VGND VGND VPWR VPWR _00347_ sky130_fd_sc_hd__nor2_1
XFILLER_113_98 VGND VGND VPWR VPWR sky130_fd_sc_hd__fill_1
X_09608_ net629 net620 net368 net367 VGND VGND VPWR VPWR _02141_ sky130_fd_sc_hd__and4_1
XFILLER_56_586 VGND VGND VPWR VPWR sky130_fd_sc_hd__fill_2
XFILLER_43_225 VGND VGND VPWR VPWR sky130_fd_sc_hd__decap_8
X_10880_ _03362_ _03524_ VGND VGND VPWR VPWR _03525_ sky130_fd_sc_hd__xnor2_1
XFILLER_28_277 VPWR VGND VPWR VGND sky130_ef_sc_hd__decap_12
X_09539_ _02054_ _02064_ VGND VGND VPWR VPWR _02065_ sky130_fd_sc_hd__xnor2_1
XFILLER_73_69 VGND VGND VPWR VPWR sky130_fd_sc_hd__decap_4
XTAP_TAPCELL_ROW_65_1240 VGND VPWR sky130_fd_sc_hd__tapvpwrvgnd_1
XFILLER_43_247 VPWR VGND VPWR VGND sky130_ef_sc_hd__decap_12
XTAP_TAPCELL_ROW_42_905 VGND VPWR sky130_fd_sc_hd__tapvpwrvgnd_1
XFILLER_12_601 VGND VGND VPWR VPWR sky130_fd_sc_hd__decap_3
X_12550_ _05338_ _05342_ _05343_ VGND VGND VPWR VPWR _05344_ sky130_fd_sc_hd__and3_1
XFILLER_11_111 VGND VGND VPWR VPWR sky130_fd_sc_hd__fill_1
XFILLER_12_645 VGND VGND VPWR VPWR sky130_fd_sc_hd__decap_8
X_12481_ _05263_ _05265_ VGND VGND VPWR VPWR _05268_ sky130_fd_sc_hd__xor2_1
X_11501_ _04200_ _04201_ VGND VGND VPWR VPWR _04203_ sky130_fd_sc_hd__xor2_1
X_11432_ net609 net317 _03984_ _03983_ VGND VGND VPWR VPWR _04128_ sky130_fd_sc_hd__a31o_1
XFILLER_137_363 VGND VGND VPWR VPWR sky130_fd_sc_hd__fill_1
XFILLER_4_811 VGND VGND VPWR VPWR sky130_fd_sc_hd__fill_1
XFILLER_125_547 VGND VGND VPWR VPWR sky130_fd_sc_hd__decap_3
X_13102_ net495 _05628_ VGND VGND VPWR VPWR _05946_ sky130_fd_sc_hd__nand2_2
X_11363_ _03901_ _04051_ VGND VGND VPWR VPWR _04052_ sky130_fd_sc_hd__nand2b_1
XFILLER_98_77 VGND VGND VPWR VPWR sky130_fd_sc_hd__decap_6
X_10314_ _02904_ VGND VGND VPWR VPWR _02905_ sky130_fd_sc_hd__inv_2
X_11294_ _03457_ _03975_ VGND VGND VPWR VPWR _03977_ sky130_fd_sc_hd__xnor2_1
X_13033_ _05868_ _05869_ VGND VGND VPWR VPWR _05871_ sky130_fd_sc_hd__xor2_1
X_10245_ _02828_ _02829_ _02826_ VGND VGND VPWR VPWR _02831_ sky130_fd_sc_hd__o21ai_1
X_10176_ _02757_ _02758_ VGND VGND VPWR VPWR _00060_ sky130_fd_sc_hd__xnor2_1
XFILLER_79_667 VGND VGND VPWR VPWR sky130_fd_sc_hd__decap_4
XFILLER_121_797 VPWR VGND VPWR VGND sky130_ef_sc_hd__decap_12
XFILLER_93_103 VGND VGND VPWR VPWR sky130_fd_sc_hd__fill_1
XFILLER_93_136 VGND VGND VPWR VPWR sky130_fd_sc_hd__decap_3
XFILLER_59_391 VGND VGND VPWR VPWR sky130_fd_sc_hd__fill_1
XFILLER_93_169 VGND VGND VPWR VPWR sky130_fd_sc_hd__decap_6
XFILLER_47_597 VPWR VGND VPWR VGND sky130_ef_sc_hd__decap_12
XFILLER_35_748 VPWR VGND VPWR VGND sky130_ef_sc_hd__decap_12
X_12817_ _05630_ _05632_ net495 net397 VGND VGND VPWR VPWR _05634_ sky130_fd_sc_hd__nand4b_1
XFILLER_74_394 VPWR VGND VPWR VGND sky130_ef_sc_hd__decap_12
XFILLER_62_589 VPWR VGND VPWR VGND sky130_ef_sc_hd__decap_12
XFILLER_62_578 VGND VGND VPWR VPWR sky130_fd_sc_hd__fill_1
XFILLER_15_461 VPWR VGND VPWR VGND sky130_ef_sc_hd__decap_12
X_12748_ _05558_ VGND VGND VPWR VPWR _05560_ sky130_fd_sc_hd__inv_2
XFILLER_63_91 VGND VGND VPWR VPWR sky130_fd_sc_hd__decap_8
XFILLER_42_291 VPWR VGND VPWR VGND sky130_ef_sc_hd__decap_12
X_12679_ _05469_ _05484_ VGND VGND VPWR VPWR _05485_ sky130_fd_sc_hd__xnor2_1
XFILLER_30_442 VGND VGND VPWR VPWR sky130_fd_sc_hd__decap_8
XFILLER_8_53 VPWR VGND VPWR VGND sky130_ef_sc_hd__decap_12
XFILLER_128_385 VGND VGND VPWR VPWR sky130_fd_sc_hd__decap_4
XFILLER_7_693 VGND VGND VPWR VPWR sky130_fd_sc_hd__fill_1
X_09890_ _02175_ _02318_ VGND VGND VPWR VPWR _02448_ sky130_fd_sc_hd__nand2b_1
X_08910_ net541 net366 _01377_ VGND VGND VPWR VPWR _01379_ sky130_fd_sc_hd__nand3_1
XFILLER_131_517 VPWR VGND VPWR VGND sky130_ef_sc_hd__decap_12
X_08841_ _01305_ _01306_ VGND VGND VPWR VPWR _01307_ sky130_fd_sc_hd__nor2_1
X_08772_ _01235_ _01237_ VGND VGND VPWR VPWR _01239_ sky130_fd_sc_hd__xnor2_2
XFILLER_111_285 VGND VGND VPWR VPWR sky130_fd_sc_hd__fill_1
XFILLER_97_497 VGND VGND VPWR VPWR sky130_fd_sc_hd__decap_6
XFILLER_84_158 VGND VGND VPWR VPWR sky130_fd_sc_hd__decap_6
XFILLER_72_309 VGND VGND VPWR VPWR sky130_fd_sc_hd__decap_6
X_07723_ _00198_ _00200_ net493 net681 VGND VGND VPWR VPWR _00202_ sky130_fd_sc_hd__nand4b_1
XTAP_TAPCELL_ROW_0_302 VGND VPWR sky130_fd_sc_hd__tapvpwrvgnd_1
X_07654_ _00131_ _00132_ _06733_ VGND VGND VPWR VPWR _00134_ sky130_fd_sc_hd__a21o_1
XFILLER_25_225 VPWR VGND VPWR VGND sky130_ef_sc_hd__decap_12
X_07585_ _06783_ _06813_ VGND VGND VPWR VPWR _06814_ sky130_fd_sc_hd__and2b_1
XFILLER_53_589 VGND VGND VPWR VPWR sky130_fd_sc_hd__decap_4
XFILLER_41_729 VGND VGND VPWR VPWR sky130_fd_sc_hd__fill_1
X_09324_ _01827_ _01828_ _01829_ VGND VGND VPWR VPWR _01831_ sky130_fd_sc_hd__a21o_1
XFILLER_43_39 VPWR VGND VPWR VGND sky130_ef_sc_hd__decap_12
XFILLER_34_781 VPWR VGND VPWR VGND sky130_ef_sc_hd__decap_12
X_09255_ _01753_ _01754_ VGND VGND VPWR VPWR _01755_ sky130_fd_sc_hd__and2b_1
XTAP_TAPCELL_ROW_60_1170 VGND VPWR sky130_fd_sc_hd__tapvpwrvgnd_1
X_08206_ _00429_ _00553_ _00681_ VGND VGND VPWR VPWR _00682_ sky130_fd_sc_hd__a21o_1
XTAP_TAPCELL_ROW_134_2248 VGND VPWR sky130_fd_sc_hd__tapvpwrvgnd_1
XTAP_TAPCELL_ROW_134_2237 VGND VPWR sky130_fd_sc_hd__tapvpwrvgnd_1
X_09186_ _01504_ _01506_ _01679_ VGND VGND VPWR VPWR _01680_ sky130_fd_sc_hd__a21oi_1
X_08137_ _00606_ _00612_ VGND VGND VPWR VPWR _00613_ sky130_fd_sc_hd__xnor2_1
XFILLER_134_333 VPWR VGND VPWR VGND sky130_ef_sc_hd__decap_12
X_08068_ _00469_ _00544_ VGND VGND VPWR VPWR _00545_ sky130_fd_sc_hd__xnor2_2
XTAP_TAPCELL_ROW_116_1981 VGND VPWR sky130_fd_sc_hd__tapvpwrvgnd_1
XFILLER_108_65 VPWR VGND VPWR VGND sky130_ef_sc_hd__decap_12
X_07019_ net98 net638 _01954_ _01943_ VGND VGND VPWR VPWR _03543_ sky130_fd_sc_hd__a31o_1
XTAP_TAPCELL_ROW_8_413 VGND VPWR sky130_fd_sc_hd__tapvpwrvgnd_1
X_10030_ _02515_ _02598_ VGND VGND VPWR VPWR _02600_ sky130_fd_sc_hd__xor2_1
XFILLER_103_753 VPWR VGND VPWR VGND sky130_ef_sc_hd__decap_12
XFILLER_102_241 VGND VGND VPWR VPWR sky130_fd_sc_hd__decap_8
XFILLER_88_486 VGND VGND VPWR VPWR sky130_fd_sc_hd__fill_1
XFILLER_88_475 VGND VGND VPWR VPWR sky130_fd_sc_hd__fill_1
XFILLER_75_103 VGND VGND VPWR VPWR sky130_fd_sc_hd__fill_2
XFILLER_0_379 VGND VGND VPWR VPWR sky130_fd_sc_hd__fill_2
XFILLER_124_53 VPWR VGND VPWR VGND sky130_ef_sc_hd__decap_12
XFILLER_103_797 VPWR VGND VPWR VGND sky130_ef_sc_hd__decap_12
XFILLER_102_296 VPWR VGND VPWR VGND sky130_ef_sc_hd__decap_12
XFILLER_75_125 VGND VGND VPWR VPWR sky130_fd_sc_hd__fill_1
XFILLER_124_97 VPWR VGND VPWR VGND sky130_ef_sc_hd__decap_12
X_11981_ _04720_ _04721_ VGND VGND VPWR VPWR _04722_ sky130_fd_sc_hd__or2_1
XFILLER_75_147 VPWR VGND VPWR VGND sky130_ef_sc_hd__decap_12
XFILLER_91_629 VPWR VGND VPWR VGND sky130_ef_sc_hd__decap_12
XFILLER_90_117 VGND VGND VPWR VPWR sky130_fd_sc_hd__fill_2
XFILLER_56_372 VGND VGND VPWR VPWR sky130_fd_sc_hd__decap_4
X_10932_ _03568_ _03580_ VGND VGND VPWR VPWR _03581_ sky130_fd_sc_hd__nand2_1
XFILLER_29_597 VPWR VGND VPWR VGND sky130_ef_sc_hd__decap_12
XFILLER_17_51 VGND VGND VPWR VPWR sky130_fd_sc_hd__decap_4
XFILLER_17_73 VGND VGND VPWR VPWR sky130_fd_sc_hd__fill_1
X_13651_ clknet_3_7__leaf_clk _00009_ net717 VGND VGND VPWR VPWR net179 sky130_fd_sc_hd__dfrtp_1
XFILLER_44_589 VGND VGND VPWR VPWR sky130_fd_sc_hd__decap_6
XFILLER_25_770 VPWR VGND VPWR VGND sky130_ef_sc_hd__decap_12
X_10863_ _03503_ _03504_ VGND VGND VPWR VPWR _03506_ sky130_fd_sc_hd__xnor2_1
X_12602_ net556 net660 _05235_ _05234_ VGND VGND VPWR VPWR _05400_ sky130_fd_sc_hd__a31oi_1
X_13582_ _06386_ _06388_ _06469_ VGND VGND VPWR VPWR _06470_ sky130_fd_sc_hd__a21oi_1
X_10794_ _03428_ _03429_ VGND VGND VPWR VPWR _03430_ sky130_fd_sc_hd__nand2_1
XFILLER_129_105 VGND VGND VPWR VPWR sky130_fd_sc_hd__decap_6
X_12533_ net615 net607 net386 net369 VGND VGND VPWR VPWR _05325_ sky130_fd_sc_hd__nand4_1
XFILLER_138_650 VGND VGND VPWR VPWR sky130_fd_sc_hd__decap_4
X_12464_ _05081_ _05084_ _05247_ VGND VGND VPWR VPWR _05249_ sky130_fd_sc_hd__nand3_1
XFILLER_138_694 VGND VGND VPWR VPWR sky130_fd_sc_hd__fill_2
XTAP_TAPCELL_ROW_78_1431 VGND VPWR sky130_fd_sc_hd__tapvpwrvgnd_1
X_12395_ net633 net624 net4 net353 VGND VGND VPWR VPWR _05174_ sky130_fd_sc_hd__and4_1
X_11415_ net415 net274 VGND VGND VPWR VPWR _04109_ sky130_fd_sc_hd__nand2_1
XFILLER_4_630 VPWR VGND VPWR VGND sky130_ef_sc_hd__decap_12
X_11346_ _03881_ _03885_ _04031_ VGND VGND VPWR VPWR _04033_ sky130_fd_sc_hd__or3_1
XTAP_TAPCELL_ROW_91_1620 VGND VPWR sky130_fd_sc_hd__tapvpwrvgnd_1
XFILLER_4_663 VGND VGND VPWR VPWR sky130_fd_sc_hd__decap_4
X_13016_ _05850_ _05851_ VGND VGND VPWR VPWR _05852_ sky130_fd_sc_hd__and2b_1
X_11277_ _03956_ _03957_ VGND VGND VPWR VPWR _03958_ sky130_fd_sc_hd__xnor2_1
XFILLER_121_561 VGND VGND VPWR VPWR sky130_fd_sc_hd__decap_4
X_10228_ _02797_ _02810_ VGND VGND VPWR VPWR _02813_ sky130_fd_sc_hd__xnor2_1
X_10159_ _02740_ _02738_ VGND VGND VPWR VPWR _02741_ sky130_fd_sc_hd__and2b_1
XFILLER_94_445 VGND VGND VPWR VPWR sky130_fd_sc_hd__fill_2
XFILLER_66_136 VGND VGND VPWR VPWR sky130_fd_sc_hd__fill_1
XFILLER_66_169 VGND VGND VPWR VPWR sky130_fd_sc_hd__fill_1
XFILLER_54_309 VGND VGND VPWR VPWR sky130_fd_sc_hd__decap_3
XFILLER_94_489 VPWR VGND VPWR VGND sky130_ef_sc_hd__decap_12
XTAP_TAPCELL_ROW_89_1593 VGND VPWR sky130_fd_sc_hd__tapvpwrvgnd_1
XFILLER_81_128 VGND VGND VPWR VPWR sky130_fd_sc_hd__decap_6
XFILLER_75_681 VGND VGND VPWR VPWR sky130_fd_sc_hd__fill_1
XFILLER_75_670 VGND VGND VPWR VPWR sky130_fd_sc_hd__fill_2
XFILLER_47_361 VGND VGND VPWR VPWR sky130_fd_sc_hd__decap_8
XFILLER_62_331 VGND VGND VPWR VPWR sky130_fd_sc_hd__decap_6
XFILLER_62_353 VGND VGND VPWR VPWR sky130_fd_sc_hd__fill_1
X_07370_ _06598_ _06599_ VGND VGND VPWR VPWR _06600_ sky130_fd_sc_hd__nand2_1
XTAP_TAPCELL_ROW_33_779 VGND VPWR sky130_fd_sc_hd__tapvpwrvgnd_1
X_09040_ _01434_ _01436_ VGND VGND VPWR VPWR _01521_ sky130_fd_sc_hd__nor2_1
XFILLER_30_250 VGND VGND VPWR VPWR sky130_fd_sc_hd__fill_2
XTAP_TAPCELL_ROW_13_481 VGND VPWR sky130_fd_sc_hd__tapvpwrvgnd_1
XTAP_TAPCELL_ROW_13_492 VGND VPWR sky130_fd_sc_hd__tapvpwrvgnd_1
XFILLER_128_160 VPWR VGND VPWR VGND sky130_ef_sc_hd__decap_12
XFILLER_7_490 VGND VGND VPWR VPWR sky130_fd_sc_hd__decap_3
XFILLER_131_303 VGND VGND VPWR VPWR sky130_fd_sc_hd__decap_8
XFILLER_116_377 VPWR VGND VPWR VGND sky130_ef_sc_hd__decap_12
X_09942_ _02496_ _02502_ VGND VGND VPWR VPWR _02504_ sky130_fd_sc_hd__xor2_1
XFILLER_104_539 VGND VGND VPWR VPWR sky130_fd_sc_hd__decap_4
X_09873_ _02427_ _02428_ VGND VGND VPWR VPWR _02429_ sky130_fd_sc_hd__nand2b_1
XFILLER_100_701 VGND VGND VPWR VPWR sky130_fd_sc_hd__decap_8
XFILLER_97_261 VPWR VGND VPWR VGND sky130_ef_sc_hd__decap_12
X_08824_ _01289_ _01283_ VGND VGND VPWR VPWR _01290_ sky130_fd_sc_hd__nand2b_1
X_08755_ _01217_ net238 _01213_ _01214_ VGND VGND VPWR VPWR _01222_ sky130_fd_sc_hd__o211ai_4
XFILLER_57_169 VPWR VGND VPWR VGND sky130_ef_sc_hd__decap_12
XFILLER_73_629 VGND VGND VPWR VPWR sky130_fd_sc_hd__decap_8
XTAP_TAPCELL_ROW_49_1010 VGND VPWR sky130_fd_sc_hd__tapvpwrvgnd_1
X_07706_ _00168_ _00184_ VGND VGND VPWR VPWR _00185_ sky130_fd_sc_hd__xnor2_1
XFILLER_38_350 VGND VGND VPWR VPWR sky130_fd_sc_hd__fill_1
XFILLER_38_372 VGND VGND VPWR VPWR sky130_fd_sc_hd__decap_6
X_08686_ net447 net58 _01151_ _01149_ VGND VGND VPWR VPWR _01153_ sky130_fd_sc_hd__a31o_1
XFILLER_66_692 VGND VGND VPWR VPWR sky130_fd_sc_hd__decap_8
XFILLER_54_27 VGND VGND VPWR VPWR sky130_fd_sc_hd__fill_1
XFILLER_81_673 VGND VGND VPWR VPWR sky130_fd_sc_hd__decap_4
XFILLER_80_161 VGND VGND VPWR VPWR sky130_fd_sc_hd__fill_1
X_07637_ _00114_ _00115_ _00097_ VGND VGND VPWR VPWR _00117_ sky130_fd_sc_hd__a21o_1
XFILLER_80_194 VGND VGND VPWR VPWR sky130_fd_sc_hd__fill_2
X_07568_ _06788_ _06796_ VGND VGND VPWR VPWR _06797_ sky130_fd_sc_hd__xnor2_1
XFILLER_41_548 VPWR VGND VPWR VGND sky130_ef_sc_hd__decap_12
XFILLER_110_77 VGND VGND VPWR VPWR sky130_fd_sc_hd__decap_6
X_09307_ _01806_ _01810_ VGND VGND VPWR VPWR _01812_ sky130_fd_sc_hd__xnor2_1
XFILLER_22_762 VPWR VGND VPWR VGND sky130_ef_sc_hd__decap_12
X_07499_ _06569_ _06572_ _06568_ VGND VGND VPWR VPWR _06729_ sky130_fd_sc_hd__a21o_1
XFILLER_21_272 VGND VGND VPWR VPWR sky130_fd_sc_hd__decap_8
XFILLER_127_609 VGND VGND VPWR VPWR sky130_fd_sc_hd__decap_6
X_09238_ _01393_ _01558_ _01557_ VGND VGND VPWR VPWR _01737_ sky130_fd_sc_hd__o21a_1
X_09169_ _01632_ _01661_ VGND VGND VPWR VPWR _01662_ sky130_fd_sc_hd__and2_1
XFILLER_107_311 VGND VGND VPWR VPWR sky130_fd_sc_hd__fill_1
XFILLER_5_405 VGND VGND VPWR VPWR sky130_fd_sc_hd__fill_1
XFILLER_134_141 VPWR VGND VPWR VGND sky130_ef_sc_hd__decap_12
XFILLER_107_355 VPWR VGND VPWR VGND sky130_ef_sc_hd__decap_12
X_12180_ _04701_ _04752_ _04938_ _04936_ VGND VGND VPWR VPWR _04940_ sky130_fd_sc_hd__a31o_1
XFILLER_5_449 VGND VGND VPWR VPWR sky130_fd_sc_hd__fill_1
X_11200_ _03548_ _03737_ _03736_ VGND VGND VPWR VPWR _03874_ sky130_fd_sc_hd__o21a_1
XFILLER_79_57 VGND VGND VPWR VPWR sky130_fd_sc_hd__decap_6
X_11131_ _03764_ _03797_ VGND VGND VPWR VPWR _03799_ sky130_fd_sc_hd__xnor2_1
XFILLER_122_325 VPWR VGND VPWR VGND sky130_ef_sc_hd__decap_12
XFILLER_0_110 VGND VGND VPWR VPWR sky130_fd_sc_hd__fill_2
XFILLER_103_561 VPWR VGND VPWR VGND sky130_ef_sc_hd__decap_12
XTAP_TAPCELL_ROW_73_1361 VGND VPWR sky130_fd_sc_hd__tapvpwrvgnd_1
X_11062_ _03721_ _03722_ VGND VGND VPWR VPWR _03723_ sky130_fd_sc_hd__nor2_1
X_10013_ net262 net367 _02497_ VGND VGND VPWR VPWR _02581_ sky130_fd_sc_hd__o21ai_1
XFILLER_76_412 VGND VGND VPWR VPWR sky130_fd_sc_hd__decap_8
XFILLER_1_699 VGND VGND VPWR VPWR sky130_fd_sc_hd__fill_1
XFILLER_36_309 VGND VGND VPWR VPWR sky130_fd_sc_hd__fill_1
XFILLER_76_489 VPWR VGND VPWR VGND sky130_ef_sc_hd__decap_12
XFILLER_57_681 VGND VGND VPWR VPWR sky130_fd_sc_hd__fill_1
XFILLER_28_83 VGND VGND VPWR VPWR sky130_fd_sc_hd__fill_1
XFILLER_29_361 VGND VGND VPWR VPWR sky130_fd_sc_hd__fill_1
X_11964_ net640 net405 VGND VGND VPWR VPWR _04703_ sky130_fd_sc_hd__nand2_1
XFILLER_72_651 VPWR VGND VPWR VGND sky130_ef_sc_hd__decap_12
XFILLER_60_813 VGND VGND VPWR VPWR sky130_fd_sc_hd__decap_6
X_11895_ _04586_ _04630_ VGND VGND VPWR VPWR _04631_ sky130_fd_sc_hd__xnor2_1
X_10915_ _03376_ _03385_ _03384_ VGND VGND VPWR VPWR _03562_ sky130_fd_sc_hd__a21bo_1
XFILLER_32_515 VGND VGND VPWR VPWR sky130_fd_sc_hd__decap_8
X_13634_ clknet_3_6__leaf_clk _00003_ net716 VGND VGND VPWR VPWR net162 sky130_fd_sc_hd__dfrtp_1
X_10846_ _03307_ _03486_ VGND VGND VPWR VPWR _03487_ sky130_fd_sc_hd__xnor2_1
XFILLER_13_751 VPWR VGND VPWR VGND sky130_ef_sc_hd__decap_12
X_13565_ _06447_ _06450_ VGND VGND VPWR VPWR _06451_ sky130_fd_sc_hd__and2b_1
X_10777_ _03364_ _03409_ VGND VGND VPWR VPWR _03411_ sky130_fd_sc_hd__xnor2_1
XTAP_TAPCELL_ROW_30_727 VGND VPWR sky130_fd_sc_hd__tapvpwrvgnd_1
XTAP_TAPCELL_ROW_30_738 VGND VPWR sky130_fd_sc_hd__tapvpwrvgnd_1
X_13496_ _05945_ _06257_ _06374_ VGND VGND VPWR VPWR _06376_ sky130_fd_sc_hd__nor3_1
X_12516_ _05303_ _05305_ VGND VGND VPWR VPWR _05306_ sky130_fd_sc_hd__nand2_1
XFILLER_9_755 VPWR VGND VPWR VGND sky130_ef_sc_hd__decap_12
X_12447_ net266 net711 VGND VGND VPWR VPWR _05230_ sky130_fd_sc_hd__nor2_1
XFILLER_8_265 VPWR VGND VPWR VGND sky130_ef_sc_hd__decap_12
XTAP_TAPCELL_ROW_10_440 VGND VPWR sky130_fd_sc_hd__tapvpwrvgnd_1
XTAP_TAPCELL_ROW_10_451 VGND VPWR sky130_fd_sc_hd__tapvpwrvgnd_1
XFILLER_126_642 VGND VGND VPWR VPWR sky130_fd_sc_hd__fill_2
XFILLER_126_697 VGND VGND VPWR VPWR sky130_fd_sc_hd__decap_3
XFILLER_113_314 VGND VGND VPWR VPWR sky130_fd_sc_hd__fill_1
X_12378_ _05152_ _05153_ _05150_ VGND VGND VPWR VPWR _05156_ sky130_fd_sc_hd__o21ai_1
X_11329_ _03873_ _04013_ VGND VGND VPWR VPWR _04016_ sky130_fd_sc_hd__xnor2_1
XFILLER_86_209 VPWR VGND VPWR VGND sky130_ef_sc_hd__decap_12
X_06870_ _01900_ _01911_ VGND VGND VPWR VPWR _00007_ sky130_fd_sc_hd__nor2_1
XFILLER_121_391 VGND VGND VPWR VPWR sky130_fd_sc_hd__fill_1
XFILLER_95_754 VGND VGND VPWR VPWR sky130_fd_sc_hd__decap_8
XFILLER_94_253 VGND VGND VPWR VPWR sky130_fd_sc_hd__decap_6
XFILLER_55_629 VPWR VGND VPWR VGND sky130_ef_sc_hd__decap_12
XFILLER_48_681 VGND VGND VPWR VPWR sky130_fd_sc_hd__decap_4
XFILLER_36_821 VGND VGND VPWR VPWR sky130_fd_sc_hd__decap_3
XFILLER_39_169 VPWR VGND VPWR VGND sky130_ef_sc_hd__decap_12
X_08540_ net471 net339 _01007_ VGND VGND VPWR VPWR _01009_ sky130_fd_sc_hd__and3_1
XTAP_TAPCELL_ROW_38_849 VGND VPWR sky130_fd_sc_hd__tapvpwrvgnd_1
XTAP_TAPCELL_ROW_18_562 VGND VPWR sky130_fd_sc_hd__tapvpwrvgnd_1
X_08471_ _00924_ _00942_ VGND VGND VPWR VPWR _00944_ sky130_fd_sc_hd__xnor2_1
X_07422_ _06639_ _06650_ _06651_ VGND VGND VPWR VPWR _06652_ sky130_fd_sc_hd__nand3_1
XTAP_TAPCELL_ROW_118_2007 VGND VPWR sky130_fd_sc_hd__tapvpwrvgnd_1
X_07353_ _06582_ VGND VGND VPWR VPWR _06583_ sky130_fd_sc_hd__inv_2
X_07284_ _04860_ _04882_ _04871_ VGND VGND VPWR VPWR _06432_ sky130_fd_sc_hd__o21bai_1
X_09023_ _01500_ _01501_ _01406_ VGND VGND VPWR VPWR _01503_ sky130_fd_sc_hd__o21a_1
XFILLER_40_29 VPWR VGND VPWR VGND sky130_ef_sc_hd__decap_12
XFILLER_132_601 VGND VGND VPWR VPWR sky130_fd_sc_hd__fill_1
XFILLER_116_141 VPWR VGND VPWR VGND sky130_ef_sc_hd__decap_12
XFILLER_2_419 VGND VGND VPWR VPWR sky130_fd_sc_hd__fill_1
XFILLER_132_645 VGND VGND VPWR VPWR sky130_fd_sc_hd__fill_1
XFILLER_131_111 VGND VGND VPWR VPWR sky130_fd_sc_hd__fill_1
XTAP_TAPCELL_ROW_113_1940 VGND VPWR sky130_fd_sc_hd__tapvpwrvgnd_1
XFILLER_104_347 VGND VGND VPWR VPWR sky130_fd_sc_hd__fill_1
XFILLER_49_27 VPWR VGND VPWR VGND sky130_ef_sc_hd__decap_12
XFILLER_131_155 VGND VGND VPWR VPWR sky130_fd_sc_hd__fill_2
X_09925_ _02482_ _02483_ VGND VGND VPWR VPWR _02485_ sky130_fd_sc_hd__and2_1
Xfanout712 net714 VGND VGND VPWR VPWR net712 sky130_fd_sc_hd__clkbuf_4
Xfanout701 net702 VGND VGND VPWR VPWR net701 sky130_fd_sc_hd__buf_2
X_09856_ _02262_ _02267_ _02122_ VGND VGND VPWR VPWR _02411_ sky130_fd_sc_hd__a21o_1
XFILLER_86_721 VGND VGND VPWR VPWR sky130_fd_sc_hd__decap_8
XTAP_TAPCELL_ROW_55_1091 VGND VPWR sky130_fd_sc_hd__tapvpwrvgnd_1
XTAP_TAPCELL_ROW_129_2169 VGND VPWR sky130_fd_sc_hd__tapvpwrvgnd_1
X_08807_ net489 net352 VGND VGND VPWR VPWR _01273_ sky130_fd_sc_hd__nand2_1
XFILLER_105_55 VGND VGND VPWR VPWR sky130_fd_sc_hd__fill_1
XFILLER_58_445 VPWR VGND VPWR VGND sky130_ef_sc_hd__decap_12
X_09787_ _02329_ _02334_ VGND VGND VPWR VPWR _02335_ sky130_fd_sc_hd__xnor2_1
XFILLER_105_99 VGND VGND VPWR VPWR sky130_fd_sc_hd__fill_1
XFILLER_85_264 VGND VGND VPWR VPWR sky130_fd_sc_hd__decap_8
X_06999_ _03270_ _03303_ VGND VGND VPWR VPWR _03325_ sky130_fd_sc_hd__nor2_1
XFILLER_18_309 VGND VGND VPWR VPWR sky130_fd_sc_hd__decap_6
X_08738_ _01039_ _01196_ _01204_ VGND VGND VPWR VPWR _01205_ sky130_fd_sc_hd__nand3_2
XFILLER_54_640 VGND VGND VPWR VPWR sky130_fd_sc_hd__decap_4
X_08669_ _01083_ _01085_ VGND VGND VPWR VPWR _01136_ sky130_fd_sc_hd__nand2b_1
XFILLER_42_813 VGND VGND VPWR VPWR sky130_fd_sc_hd__decap_6
XFILLER_81_25 VPWR VGND VPWR VGND sky130_ef_sc_hd__decap_12
XFILLER_54_684 VPWR VGND VPWR VGND sky130_ef_sc_hd__decap_12
XFILLER_41_312 VPWR VGND VPWR VGND sky130_ef_sc_hd__decap_12
XFILLER_14_526 VGND VGND VPWR VPWR sky130_fd_sc_hd__decap_6
X_10700_ _03159_ _03168_ _03167_ VGND VGND VPWR VPWR _03328_ sky130_fd_sc_hd__a21bo_1
XFILLER_81_69 VGND VGND VPWR VPWR sky130_fd_sc_hd__decap_3
XFILLER_41_356 VPWR VGND VPWR VGND sky130_ef_sc_hd__decap_12
X_11680_ _04224_ _04226_ _04397_ VGND VGND VPWR VPWR _04398_ sky130_fd_sc_hd__o21ai_1
XFILLER_14_41 VPWR VGND VPWR VGND sky130_ef_sc_hd__decap_12
X_10631_ net476 net298 net297 net485 VGND VGND VPWR VPWR _03252_ sky130_fd_sc_hd__a22o_1
XPHY_EDGE_ROW_101_Left_240 VGND VGND VPWR VPWR sky130_fd_sc_hd__decap_3
X_13350_ _06215_ _06216_ VGND VGND VPWR VPWR _06217_ sky130_fd_sc_hd__or2_1
XFILLER_22_581 VGND VGND VPWR VPWR sky130_fd_sc_hd__decap_3
X_10562_ _03173_ _03175_ _03154_ VGND VGND VPWR VPWR _03177_ sky130_fd_sc_hd__o21ai_1
XFILLER_127_439 VGND VGND VPWR VPWR sky130_fd_sc_hd__decap_8
XFILLER_108_620 VGND VGND VPWR VPWR sky130_fd_sc_hd__decap_3
X_12301_ _04948_ _04949_ _04963_ _04961_ _04790_ VGND VGND VPWR VPWR _05071_ sky130_fd_sc_hd__a32o_1
X_13281_ _05982_ _06008_ _06006_ VGND VGND VPWR VPWR _06142_ sky130_fd_sc_hd__o21a_1
X_12232_ _04971_ _04994_ VGND VGND VPWR VPWR _04996_ sky130_fd_sc_hd__and2b_1
XFILLER_6_769 VPWR VGND VPWR VGND sky130_ef_sc_hd__decap_12
X_10493_ _02958_ _03100_ VGND VGND VPWR VPWR _03101_ sky130_fd_sc_hd__and2_1
XFILLER_5_257 VPWR VGND VPWR VGND sky130_ef_sc_hd__decap_12
XFILLER_122_122 VGND VGND VPWR VPWR sky130_fd_sc_hd__decap_8
X_12163_ net565 net10 _04802_ VGND VGND VPWR VPWR _04921_ sky130_fd_sc_hd__a21o_1
XFILLER_123_689 VGND VGND VPWR VPWR sky130_fd_sc_hd__decap_8
XFILLER_123_667 VGND VGND VPWR VPWR sky130_fd_sc_hd__decap_4
XFILLER_96_529 VGND VGND VPWR VPWR sky130_fd_sc_hd__decap_3
X_12094_ _04842_ _04844_ VGND VGND VPWR VPWR _04845_ sky130_fd_sc_hd__and2_1
XFILLER_68_209 VPWR VGND VPWR VGND sky130_ef_sc_hd__decap_12
X_11114_ _03778_ _03779_ VGND VGND VPWR VPWR _03780_ sky130_fd_sc_hd__nand2b_1
XFILLER_89_592 VGND VGND VPWR VPWR sky130_fd_sc_hd__decap_3
XFILLER_49_423 VPWR VGND VPWR VGND sky130_ef_sc_hd__decap_12
X_11045_ _03701_ _03702_ VGND VGND VPWR VPWR _03705_ sky130_fd_sc_hd__xor2_1
XFILLER_1_496 VGND VGND VPWR VPWR sky130_fd_sc_hd__decap_3
XFILLER_39_93 VPWR VGND VPWR VGND sky130_ef_sc_hd__decap_12
XFILLER_49_489 VPWR VGND VPWR VGND sky130_ef_sc_hd__decap_12
XFILLER_18_821 VGND VGND VPWR VPWR sky130_fd_sc_hd__decap_3
XFILLER_92_757 VGND VGND VPWR VPWR sky130_fd_sc_hd__decap_4
X_12996_ _05815_ _05828_ VGND VGND VPWR VPWR _05830_ sky130_fd_sc_hd__xor2_1
XFILLER_36_139 VGND VGND VPWR VPWR sky130_fd_sc_hd__fill_1
XTAP_TAPCELL_ROW_86_1552 VGND VPWR sky130_fd_sc_hd__tapvpwrvgnd_1
XTAP_TAPCELL_ROW_86_1541 VGND VPWR sky130_fd_sc_hd__tapvpwrvgnd_1
X_11947_ net407 _04684_ VGND VGND VPWR VPWR _04685_ sky130_fd_sc_hd__nand2_1
XFILLER_55_81 VPWR VGND VPWR VGND sky130_ef_sc_hd__decap_12
XFILLER_45_673 VGND VGND VPWR VPWR sky130_fd_sc_hd__decap_8
XTAP_TAPCELL_ROW_35_808 VGND VPWR sky130_fd_sc_hd__tapvpwrvgnd_1
XFILLER_91_289 VGND VGND VPWR VPWR sky130_fd_sc_hd__decap_8
XFILLER_72_492 VGND VGND VPWR VPWR sky130_fd_sc_hd__decap_4
XTAP_TAPCELL_ROW_15_510 VGND VPWR sky130_fd_sc_hd__tapvpwrvgnd_1
XFILLER_17_375 VGND VGND VPWR VPWR sky130_fd_sc_hd__decap_3
X_11878_ _04610_ _04611_ VGND VGND VPWR VPWR _04614_ sky130_fd_sc_hd__xnor2_1
XTAP_TAPCELL_ROW_15_521 VGND VPWR sky130_fd_sc_hd__tapvpwrvgnd_1
XFILLER_32_334 VGND VGND VPWR VPWR sky130_fd_sc_hd__decap_3
X_13617_ _06503_ _06506_ VGND VGND VPWR VPWR _06507_ sky130_fd_sc_hd__xor2_1
X_10829_ net261 net327 _03464_ _03466_ VGND VGND VPWR VPWR _03469_ sky130_fd_sc_hd__or4b_1
X_13548_ _06319_ _06322_ _06431_ VGND VGND VPWR VPWR _06433_ sky130_fd_sc_hd__o21ai_1
X_13479_ _06355_ _06357_ VGND VGND VPWR VPWR _06358_ sky130_fd_sc_hd__xnor2_1
XFILLER_126_450 VGND VGND VPWR VPWR sky130_fd_sc_hd__decap_6
XFILLER_114_645 VGND VGND VPWR VPWR sky130_fd_sc_hd__decap_6
XFILLER_113_122 VGND VGND VPWR VPWR sky130_fd_sc_hd__decap_4
X_07971_ _00306_ _00310_ _00446_ VGND VGND VPWR VPWR _00448_ sky130_fd_sc_hd__nor3_1
X_09710_ _02248_ _02250_ VGND VGND VPWR VPWR _02252_ sky130_fd_sc_hd__and2_1
X_06922_ net527 net147 net686 net684 VGND VGND VPWR VPWR _02488_ sky130_fd_sc_hd__and4_1
X_09641_ _01858_ _02022_ _02023_ VGND VGND VPWR VPWR _02177_ sky130_fd_sc_hd__a21boi_1
XFILLER_83_713 VPWR VGND VPWR VGND sky130_ef_sc_hd__decap_12
X_06853_ _01508_ _01725_ VGND VGND VPWR VPWR _01736_ sky130_fd_sc_hd__nor2_1
XFILLER_27_106 VGND VGND VPWR VPWR sky130_fd_sc_hd__fill_1
X_09572_ _02099_ _02100_ VGND VGND VPWR VPWR _02101_ sky130_fd_sc_hd__or2_1
XFILLER_95_595 VGND VGND VPWR VPWR sky130_fd_sc_hd__fill_1
XFILLER_82_234 VGND VGND VPWR VPWR sky130_fd_sc_hd__decap_4
XFILLER_27_128 VPWR VGND VPWR VGND sky130_ef_sc_hd__decap_12
XFILLER_42_109 VPWR VGND VPWR VGND sky130_ef_sc_hd__decap_12
XFILLER_24_813 VGND VGND VPWR VPWR sky130_fd_sc_hd__decap_6
X_08523_ _00992_ _00994_ VGND VGND VPWR VPWR _00995_ sky130_fd_sc_hd__xnor2_1
XTAP_TAPCELL_ROW_124_2099 VGND VPWR sky130_fd_sc_hd__tapvpwrvgnd_1
XFILLER_63_470 VGND VGND VPWR VPWR sky130_fd_sc_hd__fill_1
XFILLER_50_131 VGND VGND VPWR VPWR sky130_fd_sc_hd__decap_8
XFILLER_23_345 VGND VGND VPWR VPWR sky130_fd_sc_hd__fill_1
X_08454_ _00925_ _00926_ VGND VGND VPWR VPWR _00927_ sky130_fd_sc_hd__nand2_1
X_07405_ _06050_ _06072_ VGND VGND VPWR VPWR _06635_ sky130_fd_sc_hd__nand2_1
X_08385_ _00857_ _00858_ VGND VGND VPWR VPWR _00859_ sky130_fd_sc_hd__or2_1
X_07336_ _06564_ _06565_ _05428_ _05450_ VGND VGND VPWR VPWR _06567_ sky130_fd_sc_hd__a211o_1
XFILLER_136_214 VPWR VGND VPWR VGND sky130_ef_sc_hd__decap_12
X_09006_ _01481_ _01482_ _01473_ VGND VGND VPWR VPWR _01484_ sky130_fd_sc_hd__a21o_1
X_07267_ _06138_ _06236_ VGND VGND VPWR VPWR _06247_ sky130_fd_sc_hd__xor2_1
XFILLER_117_461 VGND VGND VPWR VPWR sky130_fd_sc_hd__decap_3
XTAP_TAPCELL_ROW_57_1120 VGND VPWR sky130_fd_sc_hd__tapvpwrvgnd_1
X_07198_ _04123_ _04156_ _04112_ VGND VGND VPWR VPWR _05494_ sky130_fd_sc_hd__o21bai_1
XTAP_TAPCELL_ROW_57_1131 VGND VPWR sky130_fd_sc_hd__tapvpwrvgnd_1
XFILLER_132_464 VGND VGND VPWR VPWR sky130_fd_sc_hd__decap_3
XFILLER_132_453 VGND VGND VPWR VPWR sky130_fd_sc_hd__decap_3
XFILLER_105_667 VGND VGND VPWR VPWR sky130_fd_sc_hd__decap_4
XFILLER_2_249 VGND VGND VPWR VPWR sky130_fd_sc_hd__decap_3
XFILLER_132_497 VGND VGND VPWR VPWR sky130_fd_sc_hd__decap_8
XFILLER_132_475 VGND VGND VPWR VPWR sky130_fd_sc_hd__fill_1
XFILLER_116_65 VPWR VGND VPWR VGND sky130_ef_sc_hd__decap_12
Xfanout542 net543 VGND VGND VPWR VPWR net542 sky130_fd_sc_hd__buf_2
Xfanout531 net146 VGND VGND VPWR VPWR net531 sky130_fd_sc_hd__clkbuf_4
XTAP_TAPCELL_ROW_70_1320 VGND VPWR sky130_fd_sc_hd__tapvpwrvgnd_1
Xfanout520 net521 VGND VGND VPWR VPWR net520 sky130_fd_sc_hd__clkbuf_4
X_09908_ _02464_ _02465_ VGND VGND VPWR VPWR _02467_ sky130_fd_sc_hd__nor2_1
Xfanout575 net576 VGND VGND VPWR VPWR net575 sky130_fd_sc_hd__dlymetal6s2s_1
Xfanout564 net567 VGND VGND VPWR VPWR net564 sky130_fd_sc_hd__clkbuf_4
Xfanout553 net554 VGND VGND VPWR VPWR net553 sky130_fd_sc_hd__clkbuf_4
Xfanout597 net138 VGND VGND VPWR VPWR net597 sky130_fd_sc_hd__buf_2
Xfanout586 net587 VGND VGND VPWR VPWR net586 sky130_fd_sc_hd__dlymetal6s2s_1
X_09839_ _01991_ _02277_ _01989_ VGND VGND VPWR VPWR _02393_ sky130_fd_sc_hd__a21o_1
XFILLER_100_361 VGND VGND VPWR VPWR sky130_fd_sc_hd__decap_3
XFILLER_86_573 VPWR VGND VPWR VGND sky130_ef_sc_hd__decap_12
XFILLER_76_69 VGND VGND VPWR VPWR sky130_fd_sc_hd__fill_1
XFILLER_58_253 VPWR VGND VPWR VGND sky130_ef_sc_hd__decap_12
XFILLER_46_415 VGND VGND VPWR VPWR sky130_fd_sc_hd__decap_4
XFILLER_132_53 VPWR VGND VPWR VGND sky130_ef_sc_hd__decap_12
X_12850_ _05498_ _05501_ VGND VGND VPWR VPWR _05671_ sky130_fd_sc_hd__and2_1
XFILLER_73_212 VGND VGND VPWR VPWR sky130_fd_sc_hd__fill_1
XFILLER_46_448 VGND VGND VPWR VPWR sky130_fd_sc_hd__decap_8
X_11801_ _04344_ _04413_ _04412_ VGND VGND VPWR VPWR _04530_ sky130_fd_sc_hd__a21oi_1
XFILLER_132_97 VPWR VGND VPWR VGND sky130_ef_sc_hd__decap_12
X_12781_ _05592_ _05593_ VGND VGND VPWR VPWR _05595_ sky130_fd_sc_hd__xor2_1
XTAP_TAPCELL_ROW_68_1282 VGND VPWR sky130_fd_sc_hd__tapvpwrvgnd_1
XFILLER_27_673 VPWR VGND VPWR VGND sky130_ef_sc_hd__decap_12
XFILLER_41_131 VPWR VGND VPWR VGND sky130_ef_sc_hd__decap_12
XFILLER_41_120 VGND VGND VPWR VPWR sky130_fd_sc_hd__decap_4
XFILLER_14_356 VGND VGND VPWR VPWR sky130_fd_sc_hd__decap_8
XFILLER_25_51 VGND VGND VPWR VPWR sky130_fd_sc_hd__decap_4
X_11732_ _04356_ _04358_ _04369_ VGND VGND VPWR VPWR _04454_ sky130_fd_sc_hd__o21a_1
XFILLER_30_805 VGND VGND VPWR VPWR sky130_fd_sc_hd__decap_6
XFILLER_42_698 VGND VGND VPWR VPWR sky130_fd_sc_hd__fill_2
XFILLER_41_164 VGND VGND VPWR VPWR sky130_fd_sc_hd__decap_4
X_11663_ _04376_ _04377_ VGND VGND VPWR VPWR _04379_ sky130_fd_sc_hd__xnor2_1
X_13402_ _06273_ _06250_ VGND VGND VPWR VPWR _06274_ sky130_fd_sc_hd__and2b_1
XTAP_TAPCELL_ROW_81_1471 VGND VPWR sky130_fd_sc_hd__tapvpwrvgnd_1
X_10614_ net568 net309 _03088_ _03087_ VGND VGND VPWR VPWR _03233_ sky130_fd_sc_hd__a31o_1
XFILLER_128_715 VGND VGND VPWR VPWR sky130_fd_sc_hd__decap_8
X_13333_ net246 _06197_ VGND VGND VPWR VPWR _06198_ sky130_fd_sc_hd__nand2b_1
X_11594_ _04298_ _04300_ _04301_ _04302_ VGND VGND VPWR VPWR _04304_ sky130_fd_sc_hd__and4_1
XTAP_TAPCELL_ROW_40_877 VGND VPWR sky130_fd_sc_hd__tapvpwrvgnd_1
XFILLER_127_247 VGND VGND VPWR VPWR sky130_fd_sc_hd__decap_3
XFILLER_127_225 VGND VGND VPWR VPWR sky130_fd_sc_hd__fill_2
XFILLER_6_544 VPWR VGND VPWR VGND sky130_ef_sc_hd__decap_12
XFILLER_6_522 VGND VGND VPWR VPWR sky130_fd_sc_hd__fill_1
XFILLER_6_533 VGND VGND VPWR VPWR sky130_fd_sc_hd__decap_8
X_10545_ _03156_ _03157_ VGND VGND VPWR VPWR _03158_ sky130_fd_sc_hd__and2b_1
X_13264_ _06109_ _06122_ VGND VGND VPWR VPWR _06123_ sky130_fd_sc_hd__xor2_1
X_10476_ _03080_ _03081_ VGND VGND VPWR VPWR _03082_ sky130_fd_sc_hd__xnor2_1
XTAP_TAPCELL_ROW_20_590 VGND VPWR sky130_fd_sc_hd__tapvpwrvgnd_1
XFILLER_136_781 VPWR VGND VPWR VGND sky130_ef_sc_hd__decap_12
X_13195_ _05898_ _05905_ _06046_ VGND VGND VPWR VPWR _06047_ sky130_fd_sc_hd__a21o_1
X_12215_ _04974_ _04975_ _04973_ VGND VGND VPWR VPWR _04977_ sky130_fd_sc_hd__a21bo_1
XFILLER_123_464 VGND VGND VPWR VPWR sky130_fd_sc_hd__fill_1
XFILLER_97_805 VPWR VGND VPWR VGND sky130_ef_sc_hd__decap_12
X_12146_ _04825_ _04900_ _04901_ VGND VGND VPWR VPWR _04902_ sky130_fd_sc_hd__nor3_1
XFILLER_96_304 VGND VGND VPWR VPWR sky130_fd_sc_hd__decap_4
XFILLER_69_529 VGND VGND VPWR VPWR sky130_fd_sc_hd__decap_4
X_12077_ net439 net26 VGND VGND VPWR VPWR _04826_ sky130_fd_sc_hd__nand2_1
XFILLER_2_77 VGND VGND VPWR VPWR sky130_fd_sc_hd__decap_6
X_11028_ _03683_ _03684_ _03652_ VGND VGND VPWR VPWR _03687_ sky130_fd_sc_hd__a21o_1
XFILLER_92_565 VGND VGND VPWR VPWR sky130_fd_sc_hd__fill_1
XFILLER_66_91 VGND VGND VPWR VPWR sky130_fd_sc_hd__fill_1
XFILLER_64_267 VGND VGND VPWR VPWR sky130_fd_sc_hd__decap_4
XTAP_TAPCELL_ROW_48_988 VGND VPWR sky130_fd_sc_hd__tapvpwrvgnd_1
XFILLER_18_662 VPWR VGND VPWR VGND sky130_ef_sc_hd__decap_12
X_12979_ _05780_ _05809_ VGND VGND VPWR VPWR _05812_ sky130_fd_sc_hd__xnor2_1
XTAP_TAPCELL_ROW_48_999 VGND VPWR sky130_fd_sc_hd__tapvpwrvgnd_1
XFILLER_33_654 VGND VGND VPWR VPWR sky130_fd_sc_hd__decap_8
XFILLER_60_462 VPWR VGND VPWR VGND sky130_ef_sc_hd__decap_12
XFILLER_32_153 VPWR VGND VPWR VGND sky130_ef_sc_hd__decap_12
XANTENNA_27 net482 VGND VGND VPWR VPWR sky130_fd_sc_hd__diode_2
XPHY_EDGE_ROW_120_Right_120 VGND VGND VPWR VPWR sky130_fd_sc_hd__decap_3
X_08170_ _00644_ _00645_ VGND VGND VPWR VPWR _00646_ sky130_fd_sc_hd__nor2_1
XANTENNA_16 net441 VGND VGND VPWR VPWR sky130_fd_sc_hd__diode_2
XFILLER_20_348 VGND VGND VPWR VPWR sky130_fd_sc_hd__decap_8
XFILLER_32_197 VGND VGND VPWR VPWR sky130_fd_sc_hd__decap_4
XTAP_TAPCELL_ROW_99_1732 VGND VPWR sky130_fd_sc_hd__tapvpwrvgnd_1
X_07121_ _04613_ _04623_ _04634_ VGND VGND VPWR VPWR _04656_ sky130_fd_sc_hd__a21o_1
XFILLER_9_360 VGND VGND VPWR VPWR sky130_fd_sc_hd__decap_4
XFILLER_9_393 VGND VGND VPWR VPWR sky130_fd_sc_hd__fill_1
X_07052_ _03861_ _03872_ _03117_ VGND VGND VPWR VPWR _03904_ sky130_fd_sc_hd__o21ai_2
Xoutput167 net167 VGND VGND VPWR VPWR y0[14] sky130_fd_sc_hd__buf_2
XFILLER_114_453 VPWR VGND VPWR VGND sky130_ef_sc_hd__decap_12
XFILLER_0_709 VPWR VGND VPWR VGND sky130_ef_sc_hd__decap_12
Xoutput189 net189 VGND VGND VPWR VPWR y1[3] sky130_fd_sc_hd__buf_2
XFILLER_114_497 VGND VGND VPWR VPWR sky130_fd_sc_hd__fill_1
Xoutput178 net178 VGND VGND VPWR VPWR y0[9] sky130_fd_sc_hd__buf_2
XFILLER_102_659 VGND VGND VPWR VPWR sky130_fd_sc_hd__decap_8
XFILLER_101_125 VPWR VGND VPWR VGND sky130_ef_sc_hd__decap_12
XTAP_TAPCELL_ROW_52_1050 VGND VPWR sky130_fd_sc_hd__tapvpwrvgnd_1
X_07954_ _00331_ _00333_ _00430_ VGND VGND VPWR VPWR _00431_ sky130_fd_sc_hd__a21oi_2
XTAP_TAPCELL_ROW_126_2128 VGND VPWR sky130_fd_sc_hd__tapvpwrvgnd_1
XFILLER_101_169 VPWR VGND VPWR VGND sky130_ef_sc_hd__decap_12
X_07885_ _00336_ _00361_ VGND VGND VPWR VPWR _00363_ sky130_fd_sc_hd__xnor2_1
X_06905_ _02282_ _02293_ VGND VGND VPWR VPWR _02304_ sky130_fd_sc_hd__nor2_1
X_09624_ _02155_ _02156_ VGND VGND VPWR VPWR _02158_ sky130_fd_sc_hd__xnor2_2
XFILLER_95_381 VGND VGND VPWR VPWR sky130_fd_sc_hd__decap_3
X_06836_ _01518_ _01540_ VGND VGND VPWR VPWR _01551_ sky130_fd_sc_hd__nor2_1
XFILLER_56_757 VGND VGND VPWR VPWR sky130_fd_sc_hd__decap_3
X_09555_ _01919_ net343 _00342_ VGND VGND VPWR VPWR _02082_ sky130_fd_sc_hd__and3b_2
XTAP_TAPCELL_ROW_108_1872 VGND VPWR sky130_fd_sc_hd__tapvpwrvgnd_1
XTAP_TAPCELL_ROW_108_1861 VGND VPWR sky130_fd_sc_hd__tapvpwrvgnd_1
XFILLER_71_727 VGND VGND VPWR VPWR sky130_fd_sc_hd__fill_1
XFILLER_70_204 VGND VGND VPWR VPWR sky130_fd_sc_hd__fill_1
XFILLER_24_621 VGND VGND VPWR VPWR sky130_fd_sc_hd__decap_3
X_09486_ _01950_ _02006_ VGND VGND VPWR VPWR _02007_ sky130_fd_sc_hd__xor2_1
XFILLER_70_248 VGND VGND VPWR VPWR sky130_fd_sc_hd__decap_4
XFILLER_62_27 VGND VGND VPWR VPWR sky130_fd_sc_hd__fill_1
X_08506_ net251 _00862_ _00929_ VGND VGND VPWR VPWR _00978_ sky130_fd_sc_hd__o21ai_1
XFILLER_51_473 VGND VGND VPWR VPWR sky130_fd_sc_hd__fill_1
X_08437_ _00825_ _00839_ _00838_ VGND VGND VPWR VPWR _00910_ sky130_fd_sc_hd__o21ba_1
XFILLER_23_153 VPWR VGND VPWR VGND sky130_ef_sc_hd__decap_12
XFILLER_24_676 VGND VGND VPWR VPWR sky130_fd_sc_hd__fill_1
XFILLER_24_698 VGND VGND VPWR VPWR sky130_fd_sc_hd__fill_2
XFILLER_11_337 VPWR VGND VPWR VGND sky130_ef_sc_hd__decap_12
XFILLER_109_214 VGND VGND VPWR VPWR sky130_fd_sc_hd__fill_1
X_08368_ _00823_ _00841_ VGND VGND VPWR VPWR _00842_ sky130_fd_sc_hd__and2_1
XFILLER_7_308 VGND VGND VPWR VPWR sky130_fd_sc_hd__fill_2
XTAP_TAPCELL_ROW_137_2279 VGND VPWR sky130_fd_sc_hd__tapvpwrvgnd_1
XFILLER_109_236 VGND VGND VPWR VPWR sky130_fd_sc_hd__decap_8
XFILLER_109_225 VGND VGND VPWR VPWR sky130_fd_sc_hd__decap_3
X_07319_ _05210_ _05242_ _06548_ _06549_ VGND VGND VPWR VPWR _06550_ sky130_fd_sc_hd__a211o_1
X_08299_ _00761_ _00773_ VGND VGND VPWR VPWR _00774_ sky130_fd_sc_hd__xnor2_1
X_10330_ _02870_ _02873_ _02922_ VGND VGND VPWR VPWR _02923_ sky130_fd_sc_hd__o21a_1
XFILLER_124_239 VGND VGND VPWR VPWR sky130_fd_sc_hd__decap_8
X_10261_ _02809_ _02847_ VGND VGND VPWR VPWR _02848_ sky130_fd_sc_hd__and2_1
XFILLER_133_751 VPWR VGND VPWR VGND sky130_ef_sc_hd__decap_12
XFILLER_105_431 VGND VGND VPWR VPWR sky130_fd_sc_hd__fill_2
X_12000_ _04695_ _04742_ VGND VGND VPWR VPWR _04743_ sky130_fd_sc_hd__nand2_1
XFILLER_3_569 VGND VGND VPWR VPWR sky130_fd_sc_hd__fill_2
X_10192_ _02705_ _02775_ VGND VGND VPWR VPWR _02776_ sky130_fd_sc_hd__xnor2_1
XFILLER_87_57 VPWR VGND VPWR VGND sky130_ef_sc_hd__decap_12
Xfanout350 net52 VGND VGND VPWR VPWR net350 sky130_fd_sc_hd__dlymetal6s2s_1
XFILLER_120_456 VGND VGND VPWR VPWR sky130_fd_sc_hd__fill_1
XFILLER_120_434 VGND VGND VPWR VPWR sky130_fd_sc_hd__decap_3
XFILLER_94_819 VGND VGND VPWR VPWR sky130_fd_sc_hd__fill_1
Xfanout361 net45 VGND VGND VPWR VPWR net361 sky130_fd_sc_hd__buf_2
Xfanout372 net38 VGND VGND VPWR VPWR net372 sky130_fd_sc_hd__clkbuf_4
XFILLER_93_307 VGND VGND VPWR VPWR sky130_fd_sc_hd__decap_4
Xfanout383 net31 VGND VGND VPWR VPWR net383 sky130_fd_sc_hd__clkbuf_4
XTAP_TAPCELL_ROW_6_385 VGND VPWR sky130_fd_sc_hd__tapvpwrvgnd_1
X_12902_ _05560_ _05562_ _05727_ VGND VGND VPWR VPWR _05728_ sky130_fd_sc_hd__and3_1
Xfanout394 net395 VGND VGND VPWR VPWR net394 sky130_fd_sc_hd__buf_2
XFILLER_59_584 VGND VGND VPWR VPWR sky130_fd_sc_hd__fill_1
XFILLER_47_746 VPWR VGND VPWR VGND sky130_ef_sc_hd__decap_12
XFILLER_62_705 VGND VGND VPWR VPWR sky130_fd_sc_hd__decap_8
XTAP_TAPCELL_ROW_83_1500 VGND VPWR sky130_fd_sc_hd__tapvpwrvgnd_1
X_12833_ _05651_ _05650_ VGND VGND VPWR VPWR _05652_ sky130_fd_sc_hd__nand2b_1
XFILLER_74_587 VGND VGND VPWR VPWR sky130_fd_sc_hd__fill_1
X_12764_ _05444_ _05446_ VGND VGND VPWR VPWR _05576_ sky130_fd_sc_hd__nand2_1
XFILLER_61_237 VPWR VGND VPWR VGND sky130_ef_sc_hd__decap_12
XTAP_TAPCELL_ROW_45_958 VGND VPWR sky130_fd_sc_hd__tapvpwrvgnd_1
XTAP_TAPCELL_ROW_45_947 VGND VPWR sky130_fd_sc_hd__tapvpwrvgnd_1
XFILLER_15_632 VPWR VGND VPWR VGND sky130_ef_sc_hd__decap_12
XFILLER_36_83 VGND VGND VPWR VPWR sky130_fd_sc_hd__fill_1
XTAP_TAPCELL_ROW_25_660 VGND VPWR sky130_fd_sc_hd__tapvpwrvgnd_1
X_11715_ net598 net602 net314 VGND VGND VPWR VPWR _04435_ sky130_fd_sc_hd__mux2_1
XFILLER_30_613 VGND VGND VPWR VPWR sky130_fd_sc_hd__decap_8
X_12695_ net600 _01453_ _05326_ _05324_ VGND VGND VPWR VPWR _05502_ sky130_fd_sc_hd__a31o_1
XFILLER_70_793 VPWR VGND VPWR VGND sky130_ef_sc_hd__decap_12
XFILLER_128_501 VGND VGND VPWR VPWR sky130_fd_sc_hd__decap_8
X_11646_ _04348_ _04359_ VGND VGND VPWR VPWR _04360_ sky130_fd_sc_hd__xor2_1
Xinput36 w10[2] VGND VGND VPWR VPWR net36 sky130_fd_sc_hd__clkbuf_2
Xinput14 w01[4] VGND VGND VPWR VPWR net14 sky130_fd_sc_hd__buf_1
Xinput25 w02[7] VGND VGND VPWR VPWR net25 sky130_fd_sc_hd__clkbuf_2
X_11577_ _04283_ _04284_ VGND VGND VPWR VPWR _04285_ sky130_fd_sc_hd__nor2_1
Xinput58 w13[0] VGND VGND VPWR VPWR net58 sky130_fd_sc_hd__clkbuf_2
Xinput47 w11[5] VGND VGND VPWR VPWR net47 sky130_fd_sc_hd__buf_1
XFILLER_115_206 VGND VGND VPWR VPWR sky130_fd_sc_hd__decap_3
X_13316_ _06051_ _06067_ _06065_ VGND VGND VPWR VPWR _06179_ sky130_fd_sc_hd__o21ai_1
Xinput69 w20[3] VGND VGND VPWR VPWR net69 sky130_fd_sc_hd__buf_2
X_10528_ net458 net276 net278 net450 VGND VGND VPWR VPWR _03140_ sky130_fd_sc_hd__a22oi_2
XFILLER_109_781 VGND VGND VPWR VPWR sky130_fd_sc_hd__decap_3
X_13247_ _05986_ _06103_ VGND VGND VPWR VPWR _06104_ sky130_fd_sc_hd__xor2_1
XFILLER_6_363 VGND VGND VPWR VPWR sky130_fd_sc_hd__fill_1
XTAP_TAPCELL_ROW_94_1662 VGND VPWR sky130_fd_sc_hd__tapvpwrvgnd_1
X_10459_ _03059_ _03064_ VGND VGND VPWR VPWR _03065_ sky130_fd_sc_hd__and2_1
X_13178_ _06027_ _06028_ VGND VGND VPWR VPWR _00028_ sky130_fd_sc_hd__xnor2_1
XFILLER_97_624 VGND VGND VPWR VPWR sky130_fd_sc_hd__decap_6
XFILLER_97_613 VGND VGND VPWR VPWR sky130_fd_sc_hd__decap_3
X_12129_ _04880_ _04873_ _04709_ VGND VGND VPWR VPWR _04884_ sky130_fd_sc_hd__a21o_1
XFILLER_84_307 VGND VGND VPWR VPWR sky130_fd_sc_hd__fill_1
XFILLER_28_3 VPWR VGND VPWR VGND sky130_ef_sc_hd__decap_12
XFILLER_38_713 VGND VGND VPWR VPWR sky130_fd_sc_hd__fill_1
XFILLER_65_532 VGND VGND VPWR VPWR sky130_fd_sc_hd__decap_8
XFILLER_38_746 VGND VGND VPWR VPWR sky130_fd_sc_hd__fill_1
X_07670_ _06738_ _00148_ VGND VGND VPWR VPWR _00149_ sky130_fd_sc_hd__xor2_1
XFILLER_38_779 VPWR VGND VPWR VGND sky130_ef_sc_hd__decap_12
XFILLER_52_215 VGND VGND VPWR VPWR sky130_fd_sc_hd__decap_3
X_09340_ _01845_ _01847_ _01670_ _01673_ VGND VGND VPWR VPWR _01849_ sky130_fd_sc_hd__a211o_1
XTAP_TAPCELL_ROW_121_2058 VGND VPWR sky130_fd_sc_hd__tapvpwrvgnd_1
XTAP_TAPCELL_ROW_121_2047 VGND VPWR sky130_fd_sc_hd__tapvpwrvgnd_1
X_09271_ _01763_ _01772_ VGND VGND VPWR VPWR _01773_ sky130_fd_sc_hd__xor2_1
XFILLER_61_782 VGND VGND VPWR VPWR sky130_fd_sc_hd__fill_2
XFILLER_33_462 VPWR VGND VPWR VGND sky130_ef_sc_hd__decap_12
X_08222_ _00695_ _00696_ VGND VGND VPWR VPWR _00697_ sky130_fd_sc_hd__and2_1
XFILLER_138_309 VGND VGND VPWR VPWR sky130_fd_sc_hd__fill_2
XTAP_TAPCELL_ROW_103_1791 VGND VPWR sky130_fd_sc_hd__tapvpwrvgnd_1
X_08153_ _00515_ _00517_ _00514_ VGND VGND VPWR VPWR _00629_ sky130_fd_sc_hd__o21ba_1
XFILLER_134_515 VPWR VGND VPWR VGND sky130_ef_sc_hd__decap_12
XFILLER_107_729 VPWR VGND VPWR VGND sky130_ef_sc_hd__decap_12
X_08084_ _00450_ _00463_ _00462_ VGND VGND VPWR VPWR _00560_ sky130_fd_sc_hd__o21ai_2
X_07104_ _02760_ _02782_ VGND VGND VPWR VPWR _04471_ sky130_fd_sc_hd__nor2_1
X_07035_ _03631_ _03642_ _03708_ VGND VGND VPWR VPWR _03718_ sky130_fd_sc_hd__and3_1
XFILLER_102_401 VPWR VGND VPWR VGND sky130_ef_sc_hd__decap_12
XFILLER_87_101 VGND VGND VPWR VPWR sky130_fd_sc_hd__decap_8
XFILLER_0_517 VGND VGND VPWR VPWR sky130_fd_sc_hd__decap_4
XFILLER_114_283 VPWR VGND VPWR VGND sky130_ef_sc_hd__decap_12
X_08986_ net615 net377 _01317_ _01316_ VGND VGND VPWR VPWR _01462_ sky130_fd_sc_hd__a31o_1
XFILLER_102_445 VGND VGND VPWR VPWR sky130_fd_sc_hd__decap_6
XFILLER_88_657 VGND VGND VPWR VPWR sky130_fd_sc_hd__fill_1
XFILLER_87_134 VGND VGND VPWR VPWR sky130_fd_sc_hd__fill_1
XFILLER_87_167 VGND VGND VPWR VPWR sky130_fd_sc_hd__fill_1
XFILLER_76_819 VGND VGND VPWR VPWR sky130_fd_sc_hd__fill_1
XFILLER_75_307 VPWR VGND VPWR VGND sky130_ef_sc_hd__decap_12
XFILLER_57_27 VPWR VGND VPWR VGND sky130_ef_sc_hd__decap_12
X_07937_ _00334_ _00414_ VGND VGND VPWR VPWR _00415_ sky130_fd_sc_hd__xnor2_2
XFILLER_102_489 VPWR VGND VPWR VGND sky130_ef_sc_hd__decap_12
XFILLER_87_189 VGND VGND VPWR VPWR sky130_fd_sc_hd__fill_1
XTAP_TAPCELL_ROW_3_344 VGND VPWR sky130_fd_sc_hd__tapvpwrvgnd_1
XFILLER_113_55 VGND VGND VPWR VPWR sky130_fd_sc_hd__fill_1
X_07868_ _00199_ _00202_ VGND VGND VPWR VPWR _00346_ sky130_fd_sc_hd__and2_1
XFILLER_113_77 VGND VGND VPWR VPWR sky130_fd_sc_hd__decap_3
X_09607_ _01990_ _01991_ VGND VGND VPWR VPWR _02139_ sky130_fd_sc_hd__nand2_2
X_06819_ net601 VGND VGND VPWR VPWR _01365_ sky130_fd_sc_hd__inv_2
XFILLER_73_15 VPWR VGND VPWR VGND sky130_ef_sc_hd__decap_12
XFILLER_56_576 VGND VGND VPWR VPWR sky130_fd_sc_hd__decap_6
X_07799_ _00275_ _00276_ VGND VGND VPWR VPWR _00278_ sky130_fd_sc_hd__xnor2_2
XFILLER_44_749 VGND VGND VPWR VPWR sky130_fd_sc_hd__fill_1
XFILLER_28_289 VPWR VGND VPWR VGND sky130_ef_sc_hd__decap_12
X_09538_ _02055_ _02061_ VGND VGND VPWR VPWR _02064_ sky130_fd_sc_hd__xor2_1
XTAP_TAPCELL_ROW_65_1241 VGND VPWR sky130_fd_sc_hd__tapvpwrvgnd_1
XFILLER_43_259 VPWR VGND VPWR VGND sky130_ef_sc_hd__decap_12
XTAP_TAPCELL_ROW_42_906 VGND VPWR sky130_fd_sc_hd__tapvpwrvgnd_1
X_09469_ net637 _01820_ VGND VGND VPWR VPWR _01989_ sky130_fd_sc_hd__and2_1
XFILLER_51_281 VGND VGND VPWR VPWR sky130_fd_sc_hd__decap_4
X_11500_ _04200_ _04201_ VGND VGND VPWR VPWR _04202_ sky130_fd_sc_hd__nand2b_1
XFILLER_11_101 VGND VGND VPWR VPWR sky130_fd_sc_hd__decap_3
XFILLER_11_123 VGND VGND VPWR VPWR sky130_fd_sc_hd__fill_1
XFILLER_24_473 VGND VGND VPWR VPWR sky130_fd_sc_hd__decap_3
XFILLER_138_821 VGND VGND VPWR VPWR sky130_fd_sc_hd__decap_3
XFILLER_132_3 VPWR VGND VPWR VGND sky130_ef_sc_hd__decap_12
X_12480_ _05263_ _05265_ VGND VGND VPWR VPWR _05267_ sky130_fd_sc_hd__nor2_1
XFILLER_7_116 VPWR VGND VPWR VGND sky130_ef_sc_hd__decap_12
XFILLER_22_41 VPWR VGND VPWR VGND sky130_ef_sc_hd__decap_12
X_11431_ net261 net322 _03973_ _03976_ VGND VGND VPWR VPWR _04127_ sky130_fd_sc_hd__o31ai_2
XFILLER_138_41 VPWR VGND VPWR VGND sky130_ef_sc_hd__decap_12
X_11362_ _03745_ _04049_ VGND VGND VPWR VPWR _04051_ sky130_fd_sc_hd__xnor2_1
XFILLER_22_85 VGND VGND VPWR VPWR sky130_fd_sc_hd__decap_6
XFILLER_138_85 VPWR VGND VPWR VGND sky130_ef_sc_hd__decap_12
X_13101_ net495 _05628_ VGND VGND VPWR VPWR _05945_ sky130_fd_sc_hd__and2_1
X_10313_ net553 net313 net311 net561 VGND VGND VPWR VPWR _02904_ sky130_fd_sc_hd__a22o_1
XFILLER_3_322 VGND VGND VPWR VPWR sky130_fd_sc_hd__fill_1
X_11293_ _03455_ _03975_ VGND VGND VPWR VPWR _03976_ sky130_fd_sc_hd__nand2_1
XFILLER_121_721 VGND VGND VPWR VPWR sky130_fd_sc_hd__decap_6
X_13032_ _05868_ _05869_ VGND VGND VPWR VPWR _05870_ sky130_fd_sc_hd__nor2_1
X_10244_ _02826_ _02828_ _02829_ VGND VGND VPWR VPWR _02830_ sky130_fd_sc_hd__or3_1
X_10175_ net720 _02681_ _02679_ VGND VGND VPWR VPWR _02758_ sky130_fd_sc_hd__a21oi_2
XFILLER_66_307 VGND VGND VPWR VPWR sky130_fd_sc_hd__fill_1
XFILLER_19_223 VGND VGND VPWR VPWR sky130_fd_sc_hd__fill_1
XFILLER_47_554 VGND VGND VPWR VPWR sky130_fd_sc_hd__decap_6
XFILLER_90_811 VGND VGND VPWR VPWR sky130_fd_sc_hd__fill_1
XFILLER_62_513 VGND VGND VPWR VPWR sky130_fd_sc_hd__fill_1
X_12816_ net495 net397 _05631_ _05632_ VGND VGND VPWR VPWR _05633_ sky130_fd_sc_hd__a22o_1
XFILLER_62_546 VGND VGND VPWR VPWR sky130_fd_sc_hd__decap_3
X_12747_ _05381_ _05383_ _05556_ _05557_ VGND VGND VPWR VPWR _05558_ sky130_fd_sc_hd__o211a_1
XFILLER_15_473 VPWR VGND VPWR VGND sky130_ef_sc_hd__decap_12
XFILLER_30_421 VGND VGND VPWR VPWR sky130_fd_sc_hd__decap_4
XFILLER_129_821 VGND VGND VPWR VPWR sky130_fd_sc_hd__decap_3
X_12678_ _05480_ _05481_ VGND VGND VPWR VPWR _05484_ sky130_fd_sc_hd__xnor2_1
X_11629_ _04311_ _04339_ VGND VGND VPWR VPWR _04342_ sky130_fd_sc_hd__xnor2_1
XFILLER_8_65 VPWR VGND VPWR VGND sky130_ef_sc_hd__decap_12
XFILLER_116_548 VGND VGND VPWR VPWR sky130_fd_sc_hd__fill_1
XFILLER_131_529 VPWR VGND VPWR VGND sky130_ef_sc_hd__decap_12
XFILLER_69_101 VGND VGND VPWR VPWR sky130_fd_sc_hd__decap_8
X_08840_ _01302_ _01303_ _01304_ VGND VGND VPWR VPWR _01306_ sky130_fd_sc_hd__a21oi_1
XFILLER_97_465 VGND VGND VPWR VPWR sky130_fd_sc_hd__fill_1
XFILLER_69_156 VPWR VGND VPWR VGND sky130_ef_sc_hd__decap_12
XFILLER_69_145 VGND VGND VPWR VPWR sky130_fd_sc_hd__fill_2
X_08771_ _01059_ _01070_ _01232_ _01236_ VGND VGND VPWR VPWR _01238_ sky130_fd_sc_hd__o211ai_1
X_07722_ net493 net681 _00199_ _00200_ VGND VGND VPWR VPWR _00201_ sky130_fd_sc_hd__a22o_1
XTAP_TAPCELL_ROW_0_303 VGND VPWR sky130_fd_sc_hd__tapvpwrvgnd_1
XFILLER_65_351 VGND VGND VPWR VPWR sky130_fd_sc_hd__decap_6
X_07653_ _06733_ _00131_ _00132_ VGND VGND VPWR VPWR _00133_ sky130_fd_sc_hd__nand3_1
XFILLER_26_727 VPWR VGND VPWR VGND sky130_ef_sc_hd__decap_12
XFILLER_38_598 VPWR VGND VPWR VGND sky130_ef_sc_hd__decap_12
XTAP_TAPCELL_ROW_105_1820 VGND VPWR sky130_fd_sc_hd__tapvpwrvgnd_1
XFILLER_92_192 VGND VGND VPWR VPWR sky130_fd_sc_hd__decap_4
XFILLER_25_237 VGND VGND VPWR VPWR sky130_fd_sc_hd__decap_6
XFILLER_25_248 VGND VGND VPWR VPWR sky130_fd_sc_hd__fill_1
X_09323_ _01827_ _01828_ _01829_ VGND VGND VPWR VPWR _01830_ sky130_fd_sc_hd__nand3_1
XFILLER_80_365 VPWR VGND VPWR VGND sky130_ef_sc_hd__decap_12
X_07584_ _06797_ _06812_ VGND VGND VPWR VPWR _06813_ sky130_fd_sc_hd__xnor2_1
XFILLER_53_568 VGND VGND VPWR VPWR sky130_fd_sc_hd__fill_2
XFILLER_41_719 VGND VGND VPWR VPWR sky130_fd_sc_hd__decap_8
XFILLER_61_590 VGND VGND VPWR VPWR sky130_fd_sc_hd__fill_1
XFILLER_33_281 VGND VGND VPWR VPWR sky130_fd_sc_hd__fill_1
XFILLER_34_793 VPWR VGND VPWR VGND sky130_ef_sc_hd__decap_12
X_09254_ net509 net55 net345 net515 VGND VGND VPWR VPWR _01754_ sky130_fd_sc_hd__a22o_1
XFILLER_33_292 VGND VGND VPWR VPWR sky130_fd_sc_hd__decap_4
X_09185_ _01519_ _01677_ VGND VGND VPWR VPWR _01679_ sky130_fd_sc_hd__xnor2_1
XTAP_TAPCELL_ROW_60_1171 VGND VPWR sky130_fd_sc_hd__tapvpwrvgnd_1
X_08205_ _00423_ _00424_ _00429_ _00553_ VGND VGND VPWR VPWR _00681_ sky130_fd_sc_hd__o22a_1
XFILLER_21_476 VGND VGND VPWR VPWR sky130_fd_sc_hd__decap_8
XTAP_TAPCELL_ROW_134_2249 VGND VPWR sky130_fd_sc_hd__tapvpwrvgnd_1
XTAP_TAPCELL_ROW_134_2238 VGND VPWR sky130_fd_sc_hd__tapvpwrvgnd_1
X_08136_ _00607_ _00610_ VGND VGND VPWR VPWR _00612_ sky130_fd_sc_hd__xnor2_1
XFILLER_119_397 VGND VGND VPWR VPWR sky130_fd_sc_hd__fill_1
XFILLER_4_119 VGND VGND VPWR VPWR sky130_fd_sc_hd__fill_2
XFILLER_134_345 VGND VGND VPWR VPWR sky130_fd_sc_hd__decap_8
XFILLER_107_559 VGND VGND VPWR VPWR sky130_fd_sc_hd__fill_1
XFILLER_104_7 VPWR VGND VPWR VGND sky130_ef_sc_hd__decap_12
X_08067_ _00541_ _00542_ VGND VGND VPWR VPWR _00544_ sky130_fd_sc_hd__xor2_2
XTAP_TAPCELL_ROW_116_1982 VGND VPWR sky130_fd_sc_hd__tapvpwrvgnd_1
XFILLER_108_77 VGND VGND VPWR VPWR sky130_fd_sc_hd__decap_6
XFILLER_68_15 VPWR VGND VPWR VGND sky130_ef_sc_hd__decap_12
X_07018_ _03500_ _03511_ _03379_ VGND VGND VPWR VPWR _03533_ sky130_fd_sc_hd__a21o_1
XTAP_TAPCELL_ROW_8_414 VGND VPWR sky130_fd_sc_hd__tapvpwrvgnd_1
XFILLER_115_581 VGND VGND VPWR VPWR sky130_fd_sc_hd__fill_1
XFILLER_88_421 VGND VGND VPWR VPWR sky130_fd_sc_hd__decap_3
XFILLER_130_540 VPWR VGND VPWR VGND sky130_ef_sc_hd__decap_12
XFILLER_103_765 VPWR VGND VPWR VGND sky130_ef_sc_hd__decap_12
XFILLER_102_253 VGND VGND VPWR VPWR sky130_fd_sc_hd__decap_8
XFILLER_48_307 VGND VGND VPWR VPWR sky130_fd_sc_hd__fill_1
XFILLER_124_65 VPWR VGND VPWR VGND sky130_ef_sc_hd__decap_12
X_08969_ _01441_ _01443_ VGND VGND VPWR VPWR _01444_ sky130_fd_sc_hd__and2b_1
XFILLER_75_159 VGND VGND VPWR VPWR sky130_fd_sc_hd__decap_8
X_11980_ _04663_ _04678_ _04680_ VGND VGND VPWR VPWR _04721_ sky130_fd_sc_hd__a21oi_1
XFILLER_72_811 VGND VGND VPWR VPWR sky130_fd_sc_hd__fill_1
X_10931_ _03578_ _03579_ VGND VGND VPWR VPWR _03580_ sky130_fd_sc_hd__xnor2_1
XFILLER_16_204 VPWR VGND VPWR VGND sky130_ef_sc_hd__decap_12
XFILLER_84_693 VGND VGND VPWR VPWR sky130_fd_sc_hd__fill_1
XFILLER_83_181 VPWR VGND VPWR VGND sky130_ef_sc_hd__decap_12
XFILLER_71_343 VGND VGND VPWR VPWR sky130_fd_sc_hd__fill_1
X_13650_ clknet_3_5__leaf_clk _00033_ net719 VGND VGND VPWR VPWR net169 sky130_fd_sc_hd__dfrtp_1
XFILLER_44_579 VGND VGND VPWR VPWR sky130_fd_sc_hd__decap_8
X_10862_ _03504_ _03503_ VGND VGND VPWR VPWR _03505_ sky130_fd_sc_hd__and2b_1
XFILLER_31_207 VGND VGND VPWR VPWR sky130_fd_sc_hd__decap_4
X_13581_ _06182_ _06364_ _06363_ VGND VGND VPWR VPWR _06469_ sky130_fd_sc_hd__a21boi_1
X_12601_ _05274_ _05311_ _05310_ VGND VGND VPWR VPWR _05399_ sky130_fd_sc_hd__a21oi_1
X_10793_ _03256_ _03258_ VGND VGND VPWR VPWR _03429_ sky130_fd_sc_hd__nand2_1
XFILLER_24_281 VPWR VGND VPWR VGND sky130_ef_sc_hd__decap_12
XFILLER_25_782 VGND VGND VPWR VPWR sky130_fd_sc_hd__fill_2
X_12532_ net615 net607 net386 net369 VGND VGND VPWR VPWR _05324_ sky130_fd_sc_hd__and4_1
XFILLER_33_51 VGND VGND VPWR VPWR sky130_fd_sc_hd__decap_4
X_12463_ _05081_ _05084_ _05247_ VGND VGND VPWR VPWR _05248_ sky130_fd_sc_hd__a21o_1
XFILLER_126_813 VGND VGND VPWR VPWR sky130_fd_sc_hd__decap_8
X_11414_ _04106_ _04107_ VGND VGND VPWR VPWR _04108_ sky130_fd_sc_hd__nor2_1
XFILLER_137_161 VGND VGND VPWR VPWR sky130_fd_sc_hd__decap_6
XTAP_TAPCELL_ROW_78_1432 VGND VPWR sky130_fd_sc_hd__tapvpwrvgnd_1
X_12394_ net615 net386 VGND VGND VPWR VPWR _05173_ sky130_fd_sc_hd__nand2_1
XFILLER_99_708 VPWR VGND VPWR VGND sky130_ef_sc_hd__decap_12
XFILLER_4_642 VGND VGND VPWR VPWR sky130_fd_sc_hd__fill_2
X_11345_ _03881_ _03885_ _04031_ VGND VGND VPWR VPWR _04032_ sky130_fd_sc_hd__o21ai_1
XFILLER_125_389 VGND VGND VPWR VPWR sky130_fd_sc_hd__decap_3
XTAP_TAPCELL_ROW_91_1621 VGND VPWR sky130_fd_sc_hd__tapvpwrvgnd_1
X_11276_ net415 net276 VGND VGND VPWR VPWR _03957_ sky130_fd_sc_hd__nand2_1
XFILLER_106_581 VGND VGND VPWR VPWR sky130_fd_sc_hd__decap_6
X_13015_ _05694_ _05698_ _05695_ VGND VGND VPWR VPWR _05851_ sky130_fd_sc_hd__a21o_1
X_10227_ _02810_ VGND VGND VPWR VPWR _02811_ sky130_fd_sc_hd__inv_2
XFILLER_39_307 VGND VGND VPWR VPWR sky130_fd_sc_hd__decap_8
X_10158_ _02633_ _02666_ _02632_ VGND VGND VPWR VPWR _02740_ sky130_fd_sc_hd__a21oi_1
XFILLER_58_81 VGND VGND VPWR VPWR sky130_fd_sc_hd__decap_3
X_10089_ _02635_ _02662_ VGND VGND VPWR VPWR _02665_ sky130_fd_sc_hd__xor2_1
XFILLER_66_148 VGND VGND VPWR VPWR sky130_fd_sc_hd__fill_2
XTAP_TAPCELL_ROW_89_1583 VGND VPWR sky130_fd_sc_hd__tapvpwrvgnd_1
XFILLER_81_107 VGND VGND VPWR VPWR sky130_fd_sc_hd__decap_4
XFILLER_90_630 VGND VGND VPWR VPWR sky130_fd_sc_hd__fill_1
XTAP_TAPCELL_ROW_89_1594 VGND VPWR sky130_fd_sc_hd__tapvpwrvgnd_1
XFILLER_74_80 VGND VGND VPWR VPWR sky130_fd_sc_hd__decap_4
XFILLER_95_3 VPWR VGND VPWR VGND sky130_ef_sc_hd__decap_12
XFILLER_15_281 VPWR VGND VPWR VGND sky130_ef_sc_hd__decap_12
XFILLER_31_741 VPWR VGND VPWR VGND sky130_ef_sc_hd__decap_12
XTAP_TAPCELL_ROW_100_1750 VGND VPWR sky130_fd_sc_hd__tapvpwrvgnd_1
XFILLER_31_785 VPWR VGND VPWR VGND sky130_ef_sc_hd__decap_12
XTAP_TAPCELL_ROW_13_482 VGND VPWR sky130_fd_sc_hd__tapvpwrvgnd_1
XTAP_TAPCELL_ROW_13_493 VGND VPWR sky130_fd_sc_hd__tapvpwrvgnd_1
XFILLER_128_172 VGND VGND VPWR VPWR sky130_fd_sc_hd__decap_8
XFILLER_132_805 VGND VGND VPWR VPWR sky130_fd_sc_hd__decap_6
XFILLER_128_194 VGND VGND VPWR VPWR sky130_fd_sc_hd__fill_2
XFILLER_116_356 VGND VGND VPWR VPWR sky130_fd_sc_hd__fill_1
XFILLER_116_389 VGND VGND VPWR VPWR sky130_fd_sc_hd__decap_3
X_09941_ _02496_ _02502_ VGND VGND VPWR VPWR _02503_ sky130_fd_sc_hd__and2_1
XFILLER_104_529 VGND VGND VPWR VPWR sky130_fd_sc_hd__decap_3
XFILLER_131_337 VPWR VGND VPWR VGND sky130_ef_sc_hd__decap_12
X_09872_ _02257_ _02301_ _02300_ VGND VGND VPWR VPWR _02428_ sky130_fd_sc_hd__a21bo_1
XFILLER_58_605 VGND VGND VPWR VPWR sky130_fd_sc_hd__fill_2
X_08823_ _01287_ _01288_ VGND VGND VPWR VPWR _01289_ sky130_fd_sc_hd__xor2_1
XFILLER_97_273 VGND VGND VPWR VPWR sky130_fd_sc_hd__decap_6
XFILLER_57_126 VPWR VGND VPWR VGND sky130_ef_sc_hd__decap_12
XFILLER_38_29 VPWR VGND VPWR VGND sky130_ef_sc_hd__decap_12
X_08754_ _01217_ _01220_ _01219_ VGND VGND VPWR VPWR _01221_ sky130_fd_sc_hd__nor3b_1
XFILLER_100_757 VPWR VGND VPWR VGND sky130_ef_sc_hd__decap_12
XFILLER_73_608 VGND VGND VPWR VPWR sky130_fd_sc_hd__decap_3
XFILLER_38_340 VGND VGND VPWR VPWR sky130_fd_sc_hd__fill_2
XFILLER_54_811 VGND VGND VPWR VPWR sky130_fd_sc_hd__fill_1
XTAP_TAPCELL_ROW_49_1011 VGND VPWR sky130_fd_sc_hd__tapvpwrvgnd_1
X_07705_ _00180_ _00181_ VGND VGND VPWR VPWR _00184_ sky130_fd_sc_hd__xor2_1
XFILLER_26_513 VGND VGND VPWR VPWR sky130_fd_sc_hd__decap_3
X_08685_ _01149_ _01151_ VGND VGND VPWR VPWR _01152_ sky130_fd_sc_hd__and2b_1
XFILLER_81_641 VPWR VGND VPWR VGND sky130_ef_sc_hd__decap_12
XFILLER_65_181 VGND VGND VPWR VPWR sky130_fd_sc_hd__decap_3
XFILLER_53_310 VPWR VGND VPWR VGND sky130_ef_sc_hd__decap_12
X_07636_ _00097_ _00114_ _00115_ VGND VGND VPWR VPWR _00116_ sky130_fd_sc_hd__nand3_1
XFILLER_14_719 VPWR VGND VPWR VGND sky130_ef_sc_hd__decap_12
XFILLER_26_568 VGND VGND VPWR VPWR sky130_fd_sc_hd__decap_8
XTAP_TAPCELL_ROW_62_1200 VGND VPWR sky130_fd_sc_hd__tapvpwrvgnd_1
X_07567_ _06793_ _06794_ VGND VGND VPWR VPWR _06796_ sky130_fd_sc_hd__xor2_1
XFILLER_13_229 VGND VGND VPWR VPWR sky130_fd_sc_hd__fill_1
X_09306_ _01806_ _01810_ VGND VGND VPWR VPWR _01811_ sky130_fd_sc_hd__and2b_1
XFILLER_22_730 VGND VGND VPWR VPWR sky130_fd_sc_hd__fill_1
X_09237_ _01719_ _01734_ VGND VGND VPWR VPWR _01735_ sky130_fd_sc_hd__xor2_1
XFILLER_70_27 VGND VGND VPWR VPWR sky130_fd_sc_hd__fill_1
X_07498_ _06566_ _06726_ VGND VGND VPWR VPWR _06728_ sky130_fd_sc_hd__xor2_1
XFILLER_22_774 VPWR VGND VPWR VGND sky130_ef_sc_hd__decap_12
X_09168_ _01657_ _01658_ VGND VGND VPWR VPWR _01661_ sky130_fd_sc_hd__xnor2_1
XFILLER_108_813 VGND VGND VPWR VPWR sky130_fd_sc_hd__decap_8
XFILLER_5_428 VGND VGND VPWR VPWR sky130_fd_sc_hd__decap_8
X_09099_ _01583_ _01584_ VGND VGND VPWR VPWR _01585_ sky130_fd_sc_hd__nand2_1
XFILLER_119_194 VPWR VGND VPWR VGND sky130_ef_sc_hd__decap_12
XFILLER_107_334 VGND VGND VPWR VPWR sky130_fd_sc_hd__fill_2
X_08119_ _00560_ _00593_ VGND VGND VPWR VPWR _00595_ sky130_fd_sc_hd__xnor2_2
XFILLER_134_153 VPWR VGND VPWR VGND sky130_ef_sc_hd__decap_12
XFILLER_107_367 VGND VGND VPWR VPWR sky130_fd_sc_hd__decap_6
X_11130_ _03764_ _03797_ VGND VGND VPWR VPWR _03798_ sky130_fd_sc_hd__and2b_1
XFILLER_134_197 VGND VGND VPWR VPWR sky130_fd_sc_hd__decap_6
XTAP_TAPCELL_ROW_73_1351 VGND VPWR sky130_fd_sc_hd__tapvpwrvgnd_1
XFILLER_89_774 VGND VGND VPWR VPWR sky130_fd_sc_hd__decap_8
XFILLER_88_251 VGND VGND VPWR VPWR sky130_fd_sc_hd__fill_1
XTAP_TAPCELL_ROW_73_1362 VGND VPWR sky130_fd_sc_hd__tapvpwrvgnd_1
X_11061_ net552 net305 net302 net560 VGND VGND VPWR VPWR _03722_ sky130_fd_sc_hd__a22oi_1
X_10012_ net608 net367 _02498_ _02501_ VGND VGND VPWR VPWR _02580_ sky130_fd_sc_hd__a31o_1
XFILLER_103_584 VGND VGND VPWR VPWR sky130_fd_sc_hd__fill_1
XFILLER_103_573 VGND VGND VPWR VPWR sky130_fd_sc_hd__decap_3
XFILLER_95_57 VPWR VGND VPWR VGND sky130_ef_sc_hd__decap_12
XFILLER_89_785 VPWR VGND VPWR VGND sky130_ef_sc_hd__decap_12
XFILLER_49_627 VGND VGND VPWR VPWR sky130_fd_sc_hd__fill_1
XFILLER_84_490 VGND VGND VPWR VPWR sky130_fd_sc_hd__decap_4
X_11963_ _04700_ _04702_ VGND VGND VPWR VPWR _00004_ sky130_fd_sc_hd__and2_1
XFILLER_44_321 VGND VGND VPWR VPWR sky130_fd_sc_hd__decap_6
XFILLER_72_663 VGND VGND VPWR VPWR sky130_fd_sc_hd__decap_8
XFILLER_44_365 VGND VGND VPWR VPWR sky130_fd_sc_hd__fill_1
XFILLER_44_354 VGND VGND VPWR VPWR sky130_fd_sc_hd__decap_4
X_11894_ _04579_ _04629_ VGND VGND VPWR VPWR _04630_ sky130_fd_sc_hd__xor2_1
X_10914_ _03559_ _03560_ VGND VGND VPWR VPWR _03561_ sky130_fd_sc_hd__nand2_1
X_13633_ _04753_ _04939_ VGND VGND VPWR VPWR _00026_ sky130_fd_sc_hd__xor2_1
X_10845_ _03484_ _03485_ VGND VGND VPWR VPWR _03486_ sky130_fd_sc_hd__and2b_1
XFILLER_32_549 VGND VGND VPWR VPWR sky130_fd_sc_hd__fill_1
XFILLER_44_83 VGND VGND VPWR VPWR sky130_fd_sc_hd__fill_1
X_13564_ net246 _06449_ VGND VGND VPWR VPWR _06450_ sky130_fd_sc_hd__xor2_1
X_10776_ _03364_ _03409_ VGND VGND VPWR VPWR _03410_ sky130_fd_sc_hd__nand2b_1
XFILLER_13_763 VPWR VGND VPWR VGND sky130_ef_sc_hd__decap_12
XFILLER_13_785 VPWR VGND VPWR VGND sky130_ef_sc_hd__decap_12
XTAP_TAPCELL_ROW_30_728 VGND VPWR sky130_fd_sc_hd__tapvpwrvgnd_1
XFILLER_40_560 VGND VGND VPWR VPWR sky130_fd_sc_hd__fill_1
X_13495_ _05945_ _06257_ _06374_ VGND VGND VPWR VPWR _06375_ sky130_fd_sc_hd__o21a_1
X_12515_ _05130_ _05304_ VGND VGND VPWR VPWR _05305_ sky130_fd_sc_hd__nor2_1
XFILLER_9_767 VPWR VGND VPWR VGND sky130_ef_sc_hd__decap_12
XTAP_TAPCELL_ROW_30_739 VGND VPWR sky130_fd_sc_hd__tapvpwrvgnd_1
X_12446_ _05077_ _05226_ _05228_ VGND VGND VPWR VPWR _05229_ sky130_fd_sc_hd__o21ai_1
XFILLER_67_7 VPWR VGND VPWR VGND sky130_ef_sc_hd__decap_12
XFILLER_8_277 VPWR VGND VPWR VGND sky130_ef_sc_hd__decap_12
XTAP_TAPCELL_ROW_10_441 VGND VPWR sky130_fd_sc_hd__tapvpwrvgnd_1
X_12377_ _05150_ _05152_ _05153_ VGND VGND VPWR VPWR _05154_ sky130_fd_sc_hd__or3_1
XFILLER_126_665 VPWR VGND VPWR VGND sky130_ef_sc_hd__decap_12
XFILLER_114_805 VGND VGND VPWR VPWR sky130_fd_sc_hd__decap_6
XFILLER_99_505 VPWR VGND VPWR VGND sky130_ef_sc_hd__decap_12
X_11328_ _03873_ _04013_ VGND VGND VPWR VPWR _04015_ sky130_fd_sc_hd__and2_1
XFILLER_5_55 VGND VGND VPWR VPWR sky130_fd_sc_hd__fill_1
XFILLER_4_461 VPWR VGND VPWR VGND sky130_ef_sc_hd__decap_12
XFILLER_125_175 VPWR VGND VPWR VGND sky130_ef_sc_hd__decap_12
XFILLER_113_337 VGND VGND VPWR VPWR sky130_fd_sc_hd__decap_3
XFILLER_95_700 VPWR VGND VPWR VGND sky130_ef_sc_hd__decap_12
X_11259_ _03427_ _03936_ VGND VGND VPWR VPWR _03939_ sky130_fd_sc_hd__xnor2_1
XFILLER_94_221 VPWR VGND VPWR VGND sky130_ef_sc_hd__decap_12
XFILLER_67_457 VGND VGND VPWR VPWR sky130_fd_sc_hd__fill_2
XFILLER_10_3 VPWR VGND VPWR VGND sky130_ef_sc_hd__decap_12
XFILLER_36_811 VGND VGND VPWR VPWR sky130_fd_sc_hd__fill_1
XFILLER_94_298 VGND VGND VPWR VPWR sky130_fd_sc_hd__decap_8
XFILLER_48_693 VGND VGND VPWR VPWR sky130_fd_sc_hd__decap_6
XFILLER_47_181 VPWR VGND VPWR VGND sky130_ef_sc_hd__decap_12
XFILLER_23_505 VGND VGND VPWR VPWR sky130_fd_sc_hd__fill_1
X_08470_ _00924_ _00942_ VGND VGND VPWR VPWR _00943_ sky130_fd_sc_hd__and2b_1
X_07421_ _06647_ _06648_ _06649_ VGND VGND VPWR VPWR _06651_ sky130_fd_sc_hd__a21o_1
XTAP_TAPCELL_ROW_18_563 VGND VPWR sky130_fd_sc_hd__tapvpwrvgnd_1
XFILLER_23_516 VPWR VGND VPWR VGND sky130_ef_sc_hd__decap_12
X_07352_ _06580_ _06581_ VGND VGND VPWR VPWR _06582_ sky130_fd_sc_hd__xnor2_1
XTAP_TAPCELL_ROW_118_2008 VGND VPWR sky130_fd_sc_hd__tapvpwrvgnd_1
X_07283_ _06389_ _06400_ _06367_ VGND VGND VPWR VPWR _06421_ sky130_fd_sc_hd__o21ai_1
X_09022_ _01406_ _01500_ _01501_ VGND VGND VPWR VPWR _01502_ sky130_fd_sc_hd__nor3_1
XFILLER_129_481 VGND VGND VPWR VPWR sky130_fd_sc_hd__decap_3
XFILLER_117_643 VPWR VGND VPWR VGND sky130_ef_sc_hd__decap_12
XFILLER_117_676 VPWR VGND VPWR VGND sky130_ef_sc_hd__decap_12
XFILLER_116_153 VGND VGND VPWR VPWR sky130_fd_sc_hd__decap_8
XFILLER_116_197 VGND VGND VPWR VPWR sky130_fd_sc_hd__decap_8
XTAP_TAPCELL_ROW_113_1941 VGND VPWR sky130_fd_sc_hd__tapvpwrvgnd_1
X_09924_ _02482_ _02483_ VGND VGND VPWR VPWR _02484_ sky130_fd_sc_hd__nor2_1
XFILLER_49_39 VPWR VGND VPWR VGND sky130_ef_sc_hd__decap_12
Xfanout702 net107 VGND VGND VPWR VPWR net702 sky130_fd_sc_hd__clkbuf_2
Xfanout713 net714 VGND VGND VPWR VPWR net713 sky130_fd_sc_hd__clkbuf_4
X_09855_ _02407_ _02408_ VGND VGND VPWR VPWR _02410_ sky130_fd_sc_hd__xor2_1
XFILLER_98_582 VGND VGND VPWR VPWR sky130_fd_sc_hd__decap_6
XTAP_TAPCELL_ROW_55_1092 VGND VPWR sky130_fd_sc_hd__tapvpwrvgnd_1
X_08806_ _01085_ _01135_ _01137_ _01132_ VGND VGND VPWR VPWR _01272_ sky130_fd_sc_hd__o22ai_1
XFILLER_100_521 VGND VGND VPWR VPWR sky130_fd_sc_hd__decap_4
XFILLER_85_221 VGND VGND VPWR VPWR sky130_fd_sc_hd__decap_3
X_09786_ _02330_ _02332_ VGND VGND VPWR VPWR _02334_ sky130_fd_sc_hd__xnor2_1
XFILLER_100_587 VGND VGND VPWR VPWR sky130_fd_sc_hd__fill_1
XFILLER_73_416 VPWR VGND VPWR VGND sky130_ef_sc_hd__decap_12
X_06998_ _03270_ _03303_ VGND VGND VPWR VPWR _03314_ sky130_fd_sc_hd__and2_1
XPHY_EDGE_ROW_134_Right_134 VGND VGND VPWR VPWR sky130_fd_sc_hd__decap_3
X_08737_ _01193_ _01195_ _01194_ VGND VGND VPWR VPWR _01204_ sky130_fd_sc_hd__a21o_1
XFILLER_73_449 VGND VGND VPWR VPWR sky130_fd_sc_hd__decap_8
XFILLER_38_181 VGND VGND VPWR VPWR sky130_fd_sc_hd__decap_3
X_08668_ _01081_ _01134_ _01133_ _01082_ VGND VGND VPWR VPWR _01135_ sky130_fd_sc_hd__a2bb2o_1
XFILLER_121_77 VGND VGND VPWR VPWR sky130_fd_sc_hd__decap_3
XFILLER_121_55 VGND VGND VPWR VPWR sky130_fd_sc_hd__fill_1
X_07619_ net708 net619 net706 net628 VGND VGND VPWR VPWR _00099_ sky130_fd_sc_hd__a22o_1
XFILLER_54_696 VGND VGND VPWR VPWR sky130_fd_sc_hd__decap_4
XFILLER_53_151 VGND VGND VPWR VPWR sky130_fd_sc_hd__decap_4
XFILLER_41_324 VPWR VGND VPWR VGND sky130_ef_sc_hd__decap_12
X_08599_ _01027_ _01066_ VGND VGND VPWR VPWR _01067_ sky130_fd_sc_hd__nand2_1
XFILLER_81_37 VPWR VGND VPWR VGND sky130_ef_sc_hd__decap_12
X_10630_ _03108_ _03250_ VGND VGND VPWR VPWR _03251_ sky130_fd_sc_hd__nor2_1
XFILLER_41_379 VPWR VGND VPWR VGND sky130_ef_sc_hd__decap_12
XFILLER_14_53 VPWR VGND VPWR VGND sky130_ef_sc_hd__decap_12
XFILLER_22_593 VGND VGND VPWR VPWR sky130_fd_sc_hd__decap_6
X_10561_ _03154_ _03173_ _03175_ VGND VGND VPWR VPWR _03176_ sky130_fd_sc_hd__or3_4
X_12300_ _05069_ _05070_ VGND VGND VPWR VPWR _00035_ sky130_fd_sc_hd__and2b_1
X_13280_ _06125_ _06137_ VGND VGND VPWR VPWR _06141_ sky130_fd_sc_hd__xor2_1
X_10492_ _03086_ _03099_ VGND VGND VPWR VPWR _03100_ sky130_fd_sc_hd__xnor2_1
XFILLER_108_643 VGND VGND VPWR VPWR sky130_fd_sc_hd__fill_1
X_12231_ _04994_ _04971_ VGND VGND VPWR VPWR _04995_ sky130_fd_sc_hd__and2b_1
XFILLER_5_225 VGND VGND VPWR VPWR sky130_fd_sc_hd__decap_8
XFILLER_30_41 VPWR VGND VPWR VGND sky130_ef_sc_hd__decap_12
XFILLER_108_665 VGND VGND VPWR VPWR sky130_fd_sc_hd__fill_1
XFILLER_107_142 VGND VGND VPWR VPWR sky130_fd_sc_hd__decap_6
XFILLER_5_269 VGND VGND VPWR VPWR sky130_fd_sc_hd__fill_1
X_12162_ _04722_ _04732_ _04912_ _04919_ VGND VGND VPWR VPWR _04920_ sky130_fd_sc_hd__a211o_1
X_12093_ _04717_ _04843_ VGND VGND VPWR VPWR _04844_ sky130_fd_sc_hd__and2_1
XFILLER_1_453 VGND VGND VPWR VPWR sky130_fd_sc_hd__fill_1
X_11113_ _03775_ _03776_ _03777_ VGND VGND VPWR VPWR _03779_ sky130_fd_sc_hd__a21o_1
XFILLER_122_189 VGND VGND VPWR VPWR sky130_fd_sc_hd__fill_2
XFILLER_103_370 VPWR VGND VPWR VGND sky130_ef_sc_hd__decap_12
XFILLER_77_711 VPWR VGND VPWR VGND sky130_ef_sc_hd__decap_12
X_11044_ _03701_ _03702_ VGND VGND VPWR VPWR _03704_ sky130_fd_sc_hd__nand2b_1
XFILLER_1_475 VGND VGND VPWR VPWR sky130_fd_sc_hd__fill_2
XFILLER_64_405 VGND VGND VPWR VPWR sky130_fd_sc_hd__fill_1
XFILLER_49_479 VGND VGND VPWR VPWR sky130_fd_sc_hd__decap_6
XFILLER_18_811 VGND VGND VPWR VPWR sky130_fd_sc_hd__fill_1
XPHY_EDGE_ROW_101_Right_101 VGND VGND VPWR VPWR sky130_fd_sc_hd__decap_3
X_12995_ _05815_ _05828_ VGND VGND VPWR VPWR _05829_ sky130_fd_sc_hd__nor2_1
XFILLER_57_490 VPWR VGND VPWR VGND sky130_ef_sc_hd__decap_12
XTAP_TAPCELL_ROW_86_1553 VGND VPWR sky130_fd_sc_hd__tapvpwrvgnd_1
XTAP_TAPCELL_ROW_86_1542 VGND VPWR sky130_fd_sc_hd__tapvpwrvgnd_1
X_11946_ net529 net523 net406 VGND VGND VPWR VPWR _04684_ sky130_fd_sc_hd__and3_1
XFILLER_45_663 VGND VGND VPWR VPWR sky130_fd_sc_hd__decap_8
XTAP_TAPCELL_ROW_35_809 VGND VPWR sky130_fd_sc_hd__tapvpwrvgnd_1
XFILLER_60_622 VPWR VGND VPWR VGND sky130_ef_sc_hd__decap_12
XFILLER_55_93 VPWR VGND VPWR VGND sky130_ef_sc_hd__decap_12
XTAP_TAPCELL_ROW_15_511 VGND VPWR sky130_fd_sc_hd__tapvpwrvgnd_1
XFILLER_60_655 VGND VGND VPWR VPWR sky130_fd_sc_hd__decap_3
XFILLER_44_195 VGND VGND VPWR VPWR sky130_fd_sc_hd__fill_1
X_11877_ _04610_ _04611_ VGND VGND VPWR VPWR _04612_ sky130_fd_sc_hd__nand2b_1
XTAP_TAPCELL_ROW_15_522 VGND VPWR sky130_fd_sc_hd__tapvpwrvgnd_1
X_13616_ _06492_ _06505_ VGND VGND VPWR VPWR _06506_ sky130_fd_sc_hd__xnor2_1
X_10828_ net599 _01431_ _03465_ _03466_ VGND VGND VPWR VPWR _03468_ sky130_fd_sc_hd__a22o_1
X_13547_ _06333_ _06430_ VGND VGND VPWR VPWR _06431_ sky130_fd_sc_hd__xor2_1
X_10759_ _03253_ _03263_ _03262_ VGND VGND VPWR VPWR _03392_ sky130_fd_sc_hd__a21o_1
X_13478_ _06248_ _06277_ _06246_ VGND VGND VPWR VPWR _06357_ sky130_fd_sc_hd__a21oi_1
X_12429_ _05209_ _05208_ _04965_ _04968_ VGND VGND VPWR VPWR _05212_ sky130_fd_sc_hd__a211o_1
XFILLER_58_3 VPWR VGND VPWR VGND sky130_ef_sc_hd__decap_12
XFILLER_99_335 VGND VGND VPWR VPWR sky130_fd_sc_hd__fill_1
X_07970_ _00306_ _00310_ _00446_ VGND VGND VPWR VPWR _00447_ sky130_fd_sc_hd__o21a_1
XFILLER_101_307 VGND VGND VPWR VPWR sky130_fd_sc_hd__decap_6
X_06921_ net519 net684 VGND VGND VPWR VPWR _02477_ sky130_fd_sc_hd__nand2_1
XFILLER_95_541 VGND VGND VPWR VPWR sky130_fd_sc_hd__decap_6
XFILLER_68_755 VGND VGND VPWR VPWR sky130_fd_sc_hd__fill_1
X_09640_ _01860_ _01861_ _02024_ VGND VGND VPWR VPWR _02176_ sky130_fd_sc_hd__or3_1
XFILLER_83_725 VGND VGND VPWR VPWR sky130_fd_sc_hd__decap_3
X_06852_ net687 net519 VGND VGND VPWR VPWR _01725_ sky130_fd_sc_hd__nand2_1
X_09571_ _01933_ _01940_ _01939_ VGND VGND VPWR VPWR _02100_ sky130_fd_sc_hd__a21oi_1
XFILLER_55_449 VGND VGND VPWR VPWR sky130_fd_sc_hd__decap_3
XFILLER_82_246 VGND VGND VPWR VPWR sky130_fd_sc_hd__decap_6
XFILLER_24_803 VGND VGND VPWR VPWR sky130_fd_sc_hd__decap_8
X_08522_ _00948_ _00952_ _00993_ VGND VGND VPWR VPWR _00994_ sky130_fd_sc_hd__a21boi_1
XFILLER_91_780 VGND VGND VPWR VPWR sky130_fd_sc_hd__decap_4
X_08453_ _00567_ _00853_ _00692_ VGND VGND VPWR VPWR _00926_ sky130_fd_sc_hd__or3b_1
X_07404_ _06632_ _06633_ VGND VGND VPWR VPWR _06634_ sky130_fd_sc_hd__xnor2_2
XFILLER_51_655 VGND VGND VPWR VPWR sky130_fd_sc_hd__fill_2
XFILLER_51_644 VGND VGND VPWR VPWR sky130_fd_sc_hd__fill_2
XFILLER_23_324 VPWR VGND VPWR VGND sky130_ef_sc_hd__decap_12
XFILLER_50_165 VGND VGND VPWR VPWR sky130_fd_sc_hd__fill_2
X_08384_ _00693_ _00855_ _00856_ VGND VGND VPWR VPWR _00858_ sky130_fd_sc_hd__and3_1
XFILLER_137_705 VGND VGND VPWR VPWR sky130_fd_sc_hd__decap_3
X_07335_ _05428_ _05450_ _06564_ _06565_ VGND VGND VPWR VPWR _06566_ sky130_fd_sc_hd__o211ai_2
XFILLER_109_407 VGND VGND VPWR VPWR sky130_fd_sc_hd__decap_4
X_07266_ _06192_ _06214_ VGND VGND VPWR VPWR _06236_ sky130_fd_sc_hd__xnor2_1
XFILLER_136_226 VGND VGND VPWR VPWR sky130_fd_sc_hd__decap_4
X_09005_ _01473_ _01481_ _01482_ VGND VGND VPWR VPWR _01483_ sky130_fd_sc_hd__nand3_1
XTAP_TAPCELL_ROW_57_1121 VGND VPWR sky130_fd_sc_hd__tapvpwrvgnd_1
X_07197_ _05461_ _05472_ VGND VGND VPWR VPWR _05483_ sky130_fd_sc_hd__and2_1
XFILLER_132_421 VPWR VGND VPWR VGND sky130_ef_sc_hd__decap_12
XTAP_TAPCELL_ROW_57_1132 VGND VPWR sky130_fd_sc_hd__tapvpwrvgnd_1
XFILLER_3_729 VPWR VGND VPWR VGND sky130_ef_sc_hd__decap_12
XFILLER_120_605 VGND VGND VPWR VPWR sky130_fd_sc_hd__fill_1
XFILLER_104_156 VGND VGND VPWR VPWR sky130_fd_sc_hd__decap_4
X_09907_ net540 net354 net356 net265 VGND VGND VPWR VPWR _02465_ sky130_fd_sc_hd__o2bb2a_1
XFILLER_76_15 VPWR VGND VPWR VGND sky130_ef_sc_hd__decap_12
XTAP_TAPCELL_ROW_70_1321 VGND VPWR sky130_fd_sc_hd__tapvpwrvgnd_1
XTAP_TAPCELL_ROW_70_1310 VGND VPWR sky130_fd_sc_hd__tapvpwrvgnd_1
Xfanout532 net534 VGND VGND VPWR VPWR net532 sky130_fd_sc_hd__clkbuf_4
Xfanout510 net513 VGND VGND VPWR VPWR net510 sky130_fd_sc_hd__clkbuf_4
Xfanout521 net147 VGND VGND VPWR VPWR net521 sky130_fd_sc_hd__buf_4
XFILLER_116_77 VGND VGND VPWR VPWR sky130_fd_sc_hd__decap_6
Xfanout565 net566 VGND VGND VPWR VPWR net565 sky130_fd_sc_hd__buf_2
XFILLER_58_232 VGND VGND VPWR VPWR sky130_fd_sc_hd__decap_8
XFILLER_58_221 VGND VGND VPWR VPWR sky130_fd_sc_hd__decap_4
Xfanout543 net144 VGND VGND VPWR VPWR net543 sky130_fd_sc_hd__clkbuf_4
Xfanout554 net559 VGND VGND VPWR VPWR net554 sky130_fd_sc_hd__clkbuf_4
Xfanout587 net139 VGND VGND VPWR VPWR net587 sky130_fd_sc_hd__clkbuf_4
Xfanout576 net140 VGND VGND VPWR VPWR net576 sky130_fd_sc_hd__buf_2
X_09838_ _02139_ _02390_ VGND VGND VPWR VPWR _02392_ sky130_fd_sc_hd__xor2_1
XFILLER_86_585 VGND VGND VPWR VPWR sky130_fd_sc_hd__decap_3
XFILLER_74_725 VGND VGND VPWR VPWR sky130_fd_sc_hd__fill_1
Xfanout598 net137 VGND VGND VPWR VPWR net598 sky130_fd_sc_hd__clkbuf_4
XFILLER_59_788 VPWR VGND VPWR VGND sky130_ef_sc_hd__decap_12
XFILLER_58_265 VGND VGND VPWR VPWR sky130_fd_sc_hd__fill_1
X_09769_ _02028_ _02316_ VGND VGND VPWR VPWR _02317_ sky130_fd_sc_hd__xor2_2
XFILLER_100_384 VGND VGND VPWR VPWR sky130_fd_sc_hd__decap_8
XFILLER_86_596 VPWR VGND VPWR VGND sky130_ef_sc_hd__decap_12
XFILLER_46_427 VGND VGND VPWR VPWR sky130_fd_sc_hd__decap_8
XFILLER_132_65 VPWR VGND VPWR VGND sky130_ef_sc_hd__decap_12
X_11800_ _04495_ _04528_ VGND VGND VPWR VPWR _04529_ sky130_fd_sc_hd__xnor2_1
X_12780_ _05592_ _05593_ VGND VGND VPWR VPWR _05594_ sky130_fd_sc_hd__nand2b_1
XTAP_TAPCELL_ROW_68_1283 VGND VPWR sky130_fd_sc_hd__tapvpwrvgnd_1
XFILLER_54_471 VGND VGND VPWR VPWR sky130_fd_sc_hd__decap_4
XFILLER_14_313 VGND VGND VPWR VPWR sky130_fd_sc_hd__fill_1
XFILLER_26_173 VGND VGND VPWR VPWR sky130_fd_sc_hd__decap_4
XFILLER_27_685 VGND VGND VPWR VPWR sky130_fd_sc_hd__decap_4
XFILLER_41_110 VGND VGND VPWR VPWR sky130_fd_sc_hd__fill_2
X_11731_ _04452_ VGND VGND VPWR VPWR _04453_ sky130_fd_sc_hd__inv_2
XFILLER_26_195 VGND VGND VPWR VPWR sky130_fd_sc_hd__fill_1
X_11662_ _04377_ _04376_ VGND VGND VPWR VPWR _04378_ sky130_fd_sc_hd__and2b_1
X_13401_ _06259_ _06272_ VGND VGND VPWR VPWR _06273_ sky130_fd_sc_hd__xnor2_1
XTAP_TAPCELL_ROW_81_1472 VGND VPWR sky130_fd_sc_hd__tapvpwrvgnd_1
X_10613_ _03230_ _03231_ VGND VGND VPWR VPWR _03232_ sky130_fd_sc_hd__xnor2_1
X_11593_ _04301_ _04300_ _04302_ _04298_ VGND VGND VPWR VPWR _04303_ sky130_fd_sc_hd__a31oi_4
X_13332_ net247 _06195_ VGND VGND VPWR VPWR _06197_ sky130_fd_sc_hd__xnor2_1
X_10544_ net623 net326 net324 net631 VGND VGND VPWR VPWR _03157_ sky130_fd_sc_hd__a22o_1
XTAP_TAPCELL_ROW_40_878 VGND VPWR sky130_fd_sc_hd__tapvpwrvgnd_1
XFILLER_41_51 VGND VGND VPWR VPWR sky130_fd_sc_hd__decap_4
X_13263_ _06111_ _06120_ VGND VGND VPWR VPWR _06122_ sky130_fd_sc_hd__xnor2_1
XFILLER_6_556 VGND VGND VPWR VPWR sky130_fd_sc_hd__fill_2
X_10475_ net546 net313 VGND VGND VPWR VPWR _03081_ sky130_fd_sc_hd__nand2_1
XTAP_TAPCELL_ROW_20_591 VGND VPWR sky130_fd_sc_hd__tapvpwrvgnd_1
XFILLER_136_793 VPWR VGND VPWR VGND sky130_ef_sc_hd__decap_12
XFILLER_135_281 VGND VGND VPWR VPWR sky130_fd_sc_hd__decap_4
XFILLER_123_410 VGND VGND VPWR VPWR sky130_fd_sc_hd__decap_6
X_13194_ _06038_ _06045_ VGND VGND VPWR VPWR _06046_ sky130_fd_sc_hd__xnor2_1
X_12214_ _04973_ _04974_ _04975_ VGND VGND VPWR VPWR _04976_ sky130_fd_sc_hd__nand3b_1
XFILLER_6_589 VPWR VGND VPWR VGND sky130_ef_sc_hd__decap_12
XFILLER_97_817 VGND VGND VPWR VPWR sky130_fd_sc_hd__decap_3
X_12145_ _04890_ _04892_ _04895_ _04899_ VGND VGND VPWR VPWR _04901_ sky130_fd_sc_hd__o211a_1
X_12076_ _04823_ _04824_ VGND VGND VPWR VPWR _04825_ sky130_fd_sc_hd__or2_1
X_11027_ _03652_ _03683_ _03684_ VGND VGND VPWR VPWR _03685_ sky130_fd_sc_hd__nand3_1
XFILLER_37_405 VPWR VGND VPWR VGND sky130_ef_sc_hd__decap_12
XFILLER_92_533 VPWR VGND VPWR VGND sky130_ef_sc_hd__decap_12
XFILLER_92_522 VGND VGND VPWR VPWR sky130_fd_sc_hd__decap_8
XFILLER_18_652 VGND VGND VPWR VPWR sky130_fd_sc_hd__fill_2
X_12978_ _05780_ _05809_ VGND VGND VPWR VPWR _05811_ sky130_fd_sc_hd__and2b_1
XFILLER_52_419 VGND VGND VPWR VPWR sky130_fd_sc_hd__fill_1
XTAP_TAPCELL_ROW_48_989 VGND VPWR sky130_fd_sc_hd__tapvpwrvgnd_1
XFILLER_18_674 VGND VGND VPWR VPWR sky130_fd_sc_hd__fill_2
X_11929_ _04662_ _04663_ _04664_ VGND VGND VPWR VPWR _04667_ sky130_fd_sc_hd__o21a_1
XFILLER_32_121 VPWR VGND VPWR VGND sky130_ef_sc_hd__decap_12
XFILLER_60_474 VGND VGND VPWR VPWR sky130_fd_sc_hd__fill_2
XFILLER_32_165 VPWR VGND VPWR VGND sky130_ef_sc_hd__decap_12
XFILLER_33_688 VGND VGND VPWR VPWR sky130_fd_sc_hd__decap_4
XANTENNA_17 net441 VGND VGND VPWR VPWR sky130_fd_sc_hd__diode_2
XTAP_TAPCELL_ROW_99_1733 VGND VPWR sky130_fd_sc_hd__tapvpwrvgnd_1
X_07120_ _04613_ _04623_ _04634_ VGND VGND VPWR VPWR _04645_ sky130_fd_sc_hd__and3_1
XFILLER_9_372 VGND VGND VPWR VPWR sky130_fd_sc_hd__decap_3
X_07051_ _03117_ _03861_ _03872_ VGND VGND VPWR VPWR _03893_ sky130_fd_sc_hd__or3_2
Xoutput168 net168 VGND VGND VPWR VPWR y0[15] sky130_fd_sc_hd__buf_2
XPHY_EDGE_ROW_120_Left_259 VGND VGND VPWR VPWR sky130_fd_sc_hd__decap_3
XTAP_TAPCELL_ROW_110_1900 VGND VPWR sky130_fd_sc_hd__tapvpwrvgnd_1
XFILLER_88_806 VGND VGND VPWR VPWR sky130_fd_sc_hd__decap_6
Xoutput179 net179 VGND VGND VPWR VPWR y1[0] sky130_fd_sc_hd__buf_2
XFILLER_114_465 VGND VGND VPWR VPWR sky130_fd_sc_hd__decap_8
XFILLER_101_137 VPWR VGND VPWR VGND sky130_ef_sc_hd__decap_12
XTAP_TAPCELL_ROW_52_1051 VGND VPWR sky130_fd_sc_hd__tapvpwrvgnd_1
X_07953_ net245 _00311_ _00313_ _00315_ VGND VGND VPWR VPWR _00430_ sky130_fd_sc_hd__o31a_1
XTAP_TAPCELL_ROW_126_2129 VGND VPWR sky130_fd_sc_hd__tapvpwrvgnd_1
XFILLER_110_660 VGND VGND VPWR VPWR sky130_fd_sc_hd__fill_1
X_07884_ _00336_ _00361_ VGND VGND VPWR VPWR _00362_ sky130_fd_sc_hd__and2b_1
X_06904_ net703 net569 _02260_ _02271_ VGND VGND VPWR VPWR _02293_ sky130_fd_sc_hd__o2bb2a_1
X_09623_ _02155_ _02156_ VGND VGND VPWR VPWR _02157_ sky130_fd_sc_hd__nand2b_1
X_06835_ _01486_ _01497_ _01508_ VGND VGND VPWR VPWR _01540_ sky130_fd_sc_hd__o21a_1
XFILLER_55_202 VGND VGND VPWR VPWR sky130_fd_sc_hd__fill_1
XFILLER_46_29 VPWR VGND VPWR VGND sky130_ef_sc_hd__decap_12
XFILLER_83_555 VGND VGND VPWR VPWR sky130_fd_sc_hd__decap_4
X_09554_ _02079_ _02080_ VGND VGND VPWR VPWR _02081_ sky130_fd_sc_hd__xnor2_1
XTAP_TAPCELL_ROW_108_1862 VGND VPWR sky130_fd_sc_hd__tapvpwrvgnd_1
XFILLER_70_227 VGND VGND VPWR VPWR sky130_fd_sc_hd__fill_1
XFILLER_43_419 VGND VGND VPWR VPWR sky130_fd_sc_hd__fill_1
X_09485_ _02003_ _02004_ VGND VGND VPWR VPWR _02006_ sky130_fd_sc_hd__xnor2_1
X_08505_ _00377_ _00813_ _00743_ VGND VGND VPWR VPWR _00977_ sky130_fd_sc_hd__mux2_1
XFILLER_23_121 VGND VGND VPWR VPWR sky130_fd_sc_hd__decap_8
X_08436_ _00907_ _00908_ VGND VGND VPWR VPWR _00909_ sky130_fd_sc_hd__nor2_1
XFILLER_23_165 VGND VGND VPWR VPWR sky130_fd_sc_hd__decap_3
X_08367_ _00825_ _00840_ VGND VGND VPWR VPWR _00841_ sky130_fd_sc_hd__xnor2_1
XFILLER_23_187 VGND VGND VPWR VPWR sky130_fd_sc_hd__fill_1
X_07318_ _06546_ _06547_ _06529_ VGND VGND VPWR VPWR _06549_ sky130_fd_sc_hd__a21oi_1
XFILLER_11_349 VGND VGND VPWR VPWR sky130_fd_sc_hd__decap_3
X_08298_ _00771_ _00772_ VGND VGND VPWR VPWR _00773_ sky130_fd_sc_hd__nor2_1
XFILLER_137_579 VGND VGND VPWR VPWR sky130_fd_sc_hd__decap_3
XFILLER_109_259 VPWR VGND VPWR VGND sky130_ef_sc_hd__decap_12
X_07249_ net512 net683 net685 net504 VGND VGND VPWR VPWR _06050_ sky130_fd_sc_hd__nand4_1
X_10260_ _02843_ _02845_ VGND VGND VPWR VPWR _02847_ sky130_fd_sc_hd__xnor2_1
XFILLER_133_763 VPWR VGND VPWR VGND sky130_ef_sc_hd__decap_12
XFILLER_117_281 VGND VGND VPWR VPWR sky130_fd_sc_hd__decap_4
XFILLER_3_559 VGND VGND VPWR VPWR sky130_fd_sc_hd__fill_1
XFILLER_133_785 VPWR VGND VPWR VGND sky130_ef_sc_hd__decap_12
XFILLER_132_273 VGND VGND VPWR VPWR sky130_fd_sc_hd__decap_8
XFILLER_132_251 VGND VGND VPWR VPWR sky130_fd_sc_hd__fill_1
X_10191_ _02596_ _02690_ _02689_ VGND VGND VPWR VPWR _02775_ sky130_fd_sc_hd__o21a_1
XFILLER_78_316 VGND VGND VPWR VPWR sky130_fd_sc_hd__decap_3
XFILLER_78_305 VGND VGND VPWR VPWR sky130_fd_sc_hd__decap_3
Xfanout340 net59 VGND VGND VPWR VPWR net340 sky130_fd_sc_hd__buf_1
XFILLER_87_69 VPWR VGND VPWR VGND sky130_ef_sc_hd__decap_12
Xfanout362 net45 VGND VGND VPWR VPWR net362 sky130_fd_sc_hd__clkbuf_2
Xfanout351 net51 VGND VGND VPWR VPWR net351 sky130_fd_sc_hd__buf_2
Xfanout373 net37 VGND VGND VPWR VPWR net373 sky130_fd_sc_hd__clkbuf_4
Xfanout384 net30 VGND VGND VPWR VPWR net384 sky130_fd_sc_hd__buf_2
XFILLER_59_552 VGND VGND VPWR VPWR sky130_fd_sc_hd__decap_8
XTAP_TAPCELL_ROW_6_386 VGND VPWR sky130_fd_sc_hd__tapvpwrvgnd_1
X_12901_ _05394_ _05726_ VGND VGND VPWR VPWR _05727_ sky130_fd_sc_hd__xnor2_1
Xfanout395 net25 VGND VGND VPWR VPWR net395 sky130_fd_sc_hd__clkbuf_4
XFILLER_47_758 VPWR VGND VPWR VGND sky130_ef_sc_hd__decap_12
XFILLER_19_449 VGND VGND VPWR VPWR sky130_fd_sc_hd__fill_1
XTAP_TAPCELL_ROW_83_1501 VGND VPWR sky130_fd_sc_hd__tapvpwrvgnd_1
X_12832_ _05470_ _05479_ _05478_ VGND VGND VPWR VPWR _05651_ sky130_fd_sc_hd__a21oi_1
XFILLER_55_780 VGND VGND VPWR VPWR sky130_fd_sc_hd__decap_4
XFILLER_34_408 VGND VGND VPWR VPWR sky130_fd_sc_hd__decap_4
XFILLER_34_419 VGND VGND VPWR VPWR sky130_fd_sc_hd__fill_1
X_12763_ _05402_ _05574_ VGND VGND VPWR VPWR _05575_ sky130_fd_sc_hd__xor2_1
XFILLER_61_249 VGND VGND VPWR VPWR sky130_fd_sc_hd__decap_6
XTAP_TAPCELL_ROW_45_948 VGND VPWR sky130_fd_sc_hd__tapvpwrvgnd_1
XFILLER_15_644 VPWR VGND VPWR VGND sky130_ef_sc_hd__decap_12
XTAP_TAPCELL_ROW_25_661 VGND VPWR sky130_fd_sc_hd__tapvpwrvgnd_1
X_11714_ _03455_ _04354_ _04353_ VGND VGND VPWR VPWR _04434_ sky130_fd_sc_hd__a21oi_1
X_12694_ net445 net383 _05498_ _05499_ VGND VGND VPWR VPWR _05501_ sky130_fd_sc_hd__nand4_1
XFILLER_30_625 VPWR VGND VPWR VGND sky130_ef_sc_hd__decap_12
XFILLER_52_83 VGND VGND VPWR VPWR sky130_fd_sc_hd__fill_1
X_11645_ _04349_ _04357_ VGND VGND VPWR VPWR _04359_ sky130_fd_sc_hd__xnor2_1
Xinput15 w01[5] VGND VGND VPWR VPWR net15 sky130_fd_sc_hd__buf_1
Xinput37 w10[3] VGND VGND VPWR VPWR net37 sky130_fd_sc_hd__clkbuf_2
Xinput26 w03[0] VGND VGND VPWR VPWR net26 sky130_fd_sc_hd__clkbuf_2
X_11576_ _04066_ _04150_ _04149_ VGND VGND VPWR VPWR _04284_ sky130_fd_sc_hd__a21oi_1
XFILLER_7_821 VGND VGND VPWR VPWR sky130_fd_sc_hd__decap_3
Xinput59 w13[1] VGND VGND VPWR VPWR net59 sky130_fd_sc_hd__buf_1
Xinput48 w11[6] VGND VGND VPWR VPWR net48 sky130_fd_sc_hd__clkbuf_1
X_13315_ _06176_ _06177_ VGND VGND VPWR VPWR _06178_ sky130_fd_sc_hd__and2b_1
X_10527_ net458 net450 net276 net278 VGND VGND VPWR VPWR _03138_ sky130_fd_sc_hd__and4_1
X_13246_ net613 net284 VGND VGND VPWR VPWR _06103_ sky130_fd_sc_hd__nand2_1
X_10458_ _03055_ _03058_ _03057_ VGND VGND VPWR VPWR _03064_ sky130_fd_sc_hd__a21o_1
XTAP_TAPCELL_ROW_94_1663 VGND VPWR sky130_fd_sc_hd__tapvpwrvgnd_1
X_13177_ _05879_ _05884_ VGND VGND VPWR VPWR _06028_ sky130_fd_sc_hd__or2_1
X_10389_ net654 net643 net319 net322 VGND VGND VPWR VPWR _02988_ sky130_fd_sc_hd__nand4_1
X_12128_ net471 net29 VGND VGND VPWR VPWR _04883_ sky130_fd_sc_hd__and2_1
XFILLER_2_592 VGND VGND VPWR VPWR sky130_fd_sc_hd__decap_6
X_12059_ _04804_ _04806_ VGND VGND VPWR VPWR _04807_ sky130_fd_sc_hd__and2_1
XFILLER_84_319 VPWR VGND VPWR VGND sky130_ef_sc_hd__decap_12
XFILLER_77_393 VGND VGND VPWR VPWR sky130_fd_sc_hd__decap_4
XFILLER_65_511 VGND VGND VPWR VPWR sky130_fd_sc_hd__fill_1
XFILLER_37_213 VGND VGND VPWR VPWR sky130_fd_sc_hd__fill_1
XFILLER_37_235 VGND VGND VPWR VPWR sky130_fd_sc_hd__decap_3
XTAP_TAPCELL_ROW_121_2059 VGND VPWR sky130_fd_sc_hd__tapvpwrvgnd_1
XTAP_TAPCELL_ROW_121_2048 VGND VPWR sky130_fd_sc_hd__tapvpwrvgnd_1
XFILLER_80_558 VGND VGND VPWR VPWR sky130_fd_sc_hd__fill_1
XFILLER_46_791 VPWR VGND VPWR VGND sky130_ef_sc_hd__decap_12
X_09270_ _01764_ _01770_ VGND VGND VPWR VPWR _01772_ sky130_fd_sc_hd__xor2_1
XFILLER_20_113 VGND VGND VPWR VPWR sky130_fd_sc_hd__decap_3
XFILLER_33_474 VGND VGND VPWR VPWR sky130_fd_sc_hd__decap_6
X_08221_ _00693_ _00694_ _00692_ VGND VGND VPWR VPWR _00696_ sky130_fd_sc_hd__o21ai_1
XTAP_TAPCELL_ROW_103_1792 VGND VPWR sky130_fd_sc_hd__tapvpwrvgnd_1
XFILLER_60_293 VGND VGND VPWR VPWR sky130_fd_sc_hd__fill_1
X_08152_ _06659_ _00528_ _00527_ VGND VGND VPWR VPWR _00628_ sky130_fd_sc_hd__o21bai_1
X_08083_ _00557_ _00558_ VGND VGND VPWR VPWR _00559_ sky130_fd_sc_hd__and2b_1
X_07103_ _02975_ _04449_ VGND VGND VPWR VPWR _04460_ sky130_fd_sc_hd__xor2_1
XFILLER_134_527 VGND VGND VPWR VPWR sky130_fd_sc_hd__decap_4
X_07034_ _03675_ _03686_ _03664_ VGND VGND VPWR VPWR _03708_ sky130_fd_sc_hd__a21bo_1
XFILLER_115_785 VPWR VGND VPWR VGND sky130_ef_sc_hd__decap_12
XFILLER_114_251 VGND VGND VPWR VPWR sky130_fd_sc_hd__fill_1
XFILLER_130_755 VGND VGND VPWR VPWR sky130_fd_sc_hd__fill_1
XFILLER_114_295 VGND VGND VPWR VPWR sky130_fd_sc_hd__decap_3
X_08985_ _01439_ _01460_ VGND VGND VPWR VPWR _01461_ sky130_fd_sc_hd__xor2_1
XFILLER_102_413 VGND VGND VPWR VPWR sky130_fd_sc_hd__decap_6
XFILLER_88_636 VGND VGND VPWR VPWR sky130_fd_sc_hd__decap_8
XFILLER_87_113 VGND VGND VPWR VPWR sky130_fd_sc_hd__fill_2
XFILLER_76_809 VGND VGND VPWR VPWR sky130_fd_sc_hd__decap_3
XFILLER_75_319 VGND VGND VPWR VPWR sky130_fd_sc_hd__decap_4
XFILLER_57_39 VPWR VGND VPWR VGND sky130_ef_sc_hd__decap_12
X_07936_ _00411_ _00412_ VGND VGND VPWR VPWR _00414_ sky130_fd_sc_hd__xnor2_2
XTAP_TAPCELL_ROW_3_345 VGND VPWR sky130_fd_sc_hd__tapvpwrvgnd_1
XFILLER_29_725 VGND VGND VPWR VPWR sky130_fd_sc_hd__decap_3
X_07867_ _00343_ _00344_ VGND VGND VPWR VPWR _00345_ sky130_fd_sc_hd__xor2_1
X_09606_ _02128_ _02137_ VGND VGND VPWR VPWR _02138_ sky130_fd_sc_hd__xor2_2
XFILLER_73_27 VPWR VGND VPWR VGND sky130_ef_sc_hd__decap_12
X_07798_ _00275_ _00276_ VGND VGND VPWR VPWR _00277_ sky130_fd_sc_hd__and2b_1
XFILLER_44_728 VPWR VGND VPWR VGND sky130_ef_sc_hd__decap_12
X_06818_ net532 VGND VGND VPWR VPWR _01355_ sky130_fd_sc_hd__inv_2
X_09537_ _02055_ _02061_ VGND VGND VPWR VPWR _02062_ sky130_fd_sc_hd__and2_1
XFILLER_71_569 VGND VGND VPWR VPWR sky130_fd_sc_hd__decap_6
XTAP_TAPCELL_ROW_65_1242 VGND VPWR sky130_fd_sc_hd__tapvpwrvgnd_1
XTAP_TAPCELL_ROW_42_907 VGND VPWR sky130_fd_sc_hd__tapvpwrvgnd_1
X_09468_ _01985_ _01986_ VGND VGND VPWR VPWR _01988_ sky130_fd_sc_hd__nor2_1
XFILLER_12_614 VGND VGND VPWR VPWR sky130_fd_sc_hd__decap_6
X_09399_ _01782_ _01801_ _01800_ VGND VGND VPWR VPWR _01913_ sky130_fd_sc_hd__o21ba_1
XFILLER_51_293 VGND VGND VPWR VPWR sky130_fd_sc_hd__decap_6
XTAP_TAPCELL_ROW_22_620 VGND VPWR sky130_fd_sc_hd__tapvpwrvgnd_1
X_08419_ _00675_ _00685_ _00793_ _00794_ VGND VGND VPWR VPWR _00893_ sky130_fd_sc_hd__o31a_1
XFILLER_7_128 VPWR VGND VPWR VGND sky130_ef_sc_hd__decap_12
X_11430_ _04122_ _04124_ VGND VGND VPWR VPWR _04126_ sky130_fd_sc_hd__xor2_1
XFILLER_137_332 VGND VGND VPWR VPWR sky130_fd_sc_hd__decap_4
XFILLER_125_505 VGND VGND VPWR VPWR sky130_fd_sc_hd__decap_6
XFILLER_125_3 VPWR VGND VPWR VGND sky130_ef_sc_hd__decap_12
X_11361_ _04049_ _03745_ VGND VGND VPWR VPWR _04050_ sky130_fd_sc_hd__nand2b_1
XFILLER_22_53 VGND VGND VPWR VPWR sky130_fd_sc_hd__decap_8
XFILLER_22_64 VPWR VGND VPWR VGND sky130_ef_sc_hd__decap_12
XFILLER_138_53 VGND VGND VPWR VPWR sky130_fd_sc_hd__decap_3
XFILLER_125_516 VGND VGND VPWR VPWR sky130_fd_sc_hd__decap_8
X_13100_ _05942_ _05943_ VGND VGND VPWR VPWR _05944_ sky130_fd_sc_hd__nor2_1
XFILLER_4_813 VGND VGND VPWR VPWR sky130_fd_sc_hd__decap_8
X_10312_ _02863_ _02902_ VGND VGND VPWR VPWR _02903_ sky130_fd_sc_hd__nor2_1
XFILLER_138_97 VPWR VGND VPWR VGND sky130_ef_sc_hd__decap_12
XFILLER_3_345 VGND VGND VPWR VPWR sky130_fd_sc_hd__fill_2
XFILLER_3_334 VGND VGND VPWR VPWR sky130_fd_sc_hd__fill_2
X_11292_ _03973_ _03974_ VGND VGND VPWR VPWR _03975_ sky130_fd_sc_hd__xnor2_1
XFILLER_105_262 VPWR VGND VPWR VGND sky130_ef_sc_hd__decap_12
X_13031_ _05619_ _05717_ _05716_ VGND VGND VPWR VPWR _05869_ sky130_fd_sc_hd__a21oi_1
X_10243_ net589 net580 net313 net311 VGND VGND VPWR VPWR _02829_ sky130_fd_sc_hd__and4_1
X_10174_ _02753_ _02754_ VGND VGND VPWR VPWR _02757_ sky130_fd_sc_hd__xnor2_1
XFILLER_120_232 VGND VGND VPWR VPWR sky130_fd_sc_hd__fill_1
XFILLER_67_809 VGND VGND VPWR VPWR sky130_fd_sc_hd__decap_8
XFILLER_120_298 VGND VGND VPWR VPWR sky130_fd_sc_hd__decap_3
XFILLER_86_190 VGND VGND VPWR VPWR sky130_fd_sc_hd__decap_6
X_12815_ net506 net24 net25 net514 VGND VGND VPWR VPWR _05632_ sky130_fd_sc_hd__a22o_1
XFILLER_15_430 VPWR VGND VPWR VGND sky130_ef_sc_hd__decap_12
Xclkbuf_3_4__f_clk clknet_0_clk VGND VGND VPWR VPWR clknet_3_4__leaf_clk sky130_fd_sc_hd__clkbuf_16
X_12746_ _05554_ _05555_ _05397_ VGND VGND VPWR VPWR _05557_ sky130_fd_sc_hd__a21o_1
XFILLER_70_580 VGND VGND VPWR VPWR sky130_fd_sc_hd__decap_3
XFILLER_15_485 VGND VGND VPWR VPWR sky130_fd_sc_hd__fill_2
X_12677_ _05481_ _05480_ VGND VGND VPWR VPWR _05482_ sky130_fd_sc_hd__and2b_1
XFILLER_128_321 VPWR VGND VPWR VGND sky130_ef_sc_hd__decap_12
X_11628_ _04311_ _04339_ VGND VGND VPWR VPWR _04341_ sky130_fd_sc_hd__nor2_1
XFILLER_30_477 VPWR VGND VPWR VGND sky130_ef_sc_hd__decap_12
X_11559_ _04263_ _04265_ VGND VGND VPWR VPWR _04266_ sky130_fd_sc_hd__nor2_1
XFILLER_124_571 VPWR VGND VPWR VGND sky130_ef_sc_hd__decap_12
X_13229_ net522 net395 _05956_ _05955_ VGND VGND VPWR VPWR _06085_ sky130_fd_sc_hd__a31o_1
XFILLER_40_3 VPWR VGND VPWR VGND sky130_ef_sc_hd__decap_12
XFILLER_69_113 VPWR VGND VPWR VGND sky130_ef_sc_hd__decap_12
XFILLER_111_232 VGND VGND VPWR VPWR sky130_fd_sc_hd__decap_3
XFILLER_85_617 VGND VGND VPWR VPWR sky130_fd_sc_hd__decap_3
X_08770_ _01059_ _01070_ _01232_ _01236_ VGND VGND VPWR VPWR _01237_ sky130_fd_sc_hd__o211a_1
XFILLER_84_105 VGND VGND VPWR VPWR sky130_fd_sc_hd__fill_1
X_07721_ net505 net678 net676 net513 VGND VGND VPWR VPWR _00200_ sky130_fd_sc_hd__a22o_1
XFILLER_38_533 VGND VGND VPWR VPWR sky130_fd_sc_hd__decap_8
XFILLER_81_823 VGND VGND VPWR VPWR sky130_fd_sc_hd__fill_1
XFILLER_65_363 VGND VGND VPWR VPWR sky130_fd_sc_hd__decap_4
XFILLER_53_503 VGND VGND VPWR VPWR sky130_fd_sc_hd__fill_1
X_07652_ _00129_ _00130_ _06715_ _06717_ VGND VGND VPWR VPWR _00132_ sky130_fd_sc_hd__a211o_1
XTAP_TAPCELL_ROW_0_304 VGND VPWR sky130_fd_sc_hd__tapvpwrvgnd_1
XFILLER_26_706 VGND VGND VPWR VPWR sky130_fd_sc_hd__decap_8
XFILLER_26_739 VGND VGND VPWR VPWR sky130_fd_sc_hd__decap_6
XTAP_TAPCELL_ROW_105_1821 VGND VPWR sky130_fd_sc_hd__tapvpwrvgnd_1
X_07583_ _06808_ _06809_ VGND VGND VPWR VPWR _06812_ sky130_fd_sc_hd__xnor2_1
X_09322_ _01647_ _01651_ _01650_ VGND VGND VPWR VPWR _01829_ sky130_fd_sc_hd__a21o_1
XFILLER_80_377 VGND VGND VPWR VPWR sky130_fd_sc_hd__fill_1
XFILLER_80_344 VPWR VGND VPWR VGND sky130_ef_sc_hd__decap_12
XFILLER_80_399 VGND VGND VPWR VPWR sky130_fd_sc_hd__fill_1
XTAP_TAPCELL_ROW_138_2320 VGND VPWR sky130_fd_sc_hd__tapvpwrvgnd_1
X_09253_ net515 net509 net55 net345 VGND VGND VPWR VPWR _01753_ sky130_fd_sc_hd__and4_1
X_09184_ _01519_ _01677_ VGND VGND VPWR VPWR _01678_ sky130_fd_sc_hd__and2_1
X_08204_ _00142_ _00290_ _00678_ _00141_ VGND VGND VPWR VPWR _00680_ sky130_fd_sc_hd__nor4b_1
XTAP_TAPCELL_ROW_134_2239 VGND VPWR sky130_fd_sc_hd__tapvpwrvgnd_1
XTAP_TAPCELL_ROW_60_1172 VGND VPWR sky130_fd_sc_hd__tapvpwrvgnd_1
X_08135_ _00607_ _00610_ VGND VGND VPWR VPWR _00611_ sky130_fd_sc_hd__and2b_1
XFILLER_107_505 VPWR VGND VPWR VGND sky130_ef_sc_hd__decap_12
X_08066_ _00541_ _00542_ VGND VGND VPWR VPWR _00543_ sky130_fd_sc_hd__nor2_1
XTAP_TAPCELL_ROW_116_1983 VGND VPWR sky130_fd_sc_hd__tapvpwrvgnd_1
X_07017_ _03379_ _03500_ _03511_ VGND VGND VPWR VPWR _03522_ sky130_fd_sc_hd__nand3_1
XTAP_TAPCELL_ROW_8_415 VGND VPWR sky130_fd_sc_hd__tapvpwrvgnd_1
XFILLER_108_89 VGND VGND VPWR VPWR sky130_fd_sc_hd__fill_1
XFILLER_68_27 VGND VGND VPWR VPWR sky130_fd_sc_hd__fill_1
XFILLER_130_552 VPWR VGND VPWR VGND sky130_ef_sc_hd__decap_12
XFILLER_103_777 VGND VGND VPWR VPWR sky130_fd_sc_hd__decap_6
XFILLER_88_455 VPWR VGND VPWR VGND sky130_ef_sc_hd__decap_12
XFILLER_49_809 VGND VGND VPWR VPWR sky130_fd_sc_hd__decap_8
X_08968_ net431 net339 net337 net440 VGND VGND VPWR VPWR _01443_ sky130_fd_sc_hd__a22o_1
XFILLER_124_77 VGND VGND VPWR VPWR sky130_fd_sc_hd__decap_6
X_08899_ _01160_ _01291_ _01293_ VGND VGND VPWR VPWR _01367_ sky130_fd_sc_hd__a21o_1
XFILLER_84_15 VPWR VGND VPWR VGND sky130_ef_sc_hd__decap_12
X_07919_ _00394_ _00395_ net706 net610 VGND VGND VPWR VPWR _00397_ sky130_fd_sc_hd__and4bb_1
XFILLER_71_300 VPWR VGND VPWR VGND sky130_ef_sc_hd__decap_12
XFILLER_56_352 VPWR VGND VPWR VGND sky130_ef_sc_hd__decap_12
X_10930_ _03250_ _03394_ _03395_ VGND VGND VPWR VPWR _03579_ sky130_fd_sc_hd__o21bai_1
XFILLER_83_193 VGND VGND VPWR VPWR sky130_fd_sc_hd__fill_1
XFILLER_16_216 VGND VGND VPWR VPWR sky130_fd_sc_hd__decap_8
X_12600_ _05251_ _05267_ _05266_ VGND VGND VPWR VPWR _05398_ sky130_fd_sc_hd__o21ai_1
X_10861_ _03310_ _03330_ _03329_ VGND VGND VPWR VPWR _03504_ sky130_fd_sc_hd__a21boi_1
X_13580_ _06464_ _06466_ VGND VGND VPWR VPWR _06468_ sky130_fd_sc_hd__xnor2_1
XFILLER_12_400 VGND VGND VPWR VPWR sky130_fd_sc_hd__fill_2
X_10792_ _03425_ _03427_ VGND VGND VPWR VPWR _03428_ sky130_fd_sc_hd__xnor2_1
XFILLER_31_219 VGND VGND VPWR VPWR sky130_fd_sc_hd__decap_4
X_12531_ net607 net369 VGND VGND VPWR VPWR _05323_ sky130_fd_sc_hd__nand2_1
XFILLER_8_404 VGND VGND VPWR VPWR sky130_fd_sc_hd__decap_6
XFILLER_12_444 VPWR VGND VPWR VGND sky130_ef_sc_hd__decap_12
XFILLER_24_293 VGND VGND VPWR VPWR sky130_fd_sc_hd__decap_3
XFILLER_138_630 VGND VGND VPWR VPWR sky130_fd_sc_hd__decap_3
X_12462_ _05237_ _05246_ VGND VGND VPWR VPWR _05247_ sky130_fd_sc_hd__xnor2_1
XFILLER_12_477 VGND VGND VPWR VPWR sky130_fd_sc_hd__decap_3
XFILLER_40_786 VPWR VGND VPWR VGND sky130_ef_sc_hd__decap_12
X_11413_ net424 net272 net270 net433 VGND VGND VPWR VPWR _04107_ sky130_fd_sc_hd__a22oi_1
XTAP_TAPCELL_ROW_78_1433 VGND VPWR sky130_fd_sc_hd__tapvpwrvgnd_1
X_12393_ _05167_ _05170_ VGND VGND VPWR VPWR _05172_ sky130_fd_sc_hd__xor2_1
XFILLER_125_335 VGND VGND VPWR VPWR sky130_fd_sc_hd__fill_1
XFILLER_3_120 VGND VGND VPWR VPWR sky130_fd_sc_hd__decap_6
X_11344_ _04029_ _04030_ VGND VGND VPWR VPWR _04031_ sky130_fd_sc_hd__xnor2_1
XFILLER_125_357 VGND VGND VPWR VPWR sky130_fd_sc_hd__fill_2
XTAP_TAPCELL_ROW_91_1622 VGND VPWR sky130_fd_sc_hd__tapvpwrvgnd_1
X_11275_ _03954_ _03955_ VGND VGND VPWR VPWR _03956_ sky130_fd_sc_hd__nor2_1
X_13014_ _05844_ _05849_ VGND VGND VPWR VPWR _05850_ sky130_fd_sc_hd__xor2_1
XFILLER_3_164 VGND VGND VPWR VPWR sky130_fd_sc_hd__decap_4
X_10226_ _02807_ _02808_ VGND VGND VPWR VPWR _02810_ sky130_fd_sc_hd__xor2_1
X_10157_ _02715_ _02737_ VGND VGND VPWR VPWR _02738_ sky130_fd_sc_hd__xnor2_1
XFILLER_79_477 VPWR VGND VPWR VGND sky130_ef_sc_hd__decap_12
X_10088_ _02635_ _02662_ VGND VGND VPWR VPWR _02664_ sky130_fd_sc_hd__nor2_1
XFILLER_82_609 VPWR VGND VPWR VGND sky130_ef_sc_hd__decap_12
XTAP_TAPCELL_ROW_89_1584 VGND VPWR sky130_fd_sc_hd__tapvpwrvgnd_1
XFILLER_90_642 VGND VGND VPWR VPWR sky130_fd_sc_hd__fill_2
XTAP_TAPCELL_ROW_89_1595 VGND VPWR sky130_fd_sc_hd__tapvpwrvgnd_1
XFILLER_16_772 VGND VGND VPWR VPWR sky130_fd_sc_hd__fill_2
XFILLER_16_794 VPWR VGND VPWR VGND sky130_ef_sc_hd__decap_12
X_12729_ _05521_ _05537_ _05539_ VGND VGND VPWR VPWR _05540_ sky130_fd_sc_hd__nand3_1
XFILLER_15_293 VGND VGND VPWR VPWR sky130_fd_sc_hd__decap_6
XFILLER_31_753 VPWR VGND VPWR VGND sky130_ef_sc_hd__decap_12
XTAP_TAPCELL_ROW_100_1751 VGND VPWR sky130_fd_sc_hd__tapvpwrvgnd_1
XFILLER_88_3 VPWR VGND VPWR VGND sky130_ef_sc_hd__decap_12
XFILLER_31_797 VPWR VGND VPWR VGND sky130_ef_sc_hd__decap_12
XFILLER_129_663 VGND VGND VPWR VPWR sky130_fd_sc_hd__fill_2
XTAP_TAPCELL_ROW_13_483 VGND VPWR sky130_fd_sc_hd__tapvpwrvgnd_1
XTAP_TAPCELL_ROW_13_494 VGND VPWR sky130_fd_sc_hd__tapvpwrvgnd_1
XFILLER_116_302 VGND VGND VPWR VPWR sky130_fd_sc_hd__decap_6
XFILLER_7_470 VPWR VGND VPWR VGND sky130_ef_sc_hd__decap_12
X_09940_ _01611_ _02500_ VGND VGND VPWR VPWR _02502_ sky130_fd_sc_hd__xnor2_1
XFILLER_131_349 VGND VGND VPWR VPWR sky130_fd_sc_hd__decap_6
XPHY_EDGE_ROW_115_Right_115 VGND VGND VPWR VPWR sky130_fd_sc_hd__decap_3
XFILLER_98_731 VGND VGND VPWR VPWR sky130_fd_sc_hd__fill_1
X_09871_ _02388_ _02426_ VGND VGND VPWR VPWR _02427_ sky130_fd_sc_hd__xnor2_1
XFILLER_112_530 VGND VGND VPWR VPWR sky130_fd_sc_hd__fill_2
X_08822_ _01051_ _01082_ _01134_ _01081_ VGND VGND VPWR VPWR _01288_ sky130_fd_sc_hd__o22ai_1
XFILLER_112_585 VGND VGND VPWR VPWR sky130_fd_sc_hd__decap_3
X_08753_ _01209_ _01216_ _01215_ VGND VGND VPWR VPWR _01220_ sky130_fd_sc_hd__a21oi_1
XFILLER_100_769 VPWR VGND VPWR VGND sky130_ef_sc_hd__decap_12
XFILLER_85_447 VGND VGND VPWR VPWR sky130_fd_sc_hd__fill_1
XFILLER_57_138 VGND VGND VPWR VPWR sky130_fd_sc_hd__decap_3
XFILLER_72_119 VGND VGND VPWR VPWR sky130_fd_sc_hd__fill_1
X_07704_ _00180_ _00181_ VGND VGND VPWR VPWR _00183_ sky130_fd_sc_hd__nor2_1
X_08684_ net455 net340 net337 net464 VGND VGND VPWR VPWR _01151_ sky130_fd_sc_hd__a22o_1
XFILLER_54_29 VPWR VGND VPWR VGND sky130_ef_sc_hd__decap_12
XFILLER_53_322 VPWR VGND VPWR VGND sky130_ef_sc_hd__decap_12
XTAP_TAPCELL_ROW_49_1012 VGND VPWR sky130_fd_sc_hd__tapvpwrvgnd_1
XFILLER_26_525 VGND VGND VPWR VPWR sky130_fd_sc_hd__decap_3
XFILLER_26_536 VGND VGND VPWR VPWR sky130_fd_sc_hd__fill_1
XFILLER_80_141 VGND VGND VPWR VPWR sky130_fd_sc_hd__fill_1
X_07635_ _00111_ _00112_ _00113_ VGND VGND VPWR VPWR _00115_ sky130_fd_sc_hd__a21o_1
XFILLER_53_344 VGND VGND VPWR VPWR sky130_fd_sc_hd__fill_1
XFILLER_14_709 VGND VGND VPWR VPWR sky130_fd_sc_hd__fill_1
XFILLER_80_174 VPWR VGND VPWR VGND sky130_ef_sc_hd__decap_12
XTAP_TAPCELL_ROW_62_1201 VGND VPWR sky130_fd_sc_hd__tapvpwrvgnd_1
X_07566_ _06793_ _06794_ VGND VGND VPWR VPWR _06795_ sky130_fd_sc_hd__and2_1
XFILLER_13_208 VGND VGND VPWR VPWR sky130_fd_sc_hd__fill_1
X_09305_ _01610_ _01808_ VGND VGND VPWR VPWR _01810_ sky130_fd_sc_hd__xnor2_1
X_09236_ _01720_ _01732_ VGND VGND VPWR VPWR _01734_ sky130_fd_sc_hd__xnor2_1
X_07497_ _06566_ _06726_ VGND VGND VPWR VPWR _06727_ sky130_fd_sc_hd__nor2_1
XFILLER_21_241 VGND VGND VPWR VPWR sky130_fd_sc_hd__decap_6
XFILLER_22_786 VPWR VGND VPWR VGND sky130_ef_sc_hd__decap_12
XPHY_EDGE_ROW_17_Right_17 VGND VGND VPWR VPWR sky130_fd_sc_hd__decap_3
XTAP_TAPCELL_ROW_32_770 VGND VPWR sky130_fd_sc_hd__tapvpwrvgnd_1
XFILLER_119_151 VPWR VGND VPWR VGND sky130_ef_sc_hd__decap_12
X_09167_ _01658_ _01657_ VGND VGND VPWR VPWR _01659_ sky130_fd_sc_hd__and2b_1
XFILLER_134_121 VGND VGND VPWR VPWR sky130_fd_sc_hd__decap_8
X_09098_ _01414_ _01416_ VGND VGND VPWR VPWR _01584_ sky130_fd_sc_hd__nand2_1
XFILLER_119_55 VGND VGND VPWR VPWR sky130_fd_sc_hd__fill_1
X_08118_ _00593_ _00560_ VGND VGND VPWR VPWR _00594_ sky130_fd_sc_hd__and2b_1
XFILLER_134_165 VGND VGND VPWR VPWR sky130_fd_sc_hd__fill_2
X_08049_ net708 net598 VGND VGND VPWR VPWR _00526_ sky130_fd_sc_hd__nand2b_1
X_11060_ net560 net552 net304 net302 VGND VGND VPWR VPWR _03721_ sky130_fd_sc_hd__and4_1
X_10011_ _02576_ _02577_ VGND VGND VPWR VPWR _02579_ sky130_fd_sc_hd__xnor2_1
XTAP_TAPCELL_ROW_73_1363 VGND VPWR sky130_fd_sc_hd__tapvpwrvgnd_1
XTAP_TAPCELL_ROW_73_1352 VGND VPWR sky130_fd_sc_hd__tapvpwrvgnd_1
XFILLER_89_797 VPWR VGND VPWR VGND sky130_ef_sc_hd__decap_12
XFILLER_0_167 VGND VGND VPWR VPWR sky130_fd_sc_hd__fill_1
XPHY_EDGE_ROW_26_Right_26 VGND VGND VPWR VPWR sky130_fd_sc_hd__decap_3
XFILLER_95_69 VPWR VGND VPWR VGND sky130_ef_sc_hd__decap_12
XFILLER_76_436 VGND VGND VPWR VPWR sky130_fd_sc_hd__fill_1
XFILLER_28_41 VPWR VGND VPWR VGND sky130_ef_sc_hd__decap_12
XFILLER_91_406 VGND VGND VPWR VPWR sky130_fd_sc_hd__fill_2
XFILLER_17_503 VGND VGND VPWR VPWR sky130_fd_sc_hd__fill_1
X_11962_ _04669_ _04699_ VGND VGND VPWR VPWR _04702_ sky130_fd_sc_hd__nand2_1
XFILLER_56_171 VGND VGND VPWR VPWR sky130_fd_sc_hd__fill_1
XFILLER_17_525 VGND VGND VPWR VPWR sky130_fd_sc_hd__decap_3
XFILLER_28_85 VPWR VGND VPWR VGND sky130_ef_sc_hd__decap_12
XFILLER_29_374 VGND VGND VPWR VPWR sky130_fd_sc_hd__decap_6
X_13701_ clknet_3_0__leaf_clk _00047_ net715 VGND VGND VPWR VPWR net220 sky130_fd_sc_hd__dfrtp_1
X_10913_ _03547_ _03549_ _03558_ VGND VGND VPWR VPWR _03560_ sky130_fd_sc_hd__o21ai_1
X_11893_ net248 _04507_ _04582_ VGND VGND VPWR VPWR _04629_ sky130_fd_sc_hd__o21a_1
X_13632_ _06485_ _06523_ VGND VGND VPWR VPWR _00033_ sky130_fd_sc_hd__xnor2_1
XFILLER_72_686 VGND VGND VPWR VPWR sky130_fd_sc_hd__fill_1
XFILLER_13_720 VGND VGND VPWR VPWR sky130_fd_sc_hd__decap_4
X_10844_ _03482_ _03483_ _03479_ VGND VGND VPWR VPWR _03485_ sky130_fd_sc_hd__a21o_1
X_13563_ _06370_ _06448_ VGND VGND VPWR VPWR _06449_ sky130_fd_sc_hd__nand2b_1
XFILLER_9_702 VGND VGND VPWR VPWR sky130_fd_sc_hd__decap_6
XFILLER_25_591 VGND VGND VPWR VPWR sky130_fd_sc_hd__decap_3
X_12514_ _04986_ _05131_ VGND VGND VPWR VPWR _05304_ sky130_fd_sc_hd__nor2_1
X_10775_ _03391_ _03408_ VGND VGND VPWR VPWR _03409_ sky130_fd_sc_hd__xnor2_1
XFILLER_13_775 VGND VGND VPWR VPWR sky130_fd_sc_hd__decap_8
XTAP_TAPCELL_ROW_30_729 VGND VPWR sky130_fd_sc_hd__tapvpwrvgnd_1
XPHY_EDGE_ROW_35_Right_35 VGND VGND VPWR VPWR sky130_fd_sc_hd__decap_3
X_13494_ net246 _06373_ VGND VGND VPWR VPWR _06374_ sky130_fd_sc_hd__xor2_1
XFILLER_13_797 VPWR VGND VPWR VGND sky130_ef_sc_hd__decap_12
X_12445_ net541 net695 net679 net550 VGND VGND VPWR VPWR _05228_ sky130_fd_sc_hd__a22o_1
XFILLER_60_83 VGND VGND VPWR VPWR sky130_fd_sc_hd__fill_1
XFILLER_9_779 VGND VGND VPWR VPWR sky130_fd_sc_hd__decap_4
XTAP_TAPCELL_ROW_10_442 VGND VPWR sky130_fd_sc_hd__tapvpwrvgnd_1
X_12376_ net454 net385 net31 net462 VGND VGND VPWR VPWR _05153_ sky130_fd_sc_hd__a22oi_2
XFILLER_8_289 VGND VGND VPWR VPWR sky130_fd_sc_hd__decap_6
XFILLER_126_677 VGND VGND VPWR VPWR sky130_fd_sc_hd__decap_6
XFILLER_125_143 VGND VGND VPWR VPWR sky130_fd_sc_hd__decap_3
X_11327_ _04010_ _04011_ VGND VGND VPWR VPWR _04013_ sky130_fd_sc_hd__xor2_1
XFILLER_125_187 VPWR VGND VPWR VGND sky130_ef_sc_hd__decap_12
XFILLER_4_473 VGND VGND VPWR VPWR sky130_fd_sc_hd__decap_3
XFILLER_69_81 VPWR VGND VPWR VGND sky130_ef_sc_hd__decap_12
XPHY_EDGE_ROW_44_Right_44 VGND VGND VPWR VPWR sky130_fd_sc_hd__decap_3
X_11258_ _03426_ _03936_ VGND VGND VPWR VPWR _03938_ sky130_fd_sc_hd__and2_1
X_10209_ _02761_ _02794_ VGND VGND VPWR VPWR _00061_ sky130_fd_sc_hd__xnor2_1
XFILLER_121_371 VGND VGND VPWR VPWR sky130_fd_sc_hd__decap_8
XFILLER_95_712 VPWR VGND VPWR VGND sky130_ef_sc_hd__decap_12
XFILLER_79_274 VGND VGND VPWR VPWR sky130_fd_sc_hd__decap_6
X_11189_ _03717_ _03862_ VGND VGND VPWR VPWR _03863_ sky130_fd_sc_hd__xnor2_1
XFILLER_39_105 VGND VGND VPWR VPWR sky130_fd_sc_hd__decap_6
XFILLER_121_393 VGND VGND VPWR VPWR sky130_fd_sc_hd__decap_6
XFILLER_94_233 VPWR VGND VPWR VGND sky130_ef_sc_hd__decap_12
XFILLER_67_447 VGND VGND VPWR VPWR sky130_fd_sc_hd__fill_1
XFILLER_55_609 VGND VGND VPWR VPWR sky130_fd_sc_hd__decap_6
XFILLER_63_631 VGND VGND VPWR VPWR sky130_fd_sc_hd__fill_1
XFILLER_62_141 VGND VGND VPWR VPWR sky130_fd_sc_hd__decap_4
XFILLER_62_130 VGND VGND VPWR VPWR sky130_fd_sc_hd__fill_2
XFILLER_47_193 VGND VGND VPWR VPWR sky130_fd_sc_hd__decap_4
XTAP_TAPCELL_ROW_18_553 VGND VPWR sky130_fd_sc_hd__tapvpwrvgnd_1
XFILLER_63_686 VGND VGND VPWR VPWR sky130_fd_sc_hd__fill_2
XFILLER_62_152 VGND VGND VPWR VPWR sky130_fd_sc_hd__fill_1
X_07420_ _06647_ _06648_ _06649_ VGND VGND VPWR VPWR _06650_ sky130_fd_sc_hd__nand3_1
XTAP_TAPCELL_ROW_18_564 VGND VPWR sky130_fd_sc_hd__tapvpwrvgnd_1
XFILLER_23_528 VPWR VGND VPWR VGND sky130_ef_sc_hd__decap_12
XPHY_EDGE_ROW_53_Right_53 VGND VGND VPWR VPWR sky130_fd_sc_hd__decap_3
XFILLER_50_336 VPWR VGND VPWR VGND sky130_ef_sc_hd__decap_12
X_07351_ net703 net264 VGND VGND VPWR VPWR _06581_ sky130_fd_sc_hd__nor2_1
XTAP_TAPCELL_ROW_118_2009 VGND VPWR sky130_fd_sc_hd__tapvpwrvgnd_1
XFILLER_31_561 VPWR VGND VPWR VGND sky130_ef_sc_hd__decap_12
X_07282_ _06367_ _06389_ _06400_ VGND VGND VPWR VPWR _06410_ sky130_fd_sc_hd__or3_1
XFILLER_136_419 VGND VGND VPWR VPWR sky130_fd_sc_hd__fill_1
XFILLER_117_611 VGND VGND VPWR VPWR sky130_fd_sc_hd__decap_4
X_09021_ _01498_ _01499_ _01341_ _01343_ VGND VGND VPWR VPWR _01501_ sky130_fd_sc_hd__a211oi_2
XFILLER_117_688 VGND VGND VPWR VPWR sky130_fd_sc_hd__decap_3
XFILLER_117_655 VGND VGND VPWR VPWR sky130_fd_sc_hd__decap_8
XFILLER_132_625 VGND VGND VPWR VPWR sky130_fd_sc_hd__decap_3
XFILLER_131_113 VPWR VGND VPWR VGND sky130_ef_sc_hd__decap_12
XTAP_TAPCELL_ROW_113_1942 VGND VPWR sky130_fd_sc_hd__tapvpwrvgnd_1
XTAP_TAPCELL_ROW_113_1931 VGND VPWR sky130_fd_sc_hd__tapvpwrvgnd_1
XPHY_EDGE_ROW_62_Right_62 VGND VGND VPWR VPWR sky130_fd_sc_hd__decap_3
X_09923_ _02341_ _02349_ _02348_ VGND VGND VPWR VPWR _02483_ sky130_fd_sc_hd__a21oi_1
XFILLER_120_809 VGND VGND VPWR VPWR sky130_fd_sc_hd__decap_3
Xfanout714 net715 VGND VGND VPWR VPWR net714 sky130_fd_sc_hd__clkbuf_4
Xfanout703 net106 VGND VGND VPWR VPWR net703 sky130_fd_sc_hd__buf_2
X_09854_ _02407_ _02408_ VGND VGND VPWR VPWR _02409_ sky130_fd_sc_hd__nor2_1
XFILLER_98_572 VGND VGND VPWR VPWR sky130_fd_sc_hd__decap_3
XTAP_TAPCELL_ROW_55_1093 VGND VPWR sky130_fd_sc_hd__tapvpwrvgnd_1
X_08805_ _01116_ _01118_ _01269_ VGND VGND VPWR VPWR _01271_ sky130_fd_sc_hd__and3_1
XFILLER_105_57 VPWR VGND VPWR VGND sky130_ef_sc_hd__decap_12
XFILLER_100_533 VGND VGND VPWR VPWR sky130_fd_sc_hd__decap_3
X_09785_ _02332_ _02330_ VGND VGND VPWR VPWR _02333_ sky130_fd_sc_hd__nand2b_1
XFILLER_86_778 VPWR VGND VPWR VGND sky130_ef_sc_hd__decap_12
X_06997_ _02063_ _03292_ VGND VGND VPWR VPWR _03303_ sky130_fd_sc_hd__and2_1
X_08736_ _01198_ _01200_ _01162_ VGND VGND VPWR VPWR _01203_ sky130_fd_sc_hd__o21a_1
XFILLER_73_428 VGND VGND VPWR VPWR sky130_fd_sc_hd__decap_6
X_08667_ net524 net347 VGND VGND VPWR VPWR _01134_ sky130_fd_sc_hd__nand2_1
XFILLER_54_653 VGND VGND VPWR VPWR sky130_fd_sc_hd__fill_1
XFILLER_26_344 VGND VGND VPWR VPWR sky130_fd_sc_hd__fill_1
XTAP_TAPCELL_ROW_37_840 VGND VPWR sky130_fd_sc_hd__tapvpwrvgnd_1
XFILLER_38_193 VGND VGND VPWR VPWR sky130_fd_sc_hd__decap_3
XPHY_EDGE_ROW_71_Right_71 VGND VGND VPWR VPWR sky130_fd_sc_hd__decap_3
X_07618_ net708 net628 net619 net706 VGND VGND VPWR VPWR _00098_ sky130_fd_sc_hd__and4_1
X_08598_ _01064_ _01065_ VGND VGND VPWR VPWR _01066_ sky130_fd_sc_hd__nor2_1
XFILLER_81_49 VGND VGND VPWR VPWR sky130_fd_sc_hd__decap_6
XFILLER_53_196 VPWR VGND VPWR VGND sky130_ef_sc_hd__decap_12
XFILLER_26_399 VGND VGND VPWR VPWR sky130_fd_sc_hd__fill_2
X_07549_ _06757_ _06777_ VGND VGND VPWR VPWR _06778_ sky130_fd_sc_hd__xnor2_1
XFILLER_10_701 VPWR VGND VPWR VGND sky130_ef_sc_hd__decap_12
XFILLER_14_65 VGND VGND VPWR VPWR sky130_fd_sc_hd__decap_8
X_10560_ _03169_ _03170_ _03171_ VGND VGND VPWR VPWR _03175_ sky130_fd_sc_hd__a21oi_1
X_09219_ _01713_ _01715_ VGND VGND VPWR VPWR _01716_ sky130_fd_sc_hd__nand2b_1
XFILLER_108_611 VGND VGND VPWR VPWR sky130_fd_sc_hd__fill_2
XFILLER_6_716 VPWR VGND VPWR VGND sky130_ef_sc_hd__decap_12
X_10491_ _03097_ _03098_ VGND VGND VPWR VPWR _03099_ sky130_fd_sc_hd__xnor2_1
X_12230_ _04845_ _04993_ VGND VGND VPWR VPWR _04994_ sky130_fd_sc_hd__xnor2_1
XFILLER_123_603 VGND VGND VPWR VPWR sky130_fd_sc_hd__decap_3
XFILLER_107_154 VGND VGND VPWR VPWR sky130_fd_sc_hd__decap_6
XPHY_EDGE_ROW_80_Right_80 VGND VGND VPWR VPWR sky130_fd_sc_hd__decap_3
XFILLER_5_248 VGND VGND VPWR VPWR sky130_fd_sc_hd__fill_2
XPHY_EDGE_ROW_15_Left_154 VGND VGND VPWR VPWR sky130_fd_sc_hd__decap_3
XFILLER_30_53 VPWR VGND VPWR VGND sky130_ef_sc_hd__decap_12
XFILLER_108_699 VGND VGND VPWR VPWR sky130_fd_sc_hd__fill_1
XFILLER_108_688 VGND VGND VPWR VPWR sky130_fd_sc_hd__fill_2
X_12161_ _04908_ _04911_ _04910_ VGND VGND VPWR VPWR _04919_ sky130_fd_sc_hd__o21ba_1
XFILLER_123_658 VGND VGND VPWR VPWR sky130_fd_sc_hd__fill_1
XFILLER_111_809 VPWR VGND VPWR VGND sky130_ef_sc_hd__decap_12
X_12092_ _04834_ _04836_ VGND VGND VPWR VPWR _04843_ sky130_fd_sc_hd__xnor2_1
X_11112_ _03775_ _03776_ _03777_ VGND VGND VPWR VPWR _03778_ sky130_fd_sc_hd__and3_1
XFILLER_122_179 VGND VGND VPWR VPWR sky130_fd_sc_hd__decap_3
XFILLER_89_572 VPWR VGND VPWR VGND sky130_ef_sc_hd__decap_12
X_11043_ _03699_ _03700_ _03702_ VGND VGND VPWR VPWR _03703_ sky130_fd_sc_hd__and3_1
XFILLER_39_51 VGND VGND VPWR VPWR sky130_fd_sc_hd__decap_4
XFILLER_103_382 VGND VGND VPWR VPWR sky130_fd_sc_hd__decap_4
XFILLER_49_447 VGND VGND VPWR VPWR sky130_fd_sc_hd__fill_1
X_12994_ _05822_ _05827_ VGND VGND VPWR VPWR _05828_ sky130_fd_sc_hd__xnor2_1
XFILLER_64_439 VGND VGND VPWR VPWR sky130_fd_sc_hd__decap_4
XPHY_EDGE_ROW_24_Left_163 VGND VGND VPWR VPWR sky130_fd_sc_hd__decap_3
XTAP_TAPCELL_ROW_86_1543 VGND VPWR sky130_fd_sc_hd__tapvpwrvgnd_1
X_11945_ net523 net407 net406 net529 VGND VGND VPWR VPWR _04683_ sky130_fd_sc_hd__a22o_1
XFILLER_45_653 VGND VGND VPWR VPWR sky130_fd_sc_hd__decap_3
XFILLER_44_141 VGND VGND VPWR VPWR sky130_fd_sc_hd__fill_1
XFILLER_72_483 VGND VGND VPWR VPWR sky130_fd_sc_hd__fill_1
X_13615_ _06493_ _06504_ VGND VGND VPWR VPWR _06505_ sky130_fd_sc_hd__xnor2_1
XFILLER_60_634 VGND VGND VPWR VPWR sky130_fd_sc_hd__decap_8
XFILLER_60_645 VGND VGND VPWR VPWR sky130_fd_sc_hd__decap_4
X_11876_ _04433_ _04532_ _04531_ VGND VGND VPWR VPWR _04611_ sky130_fd_sc_hd__a21o_1
XTAP_TAPCELL_ROW_15_512 VGND VPWR sky130_fd_sc_hd__tapvpwrvgnd_1
XTAP_TAPCELL_ROW_15_523 VGND VPWR sky130_fd_sc_hd__tapvpwrvgnd_1
X_10827_ net604 net325 net323 net611 VGND VGND VPWR VPWR _03466_ sky130_fd_sc_hd__a22o_1
X_13546_ _06428_ _06429_ VGND VGND VPWR VPWR _06430_ sky130_fd_sc_hd__nand2b_1
X_10758_ _03372_ _03389_ VGND VGND VPWR VPWR _03391_ sky130_fd_sc_hd__xnor2_1
XFILLER_118_419 VGND VGND VPWR VPWR sky130_fd_sc_hd__fill_1
X_13477_ _06329_ _06354_ VGND VGND VPWR VPWR _06355_ sky130_fd_sc_hd__xnor2_1
XFILLER_9_587 VPWR VGND VPWR VGND sky130_ef_sc_hd__decap_12
XFILLER_40_391 VPWR VGND VPWR VGND sky130_ef_sc_hd__decap_12
X_12428_ _04965_ _04968_ _05208_ _05209_ VGND VGND VPWR VPWR _05211_ sky130_fd_sc_hd__o211ai_2
XPHY_EDGE_ROW_33_Left_172 VGND VGND VPWR VPWR sky130_fd_sc_hd__decap_3
X_10689_ _03311_ _03315_ VGND VGND VPWR VPWR _03316_ sky130_fd_sc_hd__xnor2_1
XFILLER_126_485 VGND VGND VPWR VPWR sky130_fd_sc_hd__decap_3
X_12359_ _05132_ _05134_ VGND VGND VPWR VPWR _05135_ sky130_fd_sc_hd__xor2_1
XFILLER_68_701 VPWR VGND VPWR VGND sky130_ef_sc_hd__decap_12
X_06920_ net528 net684 VGND VGND VPWR VPWR _02466_ sky130_fd_sc_hd__nand2_1
XFILLER_67_211 VGND VGND VPWR VPWR sky130_fd_sc_hd__decap_4
XTAP_TAPCELL_ROW_128_2160 VGND VPWR sky130_fd_sc_hd__tapvpwrvgnd_1
XFILLER_95_575 VPWR VGND VPWR VGND sky130_ef_sc_hd__decap_12
X_06851_ net114 net519 VGND VGND VPWR VPWR _01714_ sky130_fd_sc_hd__nand2_1
XPHY_EDGE_ROW_42_Left_181 VGND VGND VPWR VPWR sky130_fd_sc_hd__decap_3
X_09570_ _02090_ _02098_ VGND VGND VPWR VPWR _02099_ sky130_fd_sc_hd__xnor2_1
XFILLER_36_642 VGND VGND VPWR VPWR sky130_fd_sc_hd__fill_2
X_08521_ _00949_ _00954_ _00952_ _00948_ VGND VGND VPWR VPWR _00993_ sky130_fd_sc_hd__a211o_1
XFILLER_63_483 VGND VGND VPWR VPWR sky130_fd_sc_hd__decap_4
XFILLER_35_141 VGND VGND VPWR VPWR sky130_fd_sc_hd__decap_3
X_08452_ _00567_ _00853_ VGND VGND VPWR VPWR _00925_ sky130_fd_sc_hd__nand2_1
XFILLER_90_291 VPWR VGND VPWR VGND sky130_ef_sc_hd__decap_12
X_07403_ net528 net675 VGND VGND VPWR VPWR _06633_ sky130_fd_sc_hd__nand2_4
XFILLER_51_667 VGND VGND VPWR VPWR sky130_fd_sc_hd__decap_4
XFILLER_23_358 VPWR VGND VPWR VGND sky130_ef_sc_hd__decap_12
X_08383_ _00855_ _00856_ _00693_ VGND VGND VPWR VPWR _00857_ sky130_fd_sc_hd__a21oi_1
XFILLER_51_19 VPWR VGND VPWR VGND sky130_ef_sc_hd__decap_12
X_07334_ _06562_ _06563_ _04504_ _04526_ VGND VGND VPWR VPWR _06565_ sky130_fd_sc_hd__a211o_1
X_07265_ _06192_ _06203_ VGND VGND VPWR VPWR _06225_ sky130_fd_sc_hd__and2_1
XPHY_EDGE_ROW_51_Left_190 VGND VGND VPWR VPWR sky130_fd_sc_hd__decap_3
XFILLER_31_391 VGND VGND VPWR VPWR sky130_fd_sc_hd__fill_1
XFILLER_136_238 VGND VGND VPWR VPWR sky130_fd_sc_hd__fill_1
X_09004_ _01478_ _01479_ _01480_ VGND VGND VPWR VPWR _01482_ sky130_fd_sc_hd__a21o_1
X_07196_ _05428_ _05439_ _04253_ VGND VGND VPWR VPWR _05472_ sky130_fd_sc_hd__o21ai_1
XTAP_TAPCELL_ROW_57_1122 VGND VPWR sky130_fd_sc_hd__tapvpwrvgnd_1
XFILLER_132_433 VPWR VGND VPWR VGND sky130_ef_sc_hd__decap_12
XFILLER_78_509 VPWR VGND VPWR VGND sky130_ef_sc_hd__decap_12
X_09906_ net356 net354 net540 net534 VGND VGND VPWR VPWR _02464_ sky130_fd_sc_hd__and4b_1
Xfanout500 net15 VGND VGND VPWR VPWR net500 sky130_fd_sc_hd__buf_2
Xfanout522 net525 VGND VGND VPWR VPWR net522 sky130_fd_sc_hd__buf_4
Xfanout533 net534 VGND VGND VPWR VPWR net533 sky130_fd_sc_hd__buf_4
XTAP_TAPCELL_ROW_70_1311 VGND VPWR sky130_fd_sc_hd__tapvpwrvgnd_1
Xfanout511 net513 VGND VGND VPWR VPWR net511 sky130_fd_sc_hd__clkbuf_4
Xfanout566 net567 VGND VGND VPWR VPWR net566 sky130_fd_sc_hd__clkbuf_4
Xfanout555 net558 VGND VGND VPWR VPWR net555 sky130_fd_sc_hd__clkbuf_4
XFILLER_76_27 VGND VGND VPWR VPWR sky130_fd_sc_hd__fill_1
Xfanout544 net547 VGND VGND VPWR VPWR net544 sky130_fd_sc_hd__clkbuf_4
X_09837_ _02275_ _02389_ VGND VGND VPWR VPWR _02390_ sky130_fd_sc_hd__xor2_1
Xfanout577 net578 VGND VGND VPWR VPWR net577 sky130_fd_sc_hd__buf_2
Xfanout599 net137 VGND VGND VPWR VPWR net599 sky130_fd_sc_hd__clkbuf_4
Xfanout588 net591 VGND VGND VPWR VPWR net588 sky130_fd_sc_hd__buf_2
X_09768_ _02312_ _02313_ VGND VGND VPWR VPWR _02316_ sky130_fd_sc_hd__xor2_2
XFILLER_132_77 VGND VGND VPWR VPWR sky130_fd_sc_hd__decap_6
X_08719_ _01183_ _01184_ _01182_ VGND VGND VPWR VPWR _01186_ sky130_fd_sc_hd__o21bai_1
XFILLER_92_15 VPWR VGND VPWR VGND sky130_ef_sc_hd__decap_12
XFILLER_73_247 VGND VGND VPWR VPWR sky130_fd_sc_hd__decap_4
XFILLER_27_653 VPWR VGND VPWR VGND sky130_ef_sc_hd__decap_12
X_09699_ net522 net57 _02094_ _02093_ net413 VGND VGND VPWR VPWR _02240_ sky130_fd_sc_hd__a32o_1
XTAP_TAPCELL_ROW_68_1284 VGND VPWR sky130_fd_sc_hd__tapvpwrvgnd_1
X_11730_ _04105_ _04368_ _03964_ VGND VGND VPWR VPWR _04452_ sky130_fd_sc_hd__o21a_1
XFILLER_26_141 VGND VGND VPWR VPWR sky130_fd_sc_hd__fill_1
XFILLER_27_697 VGND VGND VPWR VPWR sky130_fd_sc_hd__decap_4
XFILLER_42_645 VPWR VGND VPWR VGND sky130_ef_sc_hd__decap_12
XFILLER_14_347 VGND VGND VPWR VPWR sky130_fd_sc_hd__fill_2
X_11661_ _04258_ _04259_ _04273_ VGND VGND VPWR VPWR _04377_ sky130_fd_sc_hd__o21a_1
X_13400_ _06268_ _06270_ VGND VGND VPWR VPWR _06272_ sky130_fd_sc_hd__xor2_1
XTAP_TAPCELL_ROW_81_1473 VGND VPWR sky130_fd_sc_hd__tapvpwrvgnd_1
X_10612_ net568 net306 VGND VGND VPWR VPWR _03231_ sky130_fd_sc_hd__nand2_1
X_11592_ _04018_ _04161_ _04163_ VGND VGND VPWR VPWR _04302_ sky130_fd_sc_hd__a21oi_2
X_13331_ _06195_ net247 VGND VGND VPWR VPWR _06196_ sky130_fd_sc_hd__nand2b_1
X_10543_ net631 net623 net326 net324 VGND VGND VPWR VPWR _03156_ sky130_fd_sc_hd__and4_1
XTAP_TAPCELL_ROW_40_879 VGND VPWR sky130_fd_sc_hd__tapvpwrvgnd_1
X_13262_ _06111_ _06120_ VGND VGND VPWR VPWR _06121_ sky130_fd_sc_hd__and2_1
XFILLER_6_568 VPWR VGND VPWR VGND sky130_ef_sc_hd__decap_12
X_10474_ _03078_ _03079_ VGND VGND VPWR VPWR _03080_ sky130_fd_sc_hd__nor2_1
XTAP_TAPCELL_ROW_20_592 VGND VPWR sky130_fd_sc_hd__tapvpwrvgnd_1
XFILLER_108_474 VGND VGND VPWR VPWR sky130_fd_sc_hd__fill_2
X_13193_ _06043_ _06044_ VGND VGND VPWR VPWR _06045_ sky130_fd_sc_hd__and2_1
X_12213_ net507 net403 net401 net516 VGND VGND VPWR VPWR _04975_ sky130_fd_sc_hd__a22o_1
X_12144_ _04895_ _04899_ _04890_ _04892_ VGND VGND VPWR VPWR _04900_ sky130_fd_sc_hd__a211oi_2
XFILLER_123_488 VGND VGND VPWR VPWR sky130_fd_sc_hd__fill_1
XFILLER_96_339 VPWR VGND VPWR VGND sky130_ef_sc_hd__decap_12
X_12075_ _04822_ _04821_ VGND VGND VPWR VPWR _04824_ sky130_fd_sc_hd__and2b_1
XFILLER_65_704 VPWR VGND VPWR VGND sky130_ef_sc_hd__decap_12
X_11026_ _03681_ _03682_ _03499_ _03502_ VGND VGND VPWR VPWR _03684_ sky130_fd_sc_hd__a211o_1
XFILLER_66_71 VGND VGND VPWR VPWR sky130_fd_sc_hd__fill_1
XFILLER_65_748 VGND VGND VPWR VPWR sky130_fd_sc_hd__decap_8
XFILLER_65_737 VGND VGND VPWR VPWR sky130_fd_sc_hd__fill_2
XFILLER_37_417 VGND VGND VPWR VPWR sky130_fd_sc_hd__fill_1
XFILLER_92_545 VGND VGND VPWR VPWR sky130_fd_sc_hd__decap_8
X_12977_ _05795_ _05808_ VGND VGND VPWR VPWR _05809_ sky130_fd_sc_hd__xor2_1
XFILLER_33_612 VGND VGND VPWR VPWR sky130_fd_sc_hd__fill_1
X_11928_ _04662_ _04663_ _04664_ VGND VGND VPWR VPWR _04666_ sky130_fd_sc_hd__nor3_1
XFILLER_17_185 VPWR VGND VPWR VGND sky130_ef_sc_hd__decap_12
X_11859_ _04590_ _04592_ VGND VGND VPWR VPWR _04593_ sky130_fd_sc_hd__and2b_1
XFILLER_20_306 VGND VGND VPWR VPWR sky130_fd_sc_hd__fill_2
XFILLER_32_133 VGND VGND VPWR VPWR sky130_fd_sc_hd__decap_6
XANTENNA_18 net448 VGND VGND VPWR VPWR sky130_fd_sc_hd__diode_2
XFILLER_32_177 VPWR VGND VPWR VGND sky130_ef_sc_hd__decap_12
XFILLER_119_717 VGND VGND VPWR VPWR sky130_fd_sc_hd__decap_8
XTAP_TAPCELL_ROW_99_1734 VGND VPWR sky130_fd_sc_hd__tapvpwrvgnd_1
X_13529_ _06216_ _06411_ _06409_ VGND VGND VPWR VPWR _06412_ sky130_fd_sc_hd__o21a_1
XFILLER_13_391 VGND VGND VPWR VPWR sky130_fd_sc_hd__fill_1
XFILLER_118_238 VPWR VGND VPWR VGND sky130_ef_sc_hd__decap_12
X_07050_ _03117_ _03861_ _03872_ VGND VGND VPWR VPWR _03882_ sky130_fd_sc_hd__nor3_1
XFILLER_127_783 VGND VGND VPWR VPWR sky130_fd_sc_hd__fill_1
XFILLER_99_111 VGND VGND VPWR VPWR sky130_fd_sc_hd__fill_1
XFILLER_5_590 VPWR VGND VPWR VGND sky130_ef_sc_hd__decap_12
Xoutput169 net169 VGND VGND VPWR VPWR y0[16] sky130_fd_sc_hd__buf_2
XFILLER_114_477 VGND VGND VPWR VPWR sky130_fd_sc_hd__decap_8
XTAP_TAPCELL_ROW_110_1901 VGND VPWR sky130_fd_sc_hd__tapvpwrvgnd_1
XFILLER_101_105 VGND VGND VPWR VPWR sky130_fd_sc_hd__decap_6
X_07952_ _00292_ _00422_ _00421_ VGND VGND VPWR VPWR _00429_ sky130_fd_sc_hd__a21oi_2
XTAP_TAPCELL_ROW_126_2119 VGND VPWR sky130_fd_sc_hd__tapvpwrvgnd_1
XFILLER_101_149 VPWR VGND VPWR VGND sky130_ef_sc_hd__decap_12
XTAP_TAPCELL_ROW_52_1052 VGND VPWR sky130_fd_sc_hd__tapvpwrvgnd_1
X_07883_ _00349_ _00360_ VGND VGND VPWR VPWR _00361_ sky130_fd_sc_hd__xor2_1
XFILLER_28_406 VGND VGND VPWR VPWR sky130_fd_sc_hd__fill_1
X_06903_ _02260_ _02271_ net703 net569 VGND VGND VPWR VPWR _02282_ sky130_fd_sc_hd__and4bb_1
X_09622_ _01971_ _02002_ _02001_ VGND VGND VPWR VPWR _02156_ sky130_fd_sc_hd__a21o_1
XFILLER_95_361 VPWR VGND VPWR VGND sky130_ef_sc_hd__decap_12
XFILLER_83_512 VGND VGND VPWR VPWR sky130_fd_sc_hd__decap_6
XFILLER_68_597 VGND VGND VPWR VPWR sky130_fd_sc_hd__fill_2
X_06834_ _01486_ _01497_ _01508_ VGND VGND VPWR VPWR _01529_ sky130_fd_sc_hd__or3_1
XFILLER_55_225 VGND VGND VPWR VPWR sky130_fd_sc_hd__decap_8
X_09553_ net260 net348 VGND VGND VPWR VPWR _02080_ sky130_fd_sc_hd__nor2_1
XTAP_TAPCELL_ROW_108_1863 VGND VPWR sky130_fd_sc_hd__tapvpwrvgnd_1
XFILLER_71_729 VPWR VGND VPWR VGND sky130_ef_sc_hd__decap_12
X_08504_ _00805_ _00975_ VGND VGND VPWR VPWR _00976_ sky130_fd_sc_hd__xor2_1
XFILLER_55_269 VGND VGND VPWR VPWR sky130_fd_sc_hd__decap_8
XFILLER_24_601 VPWR VGND VPWR VGND sky130_ef_sc_hd__decap_12
X_09484_ _02003_ _02004_ VGND VGND VPWR VPWR _02005_ sky130_fd_sc_hd__nand2b_1
XFILLER_51_431 VGND VGND VPWR VPWR sky130_fd_sc_hd__decap_6
XFILLER_62_29 VPWR VGND VPWR VGND sky130_ef_sc_hd__decap_12
X_08435_ _00905_ _00906_ VGND VGND VPWR VPWR _00908_ sky130_fd_sc_hd__and2_1
XFILLER_51_453 VGND VGND VPWR VPWR sky130_fd_sc_hd__fill_2
X_08366_ _00838_ _00839_ VGND VGND VPWR VPWR _00840_ sky130_fd_sc_hd__nor2_1
X_07317_ _06529_ _06546_ _06547_ VGND VGND VPWR VPWR _06548_ sky130_fd_sc_hd__and3_1
X_08297_ _00769_ _00770_ VGND VGND VPWR VPWR _00772_ sky130_fd_sc_hd__and2_1
XFILLER_118_750 VGND VGND VPWR VPWR sky130_fd_sc_hd__fill_2
X_07248_ net683 net504 VGND VGND VPWR VPWR _06039_ sky130_fd_sc_hd__nand2_1
X_07179_ _04969_ _04980_ _05264_ _05275_ VGND VGND VPWR VPWR _05286_ sky130_fd_sc_hd__nor4_2
XFILLER_3_516 VGND VGND VPWR VPWR sky130_fd_sc_hd__fill_1
XFILLER_11_55 VGND VGND VPWR VPWR sky130_fd_sc_hd__fill_1
XFILLER_127_55 VGND VGND VPWR VPWR sky130_fd_sc_hd__fill_1
X_10190_ _02765_ _02773_ VGND VGND VPWR VPWR _02774_ sky130_fd_sc_hd__xnor2_1
XFILLER_133_797 VPWR VGND VPWR VGND sky130_ef_sc_hd__decap_12
XFILLER_133_775 VGND VGND VPWR VPWR sky130_fd_sc_hd__decap_8
XFILLER_120_425 VGND VGND VPWR VPWR sky130_fd_sc_hd__fill_2
Xfanout341 net58 VGND VGND VPWR VPWR net341 sky130_fd_sc_hd__buf_2
Xfanout330 net64 VGND VGND VPWR VPWR net330 sky130_fd_sc_hd__buf_2
XFILLER_59_531 VGND VGND VPWR VPWR sky130_fd_sc_hd__fill_2
Xfanout363 net44 VGND VGND VPWR VPWR net363 sky130_fd_sc_hd__buf_2
Xfanout352 net50 VGND VGND VPWR VPWR net352 sky130_fd_sc_hd__buf_2
Xfanout374 net36 VGND VGND VPWR VPWR net374 sky130_fd_sc_hd__buf_2
XFILLER_59_542 VGND VGND VPWR VPWR sky130_fd_sc_hd__fill_1
X_12900_ _05722_ _05724_ VGND VGND VPWR VPWR _05726_ sky130_fd_sc_hd__xnor2_1
Xfanout396 net24 VGND VGND VPWR VPWR net396 sky130_fd_sc_hd__clkbuf_4
XFILLER_86_372 VPWR VGND VPWR VGND sky130_ef_sc_hd__decap_12
Xfanout385 net30 VGND VGND VPWR VPWR net385 sky130_fd_sc_hd__clkbuf_2
XFILLER_74_512 VPWR VGND VPWR VGND sky130_ef_sc_hd__decap_12
XFILLER_46_203 VPWR VGND VPWR VGND sky130_ef_sc_hd__decap_12
XTAP_TAPCELL_ROW_6_387 VGND VPWR sky130_fd_sc_hd__tapvpwrvgnd_1
X_12831_ _05641_ _05649_ VGND VGND VPWR VPWR _05650_ sky130_fd_sc_hd__xor2_1
XFILLER_46_258 VPWR VGND VPWR VGND sky130_ef_sc_hd__decap_12
XTAP_TAPCELL_ROW_83_1502 VGND VPWR sky130_fd_sc_hd__tapvpwrvgnd_1
XFILLER_74_589 VGND VGND VPWR VPWR sky130_fd_sc_hd__decap_3
XFILLER_36_41 VPWR VGND VPWR VGND sky130_ef_sc_hd__decap_12
X_12762_ _05571_ _05572_ VGND VGND VPWR VPWR _05574_ sky130_fd_sc_hd__xor2_1
XFILLER_55_792 VGND VGND VPWR VPWR sky130_fd_sc_hd__decap_6
XTAP_TAPCELL_ROW_45_949 VGND VPWR sky130_fd_sc_hd__tapvpwrvgnd_1
XFILLER_36_85 VPWR VGND VPWR VGND sky130_ef_sc_hd__decap_12
X_12693_ net445 net31 _05498_ _05499_ VGND VGND VPWR VPWR _05500_ sky130_fd_sc_hd__a22o_1
XFILLER_42_453 VGND VGND VPWR VPWR sky130_fd_sc_hd__decap_3
X_11713_ _04431_ _04432_ VGND VGND VPWR VPWR _04433_ sky130_fd_sc_hd__and2b_1
XFILLER_15_656 VPWR VGND VPWR VGND sky130_ef_sc_hd__decap_12
XTAP_TAPCELL_ROW_25_662 VGND VPWR sky130_fd_sc_hd__tapvpwrvgnd_1
X_11644_ _04349_ _04357_ VGND VGND VPWR VPWR _04358_ sky130_fd_sc_hd__and2b_1
XFILLER_30_637 VGND VGND VPWR VPWR sky130_fd_sc_hd__fill_2
Xinput16 w01[6] VGND VGND VPWR VPWR net16 sky130_fd_sc_hd__buf_1
Xinput27 w03[1] VGND VGND VPWR VPWR net27 sky130_fd_sc_hd__buf_1
X_11575_ _04208_ _04282_ VGND VGND VPWR VPWR _04283_ sky130_fd_sc_hd__xnor2_1
Xinput49 w11[7] VGND VGND VPWR VPWR net49 sky130_fd_sc_hd__clkbuf_2
Xinput38 w10[4] VGND VGND VPWR VPWR net38 sky130_fd_sc_hd__clkbuf_2
XFILLER_128_558 VGND VGND VPWR VPWR sky130_fd_sc_hd__decap_8
XFILLER_109_761 VPWR VGND VPWR VGND sky130_ef_sc_hd__decap_12
X_13314_ _06069_ _06071_ _06175_ VGND VGND VPWR VPWR _06177_ sky130_fd_sc_hd__or3b_1
X_10526_ net443 net280 VGND VGND VPWR VPWR _03137_ sky130_fd_sc_hd__nand2_1
XFILLER_115_219 VGND VGND VPWR VPWR sky130_fd_sc_hd__decap_4
X_13245_ _06074_ _06100_ VGND VGND VPWR VPWR _06102_ sky130_fd_sc_hd__xnor2_1
X_10457_ _03060_ _03061_ VGND VGND VPWR VPWR _03062_ sky130_fd_sc_hd__nand2b_1
XTAP_TAPCELL_ROW_94_1664 VGND VPWR sky130_fd_sc_hd__tapvpwrvgnd_1
X_13176_ _05887_ _06026_ VGND VGND VPWR VPWR _06027_ sky130_fd_sc_hd__xnor2_1
XFILLER_69_306 VGND VGND VPWR VPWR sky130_fd_sc_hd__decap_4
X_10388_ net641 net323 VGND VGND VPWR VPWR _02987_ sky130_fd_sc_hd__and2_1
XFILLER_96_136 VGND VGND VPWR VPWR sky130_fd_sc_hd__decap_4
X_12127_ _04709_ _04873_ _04880_ VGND VGND VPWR VPWR _04881_ sky130_fd_sc_hd__nand3_1
XFILLER_111_447 VGND VGND VPWR VPWR sky130_fd_sc_hd__fill_1
X_12058_ _04801_ _04803_ VGND VGND VPWR VPWR _04806_ sky130_fd_sc_hd__nand2_1
XFILLER_93_821 VGND VGND VPWR VPWR sky130_fd_sc_hd__decap_3
X_11009_ _03663_ _03665_ VGND VGND VPWR VPWR _03666_ sky130_fd_sc_hd__and2b_1
XFILLER_53_729 VGND VGND VPWR VPWR sky130_fd_sc_hd__decap_8
XFILLER_46_770 VGND VGND VPWR VPWR sky130_fd_sc_hd__fill_1
XFILLER_18_450 VGND VGND VPWR VPWR sky130_fd_sc_hd__decap_8
XTAP_TAPCELL_ROW_121_2049 VGND VPWR sky130_fd_sc_hd__tapvpwrvgnd_1
XFILLER_92_386 VGND VGND VPWR VPWR sky130_fd_sc_hd__fill_1
XFILLER_52_228 VGND VGND VPWR VPWR sky130_fd_sc_hd__decap_3
XFILLER_18_483 VGND VGND VPWR VPWR sky130_fd_sc_hd__fill_1
XFILLER_21_615 VGND VGND VPWR VPWR sky130_fd_sc_hd__fill_1
X_08220_ _00692_ _00693_ _00694_ VGND VGND VPWR VPWR _00695_ sky130_fd_sc_hd__or3_1
XFILLER_119_503 VGND VGND VPWR VPWR sky130_fd_sc_hd__fill_1
XTAP_TAPCELL_ROW_103_1793 VGND VPWR sky130_fd_sc_hd__tapvpwrvgnd_1
XFILLER_20_125 VPWR VGND VPWR VGND sky130_ef_sc_hd__decap_12
XFILLER_119_514 VPWR VGND VPWR VGND sky130_ef_sc_hd__decap_12
X_08151_ _00626_ VGND VGND VPWR VPWR _00627_ sky130_fd_sc_hd__inv_2
XTAP_TAPCELL_ROW_136_2270 VGND VPWR sky130_fd_sc_hd__tapvpwrvgnd_1
X_08082_ _00466_ _00468_ _00556_ VGND VGND VPWR VPWR _00558_ sky130_fd_sc_hd__or3b_1
X_07102_ _04406_ _04417_ VGND VGND VPWR VPWR _04449_ sky130_fd_sc_hd__xnor2_1
X_07033_ _03664_ _03675_ _03686_ VGND VGND VPWR VPWR _03697_ sky130_fd_sc_hd__nand3_1
XFILLER_115_797 VGND VGND VPWR VPWR sky130_fd_sc_hd__decap_6
X_08984_ _01458_ _01459_ VGND VGND VPWR VPWR _01460_ sky130_fd_sc_hd__nor2_1
XFILLER_102_458 VGND VGND VPWR VPWR sky130_fd_sc_hd__decap_6
X_07935_ _00411_ _00412_ VGND VGND VPWR VPWR _00413_ sky130_fd_sc_hd__nand2b_1
XFILLER_68_361 VGND VGND VPWR VPWR sky130_fd_sc_hd__decap_3
XFILLER_56_523 VGND VGND VPWR VPWR sky130_fd_sc_hd__decap_8
X_09605_ _02130_ _02135_ VGND VGND VPWR VPWR _02137_ sky130_fd_sc_hd__xnor2_2
XFILLER_83_331 VGND VGND VPWR VPWR sky130_fd_sc_hd__decap_4
X_07866_ net493 net677 VGND VGND VPWR VPWR _00344_ sky130_fd_sc_hd__nand2_1
XTAP_TAPCELL_ROW_3_346 VGND VPWR sky130_fd_sc_hd__tapvpwrvgnd_1
XFILLER_113_57 VPWR VGND VPWR VGND sky130_ef_sc_hd__decap_12
X_06817_ net269 VGND VGND VPWR VPWR _01344_ sky130_fd_sc_hd__inv_2
XFILLER_56_589 VPWR VGND VPWR VGND sky130_ef_sc_hd__decap_12
X_07797_ _06816_ _00124_ _00123_ VGND VGND VPWR VPWR _00276_ sky130_fd_sc_hd__a21bo_1
X_09536_ _02057_ _02060_ VGND VGND VPWR VPWR _02061_ sky130_fd_sc_hd__xnor2_1
XFILLER_73_39 VPWR VGND VPWR VGND sky130_ef_sc_hd__decap_12
XFILLER_71_559 VGND VGND VPWR VPWR sky130_fd_sc_hd__fill_1
X_09467_ _01983_ _01984_ net614 net372 VGND VGND VPWR VPWR _01986_ sky130_fd_sc_hd__and4bb_1
XTAP_TAPCELL_ROW_65_1243 VGND VPWR sky130_fd_sc_hd__tapvpwrvgnd_1
XTAP_TAPCELL_ROW_42_908 VGND VPWR sky130_fd_sc_hd__tapvpwrvgnd_1
XFILLER_24_453 VPWR VGND VPWR VGND sky130_ef_sc_hd__decap_12
X_08418_ _00889_ _00890_ VGND VGND VPWR VPWR _00892_ sky130_fd_sc_hd__xor2_1
X_09398_ _01762_ _01776_ _01775_ VGND VGND VPWR VPWR _01912_ sky130_fd_sc_hd__a21o_1
XFILLER_11_136 VPWR VGND VPWR VGND sky130_ef_sc_hd__decap_12
XTAP_TAPCELL_ROW_22_621 VGND VPWR sky130_fd_sc_hd__tapvpwrvgnd_1
X_08349_ _00744_ _00747_ VGND VGND VPWR VPWR _00823_ sky130_fd_sc_hd__or2_1
XFILLER_11_169 VGND VGND VPWR VPWR sky130_fd_sc_hd__decap_4
XFILLER_137_344 VPWR VGND VPWR VGND sky130_ef_sc_hd__decap_12
XPHY_EDGE_ROW_129_Right_129 VGND VGND VPWR VPWR sky130_fd_sc_hd__decap_3
X_11360_ _03921_ _03924_ VGND VGND VPWR VPWR _04049_ sky130_fd_sc_hd__nor2_1
XFILLER_22_76 VGND VGND VPWR VPWR sky130_fd_sc_hd__decap_8
XFILLER_137_399 VGND VGND VPWR VPWR sky130_fd_sc_hd__fill_1
XFILLER_118_3 VPWR VGND VPWR VGND sky130_ef_sc_hd__decap_12
X_10311_ _02900_ _02901_ VGND VGND VPWR VPWR _02902_ sky130_fd_sc_hd__nand2_1
XFILLER_22_98 VPWR VGND VPWR VGND sky130_ef_sc_hd__decap_12
X_13030_ _05778_ _05867_ VGND VGND VPWR VPWR _05868_ sky130_fd_sc_hd__xnor2_1
X_11291_ net322 net598 VGND VGND VPWR VPWR _03974_ sky130_fd_sc_hd__and2b_1
XFILLER_133_561 VGND VGND VPWR VPWR sky130_fd_sc_hd__decap_8
XTAP_TAPCELL_ROW_76_1394 VGND VPWR sky130_fd_sc_hd__tapvpwrvgnd_1
XFILLER_0_3 VPWR VGND VPWR VGND sky130_ef_sc_hd__decap_12
X_10242_ _02827_ VGND VGND VPWR VPWR _02828_ sky130_fd_sc_hd__inv_2
X_10173_ _02753_ _02754_ VGND VGND VPWR VPWR _02756_ sky130_fd_sc_hd__and2b_1
XFILLER_121_734 VGND VGND VPWR VPWR sky130_fd_sc_hd__decap_6
XFILLER_105_274 VGND VGND VPWR VPWR sky130_fd_sc_hd__decap_6
XFILLER_121_756 VGND VGND VPWR VPWR sky130_fd_sc_hd__decap_3
XFILLER_66_309 VGND VGND VPWR VPWR sky130_fd_sc_hd__decap_4
XFILLER_120_266 VGND VGND VPWR VPWR sky130_fd_sc_hd__fill_1
XFILLER_94_629 VPWR VGND VPWR VGND sky130_ef_sc_hd__decap_12
XFILLER_93_128 VGND VGND VPWR VPWR sky130_fd_sc_hd__decap_8
XFILLER_87_681 VGND VGND VPWR VPWR sky130_fd_sc_hd__fill_1
XFILLER_59_383 VGND VGND VPWR VPWR sky130_fd_sc_hd__decap_8
XFILLER_101_480 VGND VGND VPWR VPWR sky130_fd_sc_hd__decap_4
XFILLER_74_342 VGND VGND VPWR VPWR sky130_fd_sc_hd__fill_1
XFILLER_74_320 VGND VGND VPWR VPWR sky130_fd_sc_hd__decap_8
XFILLER_47_534 VGND VGND VPWR VPWR sky130_fd_sc_hd__fill_2
XFILLER_47_51 VGND VGND VPWR VPWR sky130_fd_sc_hd__decap_4
XFILLER_19_225 VPWR VGND VPWR VGND sky130_ef_sc_hd__decap_12
XFILLER_90_813 VGND VGND VPWR VPWR sky130_fd_sc_hd__decap_6
XFILLER_47_95 VPWR VGND VPWR VGND sky130_ef_sc_hd__decap_12
X_12814_ _05630_ VGND VGND VPWR VPWR _05631_ sky130_fd_sc_hd__inv_2
XFILLER_28_781 VPWR VGND VPWR VGND sky130_ef_sc_hd__decap_12
X_12745_ _05397_ _05554_ _05555_ VGND VGND VPWR VPWR _05556_ sky130_fd_sc_hd__nand3_1
XFILLER_42_272 VGND VGND VPWR VPWR sky130_fd_sc_hd__fill_2
X_12676_ _05129_ _05301_ _05300_ VGND VGND VPWR VPWR _05481_ sky130_fd_sc_hd__o21ba_1
X_11627_ _04323_ _04338_ VGND VGND VPWR VPWR _04339_ sky130_fd_sc_hd__xnor2_1
XPHY_EDGE_ROW_7_Left_146 VGND VGND VPWR VPWR sky130_fd_sc_hd__decap_3
XFILLER_30_489 VPWR VGND VPWR VGND sky130_ef_sc_hd__decap_12
XFILLER_128_333 VPWR VGND VPWR VGND sky130_ef_sc_hd__decap_12
XFILLER_7_652 VPWR VGND VPWR VGND sky130_ef_sc_hd__decap_12
X_11558_ net433 net424 net270 VGND VGND VPWR VPWR _04265_ sky130_fd_sc_hd__o21ai_1
XFILLER_116_517 VPWR VGND VPWR VGND sky130_ef_sc_hd__decap_12
X_10509_ _03108_ _03118_ VGND VGND VPWR VPWR _03119_ sky130_fd_sc_hd__xnor2_1
XFILLER_6_184 VPWR VGND VPWR VGND sky130_ef_sc_hd__decap_12
X_11489_ _04075_ _04082_ _04078_ VGND VGND VPWR VPWR _04190_ sky130_fd_sc_hd__a21o_1
XFILLER_112_701 VPWR VGND VPWR VGND sky130_ef_sc_hd__decap_12
X_13228_ _06076_ _06081_ VGND VGND VPWR VPWR _06084_ sky130_fd_sc_hd__xnor2_1
XFILLER_124_583 VGND VGND VPWR VPWR sky130_fd_sc_hd__decap_4
X_13159_ _05982_ _06008_ VGND VGND VPWR VPWR _06009_ sky130_fd_sc_hd__xnor2_2
XFILLER_69_125 VPWR VGND VPWR VGND sky130_ef_sc_hd__decap_12
XFILLER_33_3 VPWR VGND VPWR VGND sky130_ef_sc_hd__decap_12
XFILLER_78_670 VPWR VGND VPWR VGND sky130_ef_sc_hd__decap_12
XFILLER_69_169 VPWR VGND VPWR VGND sky130_ef_sc_hd__decap_12
XFILLER_66_810 VGND VGND VPWR VPWR sky130_fd_sc_hd__fill_2
X_07720_ _00198_ VGND VGND VPWR VPWR _00199_ sky130_fd_sc_hd__inv_2
XFILLER_93_673 VGND VGND VPWR VPWR sky130_fd_sc_hd__decap_6
XFILLER_81_802 VGND VGND VPWR VPWR sky130_fd_sc_hd__fill_1
XFILLER_80_301 VGND VGND VPWR VPWR sky130_fd_sc_hd__decap_6
X_07651_ _06715_ _06717_ _00129_ _00130_ VGND VGND VPWR VPWR _00131_ sky130_fd_sc_hd__o211ai_2
XTAP_TAPCELL_ROW_0_305 VGND VPWR sky130_fd_sc_hd__tapvpwrvgnd_1
XTAP_TAPCELL_ROW_105_1822 VGND VPWR sky130_fd_sc_hd__tapvpwrvgnd_1
XFILLER_92_172 VGND VGND VPWR VPWR sky130_fd_sc_hd__decap_6
XFILLER_65_397 VPWR VGND VPWR VGND sky130_ef_sc_hd__decap_12
XFILLER_65_386 VGND VGND VPWR VPWR sky130_fd_sc_hd__fill_1
X_07582_ _06808_ _06809_ VGND VGND VPWR VPWR _06811_ sky130_fd_sc_hd__and2b_1
XFILLER_53_548 VGND VGND VPWR VPWR sky130_fd_sc_hd__decap_6
X_09321_ _01825_ _01826_ _01819_ VGND VGND VPWR VPWR _01828_ sky130_fd_sc_hd__a21o_1
XFILLER_80_356 VGND VGND VPWR VPWR sky130_fd_sc_hd__decap_8
XTAP_TAPCELL_ROW_138_2321 VGND VPWR sky130_fd_sc_hd__tapvpwrvgnd_1
XTAP_TAPCELL_ROW_138_2310 VGND VPWR sky130_fd_sc_hd__tapvpwrvgnd_1
X_09252_ _01751_ VGND VGND VPWR VPWR _01752_ sky130_fd_sc_hd__inv_2
XFILLER_21_434 VPWR VGND VPWR VGND sky130_ef_sc_hd__decap_12
X_09183_ _01674_ _01675_ VGND VGND VPWR VPWR _01677_ sky130_fd_sc_hd__xnor2_1
XTAP_TAPCELL_ROW_60_1162 VGND VPWR sky130_fd_sc_hd__tapvpwrvgnd_1
X_08203_ _00427_ _00678_ VGND VGND VPWR VPWR _00679_ sky130_fd_sc_hd__nor2_1
XTAP_TAPCELL_ROW_60_1173 VGND VPWR sky130_fd_sc_hd__tapvpwrvgnd_1
X_08134_ _06804_ _00609_ VGND VGND VPWR VPWR _00610_ sky130_fd_sc_hd__xnor2_1
XFILLER_107_517 VGND VGND VPWR VPWR sky130_fd_sc_hd__decap_4
X_08065_ _00364_ _00410_ _00409_ VGND VGND VPWR VPWR _00542_ sky130_fd_sc_hd__a21oi_2
XTAP_TAPCELL_ROW_116_1984 VGND VPWR sky130_fd_sc_hd__tapvpwrvgnd_1
XFILLER_115_561 VPWR VGND VPWR VGND sky130_ef_sc_hd__decap_12
X_07016_ _03423_ _03434_ _03489_ VGND VGND VPWR VPWR _03511_ sky130_fd_sc_hd__a21o_1
XTAP_TAPCELL_ROW_8_416 VGND VPWR sky130_fd_sc_hd__tapvpwrvgnd_1
XFILLER_88_467 VGND VGND VPWR VPWR sky130_fd_sc_hd__decap_8
XFILLER_130_564 VPWR VGND VPWR VGND sky130_ef_sc_hd__decap_12
X_08967_ net440 net431 net339 net337 VGND VGND VPWR VPWR _01441_ sky130_fd_sc_hd__and4_1
XFILLER_76_629 VGND VGND VPWR VPWR sky130_fd_sc_hd__fill_2
XFILLER_48_309 VGND VGND VPWR VPWR sky130_fd_sc_hd__decap_4
X_08898_ _01251_ _01252_ _01265_ _01263_ _01110_ VGND VGND VPWR VPWR _01366_ sky130_fd_sc_hd__a32o_1
XFILLER_84_27 VGND VGND VPWR VPWR sky130_fd_sc_hd__fill_1
X_07918_ net706 net610 _00394_ _00395_ VGND VGND VPWR VPWR _00396_ sky130_fd_sc_hd__o2bb2a_1
XFILLER_90_109 VGND VGND VPWR VPWR sky130_fd_sc_hd__decap_8
XFILLER_84_662 VPWR VGND VPWR VGND sky130_ef_sc_hd__decap_12
XFILLER_72_813 VGND VGND VPWR VPWR sky130_fd_sc_hd__decap_3
X_07849_ _00169_ _00179_ _00178_ VGND VGND VPWR VPWR _00327_ sky130_fd_sc_hd__a21oi_1
XFILLER_71_312 VGND VGND VPWR VPWR sky130_fd_sc_hd__decap_8
X_10860_ _03487_ _03501_ VGND VGND VPWR VPWR _03503_ sky130_fd_sc_hd__xor2_1
X_09519_ _02039_ _02040_ VGND VGND VPWR VPWR _02043_ sky130_fd_sc_hd__xnor2_1
XFILLER_71_378 VPWR VGND VPWR VGND sky130_ef_sc_hd__decap_12
XFILLER_52_581 VGND VGND VPWR VPWR sky130_fd_sc_hd__decap_6
X_10791_ net528 net287 VGND VGND VPWR VPWR _03427_ sky130_fd_sc_hd__nand2_4
X_12530_ _05151_ _05321_ VGND VGND VPWR VPWR _05322_ sky130_fd_sc_hd__xor2_1
X_12461_ _05243_ _05244_ VGND VGND VPWR VPWR _05246_ sky130_fd_sc_hd__xnor2_1
XFILLER_8_416 VGND VGND VPWR VPWR sky130_fd_sc_hd__decap_4
XFILLER_12_456 VGND VGND VPWR VPWR sky130_fd_sc_hd__decap_4
X_11412_ net433 net424 net272 net270 VGND VGND VPWR VPWR _04106_ sky130_fd_sc_hd__and4_1
XFILLER_40_798 VPWR VGND VPWR VGND sky130_ef_sc_hd__decap_12
XTAP_TAPCELL_ROW_78_1434 VGND VPWR sky130_fd_sc_hd__tapvpwrvgnd_1
XTAP_TAPCELL_ROW_78_1423 VGND VPWR sky130_fd_sc_hd__tapvpwrvgnd_1
X_12392_ _05167_ _05170_ VGND VGND VPWR VPWR _05171_ sky130_fd_sc_hd__nand2_1
X_11343_ net544 net301 VGND VGND VPWR VPWR _04030_ sky130_fd_sc_hd__nand2_1
XFILLER_125_369 VPWR VGND VPWR VGND sky130_ef_sc_hd__decap_12
XTAP_TAPCELL_ROW_91_1623 VGND VPWR sky130_fd_sc_hd__tapvpwrvgnd_1
XTAP_TAPCELL_ROW_91_1612 VGND VPWR sky130_fd_sc_hd__tapvpwrvgnd_1
X_11274_ net424 net274 net272 net433 VGND VGND VPWR VPWR _03955_ sky130_fd_sc_hd__a22oi_1
X_13013_ _05847_ _05848_ VGND VGND VPWR VPWR _05849_ sky130_fd_sc_hd__xnor2_1
X_10225_ net468 net281 _02807_ VGND VGND VPWR VPWR _02809_ sky130_fd_sc_hd__and3_1
XFILLER_121_542 VGND VGND VPWR VPWR sky130_fd_sc_hd__decap_4
XFILLER_67_607 VGND VGND VPWR VPWR sky130_fd_sc_hd__fill_2
X_10156_ _02716_ _02736_ VGND VGND VPWR VPWR _02737_ sky130_fd_sc_hd__xor2_1
XFILLER_121_586 VGND VGND VPWR VPWR sky130_fd_sc_hd__fill_2
XFILLER_79_489 VGND VGND VPWR VPWR sky130_fd_sc_hd__decap_6
XFILLER_48_821 VGND VGND VPWR VPWR sky130_fd_sc_hd__decap_3
X_10087_ _02646_ _02661_ VGND VGND VPWR VPWR _02662_ sky130_fd_sc_hd__xnor2_1
XFILLER_58_94 VGND VGND VPWR VPWR sky130_fd_sc_hd__decap_6
XFILLER_75_673 VGND VGND VPWR VPWR sky130_fd_sc_hd__decap_8
XTAP_TAPCELL_ROW_89_1596 VGND VPWR sky130_fd_sc_hd__tapvpwrvgnd_1
XTAP_TAPCELL_ROW_89_1585 VGND VPWR sky130_fd_sc_hd__tapvpwrvgnd_1
XFILLER_62_301 VGND VGND VPWR VPWR sky130_fd_sc_hd__fill_1
XFILLER_16_740 VGND VGND VPWR VPWR sky130_fd_sc_hd__decap_3
XFILLER_35_559 VGND VGND VPWR VPWR sky130_fd_sc_hd__fill_1
XFILLER_90_698 VGND VGND VPWR VPWR sky130_fd_sc_hd__fill_2
XFILLER_50_518 VPWR VGND VPWR VGND sky130_ef_sc_hd__decap_12
XFILLER_22_209 VGND VGND VPWR VPWR sky130_fd_sc_hd__decap_6
X_10989_ net599 _01431_ _03466_ _03464_ VGND VGND VPWR VPWR _03644_ sky130_fd_sc_hd__a31o_1
XFILLER_31_721 VGND VGND VPWR VPWR sky130_fd_sc_hd__decap_6
X_12728_ _05534_ _05535_ _05536_ VGND VGND VPWR VPWR _05539_ sky130_fd_sc_hd__a21o_1
XTAP_TAPCELL_ROW_100_1752 VGND VPWR sky130_fd_sc_hd__tapvpwrvgnd_1
X_12659_ _05460_ _05462_ VGND VGND VPWR VPWR _05463_ sky130_fd_sc_hd__and2b_1
XFILLER_30_253 VPWR VGND VPWR VGND sky130_ef_sc_hd__decap_12
XFILLER_31_765 VPWR VGND VPWR VGND sky130_ef_sc_hd__decap_12
XTAP_TAPCELL_ROW_13_484 VGND VPWR sky130_fd_sc_hd__tapvpwrvgnd_1
XFILLER_128_141 VGND VGND VPWR VPWR sky130_fd_sc_hd__fill_1
XFILLER_116_347 VGND VGND VPWR VPWR sky130_fd_sc_hd__fill_1
XFILLER_7_482 VGND VGND VPWR VPWR sky130_fd_sc_hd__decap_8
X_09870_ _02423_ _02424_ VGND VGND VPWR VPWR _02426_ sky130_fd_sc_hd__xnor2_1
X_08821_ _01134_ _01286_ _01285_ VGND VGND VPWR VPWR _01287_ sky130_fd_sc_hd__a21o_1
XFILLER_97_253 VGND VGND VPWR VPWR sky130_fd_sc_hd__decap_3
X_08752_ _01091_ _01218_ VGND VGND VPWR VPWR _01219_ sky130_fd_sc_hd__nor2_1
X_08683_ net446 net58 VGND VGND VPWR VPWR _01150_ sky130_fd_sc_hd__nand2_1
XFILLER_54_813 VGND VGND VPWR VPWR sky130_fd_sc_hd__fill_1
X_07703_ _00180_ _00181_ VGND VGND VPWR VPWR _00182_ sky130_fd_sc_hd__nand2_1
X_07634_ _00111_ _00112_ _00113_ VGND VGND VPWR VPWR _00114_ sky130_fd_sc_hd__nand3_1
XFILLER_53_301 VGND VGND VPWR VPWR sky130_fd_sc_hd__decap_3
XTAP_TAPCELL_ROW_49_1013 VGND VPWR sky130_fd_sc_hd__tapvpwrvgnd_1
XFILLER_53_334 VGND VGND VPWR VPWR sky130_fd_sc_hd__fill_2
XTAP_TAPCELL_ROW_62_1202 VGND VPWR sky130_fd_sc_hd__tapvpwrvgnd_1
X_07565_ net528 net676 _06632_ _06631_ VGND VGND VPWR VPWR _06794_ sky130_fd_sc_hd__a31o_1
X_09304_ _01611_ _01808_ VGND VGND VPWR VPWR _01809_ sky130_fd_sc_hd__nor2_1
XFILLER_80_197 VGND VGND VPWR VPWR sky130_fd_sc_hd__decap_4
XFILLER_80_186 VGND VGND VPWR VPWR sky130_fd_sc_hd__decap_8
X_07496_ _06724_ _06725_ VGND VGND VPWR VPWR _06726_ sky130_fd_sc_hd__or2_1
X_09235_ _01720_ _01732_ VGND VGND VPWR VPWR _01733_ sky130_fd_sc_hd__nand2_1
XFILLER_70_29 VPWR VGND VPWR VGND sky130_ef_sc_hd__decap_12
XTAP_TAPCELL_ROW_32_760 VGND VPWR sky130_fd_sc_hd__tapvpwrvgnd_1
XFILLER_22_798 VPWR VGND VPWR VGND sky130_ef_sc_hd__decap_12
XFILLER_119_163 VGND VGND VPWR VPWR sky130_fd_sc_hd__decap_4
X_09166_ _01468_ _01488_ _01487_ VGND VGND VPWR VPWR _01658_ sky130_fd_sc_hd__a21boi_1
XFILLER_107_303 VGND VGND VPWR VPWR sky130_fd_sc_hd__decap_8
XFILLER_135_645 VGND VGND VPWR VPWR sky130_fd_sc_hd__fill_2
X_09097_ _01580_ net255 VGND VGND VPWR VPWR _01583_ sky130_fd_sc_hd__xnor2_1
XFILLER_107_325 VGND VGND VPWR VPWR sky130_fd_sc_hd__decap_3
X_08117_ _00561_ _00591_ VGND VGND VPWR VPWR _00593_ sky130_fd_sc_hd__xnor2_1
X_08048_ net706 net602 VGND VGND VPWR VPWR _00525_ sky130_fd_sc_hd__nand2_1
XFILLER_122_317 VGND VGND VPWR VPWR sky130_fd_sc_hd__decap_3
XPHY_EDGE_ROW_79_Left_218 VGND VGND VPWR VPWR sky130_fd_sc_hd__decap_3
XFILLER_1_614 VGND VGND VPWR VPWR sky130_fd_sc_hd__fill_2
XFILLER_135_55 VGND VGND VPWR VPWR sky130_fd_sc_hd__fill_1
X_10010_ _02576_ _02577_ VGND VGND VPWR VPWR _02578_ sky130_fd_sc_hd__or2_1
XFILLER_103_531 VPWR VGND VPWR VGND sky130_ef_sc_hd__decap_12
XTAP_TAPCELL_ROW_73_1364 VGND VPWR sky130_fd_sc_hd__tapvpwrvgnd_1
XTAP_TAPCELL_ROW_73_1353 VGND VPWR sky130_fd_sc_hd__tapvpwrvgnd_1
XFILLER_0_113 VPWR VGND VPWR VGND sky130_ef_sc_hd__decap_12
X_09999_ _02432_ _02436_ _02566_ VGND VGND VPWR VPWR _02567_ sky130_fd_sc_hd__a21oi_1
XFILLER_130_372 VGND VGND VPWR VPWR sky130_fd_sc_hd__decap_3
XFILLER_95_15 VPWR VGND VPWR VGND sky130_ef_sc_hd__decap_12
XFILLER_88_275 VGND VGND VPWR VPWR sky130_fd_sc_hd__decap_4
XFILLER_88_253 VGND VGND VPWR VPWR sky130_fd_sc_hd__fill_1
XFILLER_103_597 VPWR VGND VPWR VGND sky130_ef_sc_hd__decap_12
XFILLER_48_139 VGND VGND VPWR VPWR sky130_fd_sc_hd__fill_1
X_11961_ _04700_ VGND VGND VPWR VPWR _04701_ sky130_fd_sc_hd__inv_2
XFILLER_57_673 VGND VGND VPWR VPWR sky130_fd_sc_hd__decap_8
XFILLER_28_53 VPWR VGND VPWR VGND sky130_ef_sc_hd__decap_12
XFILLER_28_75 VGND VGND VPWR VPWR sky130_fd_sc_hd__decap_8
XFILLER_72_632 VGND VGND VPWR VPWR sky130_fd_sc_hd__decap_3
X_10912_ _03547_ _03549_ _03558_ VGND VGND VPWR VPWR _03559_ sky130_fd_sc_hd__or3_1
XFILLER_17_515 VGND VGND VPWR VPWR sky130_fd_sc_hd__decap_3
XFILLER_28_97 VPWR VGND VPWR VGND sky130_ef_sc_hd__decap_12
X_13700_ clknet_3_0__leaf_clk _00046_ net715 VGND VGND VPWR VPWR net219 sky130_fd_sc_hd__dfrtp_1
X_11892_ _04586_ _04588_ _04585_ VGND VGND VPWR VPWR _04628_ sky130_fd_sc_hd__a21o_1
X_13631_ _06487_ _06522_ VGND VGND VPWR VPWR _06523_ sky130_fd_sc_hd__xnor2_1
XPHY_EDGE_ROW_88_Left_227 VGND VGND VPWR VPWR sky130_fd_sc_hd__decap_3
XFILLER_44_389 VGND VGND VPWR VPWR sky130_fd_sc_hd__decap_3
XFILLER_44_378 VGND VGND VPWR VPWR sky130_fd_sc_hd__decap_4
XFILLER_44_41 VPWR VGND VPWR VGND sky130_ef_sc_hd__decap_12
X_10843_ _03479_ _03482_ _03483_ VGND VGND VPWR VPWR _03484_ sky130_fd_sc_hd__and3_1
X_13562_ net247 _06251_ VGND VGND VPWR VPWR _06448_ sky130_fd_sc_hd__nand2_1
XFILLER_44_85 VGND VGND VPWR VPWR sky130_fd_sc_hd__decap_6
X_10774_ _03404_ _03405_ VGND VGND VPWR VPWR _03408_ sky130_fd_sc_hd__xor2_1
X_12513_ _05129_ _05302_ VGND VGND VPWR VPWR _05303_ sky130_fd_sc_hd__xor2_1
XFILLER_9_714 VPWR VGND VPWR VGND sky130_ef_sc_hd__decap_12
XFILLER_12_253 VPWR VGND VPWR VGND sky130_ef_sc_hd__decap_12
X_13493_ net247 _06371_ VGND VGND VPWR VPWR _06373_ sky130_fd_sc_hd__xnor2_1
XFILLER_12_297 VGND VGND VPWR VPWR sky130_fd_sc_hd__decap_8
XFILLER_40_584 VGND VGND VPWR VPWR sky130_fd_sc_hd__decap_4
XFILLER_126_601 VGND VGND VPWR VPWR sky130_fd_sc_hd__decap_6
X_12444_ _05077_ _05226_ VGND VGND VPWR VPWR _05227_ sky130_fd_sc_hd__nor2_1
XFILLER_60_73 VGND VGND VPWR VPWR sky130_fd_sc_hd__decap_3
XTAP_TAPCELL_ROW_10_443 VGND VPWR sky130_fd_sc_hd__tapvpwrvgnd_1
XFILLER_126_634 VGND VGND VPWR VPWR sky130_fd_sc_hd__decap_8
XFILLER_125_111 VGND VGND VPWR VPWR sky130_fd_sc_hd__fill_1
X_12375_ net462 net454 net385 net31 VGND VGND VPWR VPWR _05152_ sky130_fd_sc_hd__and4_1
XFILLER_125_155 VGND VGND VPWR VPWR sky130_fd_sc_hd__decap_6
XPHY_EDGE_ROW_97_Left_236 VGND VGND VPWR VPWR sky130_fd_sc_hd__decap_3
X_11326_ _04010_ _04011_ VGND VGND VPWR VPWR _04012_ sky130_fd_sc_hd__nor2_1
XFILLER_126_689 VGND VGND VPWR VPWR sky130_fd_sc_hd__fill_1
XFILLER_113_306 VGND VGND VPWR VPWR sky130_fd_sc_hd__decap_8
XFILLER_99_529 VGND VGND VPWR VPWR sky130_fd_sc_hd__decap_8
XFILLER_5_57 VPWR VGND VPWR VGND sky130_ef_sc_hd__decap_12
XFILLER_125_199 VGND VGND VPWR VPWR sky130_fd_sc_hd__fill_2
XFILLER_69_93 VGND VGND VPWR VPWR sky130_fd_sc_hd__decap_4
X_11257_ net278 net410 VGND VGND VPWR VPWR _03936_ sky130_fd_sc_hd__and2b_1
X_10208_ _02762_ _02792_ VGND VGND VPWR VPWR _02794_ sky130_fd_sc_hd__xnor2_1
XFILLER_95_724 VGND VGND VPWR VPWR sky130_fd_sc_hd__decap_4
X_11188_ _03858_ _03859_ VGND VGND VPWR VPWR _03862_ sky130_fd_sc_hd__xor2_1
X_10139_ _02333_ _02636_ VGND VGND VPWR VPWR _02719_ sky130_fd_sc_hd__and2b_1
XFILLER_94_245 VGND VGND VPWR VPWR sky130_fd_sc_hd__decap_6
XFILLER_82_407 VPWR VGND VPWR VGND sky130_ef_sc_hd__decap_12
XFILLER_36_813 VGND VGND VPWR VPWR sky130_fd_sc_hd__decap_8
XFILLER_85_81 VPWR VGND VPWR VGND sky130_ef_sc_hd__decap_12
XFILLER_75_481 VPWR VGND VPWR VGND sky130_ef_sc_hd__decap_12
XFILLER_90_451 VGND VGND VPWR VPWR sky130_fd_sc_hd__decap_8
XFILLER_35_334 VGND VGND VPWR VPWR sky130_fd_sc_hd__fill_2
XFILLER_62_175 VGND VGND VPWR VPWR sky130_fd_sc_hd__fill_1
XFILLER_50_304 VGND VGND VPWR VPWR sky130_fd_sc_hd__decap_4
XTAP_TAPCELL_ROW_18_554 VGND VPWR sky130_fd_sc_hd__tapvpwrvgnd_1
XTAP_TAPCELL_ROW_18_565 VGND VPWR sky130_fd_sc_hd__tapvpwrvgnd_1
XFILLER_35_378 VPWR VGND VPWR VGND sky130_ef_sc_hd__decap_12
XFILLER_50_348 VGND VGND VPWR VPWR sky130_fd_sc_hd__fill_2
X_07350_ _06578_ _06579_ VGND VGND VPWR VPWR _06580_ sky130_fd_sc_hd__nand2b_1
X_09020_ _01341_ _01343_ _01498_ _01499_ VGND VGND VPWR VPWR _01500_ sky130_fd_sc_hd__o211a_1
X_07281_ net451 net668 net666 net459 VGND VGND VPWR VPWR _06400_ sky130_fd_sc_hd__a22oi_2
XFILLER_31_573 VGND VGND VPWR VPWR sky130_fd_sc_hd__fill_2
XFILLER_129_461 VPWR VGND VPWR VGND sky130_ef_sc_hd__decap_12
XFILLER_129_494 VGND VGND VPWR VPWR sky130_fd_sc_hd__decap_8
XFILLER_117_623 VGND VGND VPWR VPWR sky130_fd_sc_hd__decap_3
XFILLER_116_122 VPWR VGND VPWR VGND sky130_ef_sc_hd__decap_12
XTAP_TAPCELL_ROW_113_1943 VGND VPWR sky130_fd_sc_hd__tapvpwrvgnd_1
XTAP_TAPCELL_ROW_113_1932 VGND VPWR sky130_fd_sc_hd__tapvpwrvgnd_1
XFILLER_131_147 VGND VGND VPWR VPWR sky130_fd_sc_hd__decap_8
XFILLER_131_125 VGND VGND VPWR VPWR sky130_fd_sc_hd__fill_2
X_09922_ _02473_ _02481_ VGND VGND VPWR VPWR _02482_ sky130_fd_sc_hd__xnor2_1
Xfanout704 net105 VGND VGND VPWR VPWR net704 sky130_fd_sc_hd__buf_2
Xfanout715 net1 VGND VGND VPWR VPWR net715 sky130_fd_sc_hd__buf_4
X_09853_ _02281_ _02292_ _02280_ VGND VGND VPWR VPWR _02408_ sky130_fd_sc_hd__a21oi_1
XTAP_TAPCELL_ROW_55_1094 VGND VPWR sky130_fd_sc_hd__tapvpwrvgnd_1
X_09784_ _02188_ _02331_ VGND VGND VPWR VPWR _02332_ sky130_fd_sc_hd__xor2_1
X_08804_ _01116_ _01118_ _01269_ VGND VGND VPWR VPWR _01270_ sky130_fd_sc_hd__a21oi_2
XFILLER_86_757 VGND VGND VPWR VPWR sky130_fd_sc_hd__decap_4
XFILLER_85_212 VGND VGND VPWR VPWR sky130_fd_sc_hd__decap_3
X_08735_ _01162_ _01198_ _01200_ VGND VGND VPWR VPWR _01202_ sky130_fd_sc_hd__or3_4
XFILLER_105_69 VPWR VGND VPWR VGND sky130_ef_sc_hd__decap_12
X_06996_ _03215_ _03281_ VGND VGND VPWR VPWR _03292_ sky130_fd_sc_hd__nor2_1
XFILLER_85_289 VGND VGND VPWR VPWR sky130_fd_sc_hd__decap_4
XFILLER_54_621 VGND VGND VPWR VPWR sky130_fd_sc_hd__fill_1
XFILLER_54_610 VGND VGND VPWR VPWR sky130_fd_sc_hd__decap_4
XFILLER_39_673 VPWR VGND VPWR VGND sky130_ef_sc_hd__decap_12
X_08666_ net530 net347 VGND VGND VPWR VPWR _01133_ sky130_fd_sc_hd__nand2_1
XFILLER_42_805 VGND VGND VPWR VPWR sky130_fd_sc_hd__decap_6
XTAP_TAPCELL_ROW_37_830 VGND VPWR sky130_fd_sc_hd__tapvpwrvgnd_1
XTAP_TAPCELL_ROW_37_841 VGND VPWR sky130_fd_sc_hd__tapvpwrvgnd_1
X_08597_ net575 net366 _01062_ _01063_ VGND VGND VPWR VPWR _01065_ sky130_fd_sc_hd__a22oi_1
XFILLER_121_57 VPWR VGND VPWR VGND sky130_ef_sc_hd__decap_12
X_07617_ _00089_ _00096_ VGND VGND VPWR VPWR _00097_ sky130_fd_sc_hd__xor2_1
X_07548_ _06774_ _06775_ VGND VGND VPWR VPWR _06777_ sky130_fd_sc_hd__xnor2_1
X_07479_ _06519_ _06551_ _06550_ VGND VGND VPWR VPWR _06709_ sky130_fd_sc_hd__a21bo_1
XFILLER_10_713 VPWR VGND VPWR VGND sky130_ef_sc_hd__decap_12
X_09218_ _01533_ _01542_ _01541_ VGND VGND VPWR VPWR _01715_ sky130_fd_sc_hd__a21bo_1
XFILLER_10_757 VPWR VGND VPWR VGND sky130_ef_sc_hd__decap_12
X_10490_ _02919_ _02924_ VGND VGND VPWR VPWR _03098_ sky130_fd_sc_hd__nor2_1
XFILLER_135_420 VPWR VGND VPWR VGND sky130_ef_sc_hd__decap_12
XFILLER_107_111 VGND VGND VPWR VPWR sky130_fd_sc_hd__fill_1
X_09149_ _01636_ _01637_ _01633_ VGND VGND VPWR VPWR _01640_ sky130_fd_sc_hd__a21o_1
XFILLER_6_728 VGND VGND VPWR VPWR sky130_fd_sc_hd__decap_3
XFILLER_135_464 VGND VGND VPWR VPWR sky130_fd_sc_hd__fill_1
X_12160_ _04913_ _04914_ _04807_ VGND VGND VPWR VPWR _04918_ sky130_fd_sc_hd__a21oi_1
XFILLER_122_103 VGND VGND VPWR VPWR sky130_fd_sc_hd__fill_1
X_11111_ net492 net291 _03603_ _03602_ VGND VGND VPWR VPWR _03777_ sky130_fd_sc_hd__a31o_1
XFILLER_107_199 VPWR VGND VPWR VGND sky130_ef_sc_hd__decap_12
X_12091_ _04826_ _04840_ VGND VGND VPWR VPWR _04842_ sky130_fd_sc_hd__xnor2_1
XFILLER_110_309 VGND VGND VPWR VPWR sky130_fd_sc_hd__decap_4
XFILLER_89_584 VGND VGND VPWR VPWR sky130_fd_sc_hd__decap_8
X_11042_ _03362_ _03524_ _03521_ VGND VGND VPWR VPWR _03702_ sky130_fd_sc_hd__a21o_1
XFILLER_92_716 VGND VGND VPWR VPWR sky130_fd_sc_hd__decap_6
XFILLER_92_749 VGND VGND VPWR VPWR sky130_fd_sc_hd__decap_4
X_12993_ _05823_ _05825_ VGND VGND VPWR VPWR _05827_ sky130_fd_sc_hd__xnor2_1
XFILLER_18_813 VGND VGND VPWR VPWR sky130_fd_sc_hd__decap_8
XFILLER_29_150 VGND VGND VPWR VPWR sky130_fd_sc_hd__fill_1
XFILLER_36_109 VPWR VGND VPWR VGND sky130_ef_sc_hd__decap_12
XTAP_TAPCELL_ROW_86_1544 VGND VPWR sky130_fd_sc_hd__tapvpwrvgnd_1
X_11944_ _04680_ _04681_ VGND VGND VPWR VPWR _04682_ sky130_fd_sc_hd__nor2_1
XFILLER_17_345 VPWR VGND VPWR VGND sky130_ef_sc_hd__decap_12
XFILLER_72_462 VGND VGND VPWR VPWR sky130_fd_sc_hd__fill_1
X_11875_ _04605_ _04609_ VGND VGND VPWR VPWR _04610_ sky130_fd_sc_hd__xnor2_1
X_13614_ _06216_ _06309_ _06411_ VGND VGND VPWR VPWR _06504_ sky130_fd_sc_hd__o21ai_1
XTAP_TAPCELL_ROW_15_513 VGND VPWR sky130_fd_sc_hd__tapvpwrvgnd_1
X_10826_ net611 net604 net325 net323 VGND VGND VPWR VPWR _03465_ sky130_fd_sc_hd__nand4_1
XFILLER_32_326 VGND VGND VPWR VPWR sky130_fd_sc_hd__decap_8
XFILLER_32_348 VPWR VGND VPWR VGND sky130_ef_sc_hd__decap_12
XFILLER_13_540 VGND VGND VPWR VPWR sky130_fd_sc_hd__decap_8
X_13545_ _06340_ _06344_ _06427_ VGND VGND VPWR VPWR _06429_ sky130_fd_sc_hd__a21o_1
X_10757_ _03387_ _03388_ VGND VGND VPWR VPWR _03389_ sky130_fd_sc_hd__nand2_1
X_13476_ _06330_ _06352_ VGND VGND VPWR VPWR _06354_ sky130_fd_sc_hd__xnor2_1
XFILLER_72_7 VPWR VGND VPWR VGND sky130_ef_sc_hd__decap_12
XFILLER_9_555 VGND VGND VPWR VPWR sky130_fd_sc_hd__decap_4
X_10688_ _03312_ _03313_ VGND VGND VPWR VPWR _03315_ sky130_fd_sc_hd__and2b_1
X_12427_ _05206_ _05207_ _05054_ _05058_ VGND VGND VPWR VPWR _05209_ sky130_fd_sc_hd__o211ai_2
XFILLER_9_599 VPWR VGND VPWR VGND sky130_ef_sc_hd__decap_12
XFILLER_126_475 VGND VGND VPWR VPWR sky130_fd_sc_hd__fill_1
XFILLER_99_315 VPWR VGND VPWR VGND sky130_ef_sc_hd__decap_12
X_12358_ _04817_ _04987_ _04986_ VGND VGND VPWR VPWR _05134_ sky130_fd_sc_hd__a21o_1
XFILLER_5_783 VGND VGND VPWR VPWR sky130_fd_sc_hd__fill_1
XFILLER_99_337 VGND VGND VPWR VPWR sky130_fd_sc_hd__fill_1
X_12289_ _04968_ _04970_ _05053_ _05055_ VGND VGND VPWR VPWR _05059_ sky130_fd_sc_hd__o22a_1
X_11309_ _03830_ _03843_ _03842_ VGND VGND VPWR VPWR _03994_ sky130_fd_sc_hd__a21o_1
XFILLER_68_713 VPWR VGND VPWR VGND sky130_ef_sc_hd__decap_12
XFILLER_110_821 VGND VGND VPWR VPWR sky130_fd_sc_hd__decap_3
XFILLER_68_757 VPWR VGND VPWR VGND sky130_ef_sc_hd__decap_12
X_06850_ net526 net687 VGND VGND VPWR VPWR _01703_ sky130_fd_sc_hd__nand2_1
XTAP_TAPCELL_ROW_128_2161 VGND VPWR sky130_fd_sc_hd__tapvpwrvgnd_1
XTAP_TAPCELL_ROW_128_2150 VGND VPWR sky130_fd_sc_hd__tapvpwrvgnd_1
XFILLER_95_587 VGND VGND VPWR VPWR sky130_fd_sc_hd__decap_8
XFILLER_67_289 VGND VGND VPWR VPWR sky130_fd_sc_hd__fill_1
X_08520_ _00989_ _00991_ VGND VGND VPWR VPWR _00992_ sky130_fd_sc_hd__xnor2_1
X_08451_ _00871_ _00873_ VGND VGND VPWR VPWR _00924_ sky130_fd_sc_hd__and2b_1
X_07402_ _06629_ _06630_ VGND VGND VPWR VPWR _06632_ sky130_fd_sc_hd__xnor2_2
XFILLER_23_337 VGND VGND VPWR VPWR sky130_fd_sc_hd__decap_8
X_08382_ _00568_ _00695_ _00854_ VGND VGND VPWR VPWR _00856_ sky130_fd_sc_hd__nand3_1
X_07333_ _04504_ _04526_ _06562_ _06563_ VGND VGND VPWR VPWR _06564_ sky130_fd_sc_hd__o211ai_2
XFILLER_137_729 VPWR VGND VPWR VGND sky130_ef_sc_hd__decap_12
X_07264_ _04697_ _06203_ VGND VGND VPWR VPWR _06214_ sky130_fd_sc_hd__nor2_1
X_09003_ _01478_ _01479_ _01480_ VGND VGND VPWR VPWR _01481_ sky130_fd_sc_hd__nand3_1
X_07195_ _04253_ _05428_ _05439_ VGND VGND VPWR VPWR _05461_ sky130_fd_sc_hd__or3_1
XFILLER_3_709 VPWR VGND VPWR VGND sky130_ef_sc_hd__decap_12
XTAP_TAPCELL_ROW_57_1123 VGND VPWR sky130_fd_sc_hd__tapvpwrvgnd_1
XFILLER_132_445 VGND VGND VPWR VPWR sky130_fd_sc_hd__decap_8
X_09905_ net549 _00436_ _02333_ net354 VGND VGND VPWR VPWR _02463_ sky130_fd_sc_hd__o211a_1
Xfanout501 net15 VGND VGND VPWR VPWR net501 sky130_fd_sc_hd__clkbuf_2
Xfanout523 net525 VGND VGND VPWR VPWR net523 sky130_fd_sc_hd__clkbuf_4
XTAP_TAPCELL_ROW_70_1312 VGND VPWR sky130_fd_sc_hd__tapvpwrvgnd_1
Xfanout512 net513 VGND VGND VPWR VPWR net512 sky130_fd_sc_hd__clkbuf_2
Xfanout556 net558 VGND VGND VPWR VPWR net556 sky130_fd_sc_hd__buf_2
XFILLER_59_757 VGND VGND VPWR VPWR sky130_fd_sc_hd__decap_6
Xfanout534 net145 VGND VGND VPWR VPWR net534 sky130_fd_sc_hd__buf_4
Xfanout545 net547 VGND VGND VPWR VPWR net545 sky130_fd_sc_hd__buf_2
X_09836_ net614 net367 VGND VGND VPWR VPWR _02389_ sky130_fd_sc_hd__nand2_1
Xfanout567 net141 VGND VGND VPWR VPWR net567 sky130_fd_sc_hd__clkbuf_4
Xfanout578 net14 VGND VGND VPWR VPWR net578 sky130_fd_sc_hd__clkbuf_2
XFILLER_74_716 VGND VGND VPWR VPWR sky130_fd_sc_hd__fill_2
XFILLER_58_245 VGND VGND VPWR VPWR sky130_fd_sc_hd__decap_6
Xfanout589 net591 VGND VGND VPWR VPWR net589 sky130_fd_sc_hd__buf_2
X_09767_ _02312_ _02313_ VGND VGND VPWR VPWR _02314_ sky130_fd_sc_hd__nor2_1
X_06979_ _03074_ _03084_ VGND VGND VPWR VPWR _03106_ sky130_fd_sc_hd__and2_1
X_09698_ _02231_ _02237_ VGND VGND VPWR VPWR _02239_ sky130_fd_sc_hd__xnor2_1
X_08718_ _01182_ _01183_ _01184_ VGND VGND VPWR VPWR _01185_ sky130_fd_sc_hd__or3_4
XFILLER_92_27 VGND VGND VPWR VPWR sky130_fd_sc_hd__fill_1
X_08649_ _01112_ _01115_ VGND VGND VPWR VPWR _01116_ sky130_fd_sc_hd__nand2_1
XFILLER_82_771 VGND VGND VPWR VPWR sky130_fd_sc_hd__decap_6
XFILLER_27_665 VGND VGND VPWR VPWR sky130_fd_sc_hd__fill_1
XFILLER_81_281 VGND VGND VPWR VPWR sky130_fd_sc_hd__decap_4
XFILLER_81_270 VGND VGND VPWR VPWR sky130_fd_sc_hd__decap_8
XTAP_TAPCELL_ROW_68_1285 VGND VPWR sky130_fd_sc_hd__tapvpwrvgnd_1
XFILLER_41_101 VGND VGND VPWR VPWR sky130_fd_sc_hd__fill_2
XFILLER_26_197 VGND VGND VPWR VPWR sky130_fd_sc_hd__decap_8
XFILLER_42_657 VGND VGND VPWR VPWR sky130_fd_sc_hd__fill_1
XFILLER_25_76 VGND VGND VPWR VPWR sky130_fd_sc_hd__decap_6
X_11660_ _04364_ _04375_ VGND VGND VPWR VPWR _04376_ sky130_fd_sc_hd__xor2_1
XFILLER_30_819 VGND VGND VPWR VPWR sky130_fd_sc_hd__fill_1
XTAP_TAPCELL_ROW_81_1474 VGND VPWR sky130_fd_sc_hd__tapvpwrvgnd_1
X_10611_ _03228_ _03229_ VGND VGND VPWR VPWR _03230_ sky130_fd_sc_hd__and2b_1
X_11591_ _03709_ _03710_ _03870_ _04299_ VGND VGND VPWR VPWR _04301_ sky130_fd_sc_hd__or4bb_4
XFILLER_10_510 VGND VGND VPWR VPWR sky130_fd_sc_hd__fill_1
X_13330_ _06078_ _06080_ _06077_ VGND VGND VPWR VPWR _06195_ sky130_fd_sc_hd__a21oi_1
X_10542_ net611 net327 VGND VGND VPWR VPWR _03155_ sky130_fd_sc_hd__nand2_1
XFILLER_127_239 VGND VGND VPWR VPWR sky130_fd_sc_hd__decap_8
X_13261_ _06112_ _06118_ VGND VGND VPWR VPWR _06120_ sky130_fd_sc_hd__xnor2_1
XFILLER_10_587 VGND VGND VPWR VPWR sky130_fd_sc_hd__fill_1
X_12212_ net516 net507 net403 net400 VGND VGND VPWR VPWR _04974_ sky130_fd_sc_hd__nand4_1
X_10473_ net554 net312 net76 net562 VGND VGND VPWR VPWR _03079_ sky130_fd_sc_hd__a22oi_1
XTAP_TAPCELL_ROW_20_582 VGND VPWR sky130_fd_sc_hd__tapvpwrvgnd_1
XTAP_TAPCELL_ROW_20_593 VGND VPWR sky130_fd_sc_hd__tapvpwrvgnd_1
X_13192_ net548 net422 _05894_ _06041_ _05740_ VGND VGND VPWR VPWR _06044_ sky130_fd_sc_hd__a311o_1
XFILLER_123_423 VPWR VGND VPWR VGND sky130_ef_sc_hd__decap_12
X_12143_ _04895_ _04897_ _04898_ VGND VGND VPWR VPWR _04899_ sky130_fd_sc_hd__nand3_1
X_12074_ _04821_ _04822_ VGND VGND VPWR VPWR _04823_ sky130_fd_sc_hd__and2b_1
XFILLER_1_252 VGND VGND VPWR VPWR sky130_fd_sc_hd__decap_8
XFILLER_110_139 VGND VGND VPWR VPWR sky130_fd_sc_hd__fill_1
XFILLER_104_681 VPWR VGND VPWR VGND sky130_ef_sc_hd__decap_12
XFILLER_49_223 VGND VGND VPWR VPWR sky130_fd_sc_hd__fill_1
XFILLER_49_201 VGND VGND VPWR VPWR sky130_fd_sc_hd__fill_2
X_11025_ _03499_ _03502_ _03681_ _03682_ VGND VGND VPWR VPWR _03683_ sky130_fd_sc_hd__o211ai_2
XFILLER_103_191 VGND VGND VPWR VPWR sky130_fd_sc_hd__decap_8
XFILLER_65_716 VPWR VGND VPWR VGND sky130_ef_sc_hd__decap_12
XFILLER_64_215 VGND VGND VPWR VPWR sky130_fd_sc_hd__decap_6
XFILLER_49_278 VGND VGND VPWR VPWR sky130_fd_sc_hd__fill_2
XFILLER_17_120 VPWR VGND VPWR VGND sky130_ef_sc_hd__decap_12
XFILLER_18_643 VGND VGND VPWR VPWR sky130_fd_sc_hd__fill_1
X_12976_ _05805_ _05806_ VGND VGND VPWR VPWR _05808_ sky130_fd_sc_hd__xnor2_1
XFILLER_45_462 VPWR VGND VPWR VGND sky130_ef_sc_hd__decap_12
XTAP_TAPCELL_ROW_123_2080 VGND VPWR sky130_fd_sc_hd__tapvpwrvgnd_1
X_11927_ net529 net407 VGND VGND VPWR VPWR _04664_ sky130_fd_sc_hd__nand2_1
XFILLER_17_197 VGND VGND VPWR VPWR sky130_fd_sc_hd__fill_1
X_11858_ _04513_ _04517_ _04589_ VGND VGND VPWR VPWR _04592_ sky130_fd_sc_hd__or3_1
XANTENNA_19 net465 VGND VGND VPWR VPWR sky130_fd_sc_hd__diode_2
X_11789_ _04516_ _04506_ VGND VGND VPWR VPWR _04517_ sky130_fd_sc_hd__and2b_1
X_10809_ _03443_ _03446_ VGND VGND VPWR VPWR _03447_ sky130_fd_sc_hd__nand2_1
XFILLER_32_189 VGND VGND VPWR VPWR sky130_fd_sc_hd__decap_6
XTAP_TAPCELL_ROW_99_1735 VGND VPWR sky130_fd_sc_hd__tapvpwrvgnd_1
X_13528_ _06215_ _06307_ _06308_ VGND VGND VPWR VPWR _06411_ sky130_fd_sc_hd__or3b_1
X_13459_ net256 net379 net254 VGND VGND VPWR VPWR _06336_ sky130_fd_sc_hd__o21ai_1
XFILLER_63_3 VPWR VGND VPWR VGND sky130_ef_sc_hd__decap_12
XFILLER_102_618 VPWR VGND VPWR VGND sky130_ef_sc_hd__decap_12
XFILLER_102_607 VGND VGND VPWR VPWR sky130_fd_sc_hd__fill_1
XFILLER_99_167 VGND VGND VPWR VPWR sky130_fd_sc_hd__fill_1
X_07951_ _00426_ _00428_ VGND VGND VPWR VPWR _00041_ sky130_fd_sc_hd__xor2_1
XFILLER_87_329 VGND VGND VPWR VPWR sky130_fd_sc_hd__decap_6
X_06902_ net701 net580 net699 net589 VGND VGND VPWR VPWR _02271_ sky130_fd_sc_hd__a22oi_1
XFILLER_68_543 VPWR VGND VPWR VGND sky130_ef_sc_hd__decap_12
X_07882_ _00357_ _00358_ VGND VGND VPWR VPWR _00360_ sky130_fd_sc_hd__xnor2_1
XTAP_TAPCELL_ROW_52_1053 VGND VPWR sky130_fd_sc_hd__tapvpwrvgnd_1
X_09621_ _02127_ _02154_ VGND VGND VPWR VPWR _02155_ sky130_fd_sc_hd__xnor2_2
XFILLER_95_373 VGND VGND VPWR VPWR sky130_fd_sc_hd__decap_8
XFILLER_68_587 VGND VGND VPWR VPWR sky130_fd_sc_hd__fill_1
X_06833_ _01486_ _01497_ _01508_ VGND VGND VPWR VPWR _01518_ sky130_fd_sc_hd__nor3_1
X_09552_ _02077_ _02078_ VGND VGND VPWR VPWR _02079_ sky130_fd_sc_hd__nand2b_1
XFILLER_83_546 VGND VGND VPWR VPWR sky130_fd_sc_hd__fill_2
XTAP_TAPCELL_ROW_108_1864 VGND VPWR sky130_fd_sc_hd__tapvpwrvgnd_1
X_08503_ _00723_ _00722_ _00806_ VGND VGND VPWR VPWR _00975_ sky130_fd_sc_hd__mux2_1
X_09483_ _01804_ _01836_ _01834_ VGND VGND VPWR VPWR _02004_ sky130_fd_sc_hd__a21bo_1
XFILLER_62_19 VGND VGND VPWR VPWR sky130_fd_sc_hd__decap_8
XTAP_TAPCELL_ROW_47_980 VGND VPWR sky130_fd_sc_hd__tapvpwrvgnd_1
XFILLER_24_613 VGND VGND VPWR VPWR sky130_fd_sc_hd__decap_8
XFILLER_36_473 VGND VGND VPWR VPWR sky130_fd_sc_hd__decap_3
XFILLER_63_292 VPWR VGND VPWR VGND sky130_ef_sc_hd__decap_12
X_08434_ _00905_ _00906_ VGND VGND VPWR VPWR _00907_ sky130_fd_sc_hd__nor2_1
XFILLER_51_443 VGND VGND VPWR VPWR sky130_fd_sc_hd__decap_4
XFILLER_12_819 VGND VGND VPWR VPWR sky130_fd_sc_hd__fill_1
XFILLER_24_657 VGND VGND VPWR VPWR sky130_fd_sc_hd__fill_2
X_08365_ _00836_ _00837_ VGND VGND VPWR VPWR _00839_ sky130_fd_sc_hd__and2_1
XFILLER_11_307 VGND VGND VPWR VPWR sky130_fd_sc_hd__decap_4
X_07316_ _06543_ _06544_ _06545_ VGND VGND VPWR VPWR _06547_ sky130_fd_sc_hd__a21o_1
X_08296_ _00769_ _00770_ VGND VGND VPWR VPWR _00771_ sky130_fd_sc_hd__nor2_1
X_07247_ net116 net494 VGND VGND VPWR VPWR _06029_ sky130_fd_sc_hd__nand2_1
XFILLER_133_710 VGND VGND VPWR VPWR sky130_fd_sc_hd__decap_8
XFILLER_124_209 VPWR VGND VPWR VGND sky130_ef_sc_hd__decap_12
XFILLER_118_762 VGND VGND VPWR VPWR sky130_fd_sc_hd__fill_1
XFILLER_117_261 VGND VGND VPWR VPWR sky130_fd_sc_hd__decap_3
X_07178_ _05231_ _05253_ _03609_ _03631_ VGND VGND VPWR VPWR _05275_ sky130_fd_sc_hd__o211a_1
XFILLER_132_264 VGND VGND VPWR VPWR sky130_fd_sc_hd__fill_2
Xfanout331 net332 VGND VGND VPWR VPWR net331 sky130_fd_sc_hd__buf_2
XFILLER_78_329 VPWR VGND VPWR VGND sky130_ef_sc_hd__decap_12
Xfanout320 net7 VGND VGND VPWR VPWR net320 sky130_fd_sc_hd__clkbuf_4
Xfanout364 net43 VGND VGND VPWR VPWR net364 sky130_fd_sc_hd__buf_2
Xfanout342 net343 VGND VGND VPWR VPWR net342 sky130_fd_sc_hd__buf_2
XFILLER_120_448 VGND VGND VPWR VPWR sky130_fd_sc_hd__decap_8
Xfanout375 net35 VGND VGND VPWR VPWR net375 sky130_fd_sc_hd__buf_2
XFILLER_86_340 VPWR VGND VPWR VGND sky130_ef_sc_hd__decap_12
Xfanout353 net5 VGND VGND VPWR VPWR net353 sky130_fd_sc_hd__clkbuf_4
X_09819_ net525 net343 _02244_ _02243_ net413 VGND VGND VPWR VPWR _02371_ sky130_fd_sc_hd__a32o_1
Xfanout397 net23 VGND VGND VPWR VPWR net397 sky130_fd_sc_hd__clkbuf_4
XFILLER_86_384 VPWR VGND VPWR VGND sky130_ef_sc_hd__decap_12
XFILLER_74_524 VGND VGND VPWR VPWR sky130_fd_sc_hd__decap_8
Xfanout386 net3 VGND VGND VPWR VPWR net386 sky130_fd_sc_hd__buf_2
XFILLER_47_727 VGND VGND VPWR VPWR sky130_fd_sc_hd__fill_1
XFILLER_46_215 VPWR VGND VPWR VGND sky130_ef_sc_hd__decap_12
XTAP_TAPCELL_ROW_6_388 VGND VPWR sky130_fd_sc_hd__tapvpwrvgnd_1
XFILLER_101_695 VGND VGND VPWR VPWR sky130_fd_sc_hd__decap_8
X_12830_ _05642_ _05647_ VGND VGND VPWR VPWR _05649_ sky130_fd_sc_hd__xor2_1
XTAP_TAPCELL_ROW_83_1503 VGND VPWR sky130_fd_sc_hd__tapvpwrvgnd_1
XFILLER_36_53 VPWR VGND VPWR VGND sky130_ef_sc_hd__decap_12
X_12761_ _05571_ _05572_ VGND VGND VPWR VPWR _05573_ sky130_fd_sc_hd__nor2_1
XFILLER_42_421 VPWR VGND VPWR VGND sky130_ef_sc_hd__decap_12
XFILLER_27_473 VPWR VGND VPWR VGND sky130_ef_sc_hd__decap_12
XFILLER_36_97 VPWR VGND VPWR VGND sky130_ef_sc_hd__decap_12
X_12692_ net453 net382 net380 net461 VGND VGND VPWR VPWR _05499_ sky130_fd_sc_hd__a22o_1
X_11712_ _04341_ _04343_ _04430_ VGND VGND VPWR VPWR _04432_ sky130_fd_sc_hd__or3b_1
XFILLER_15_668 VGND VGND VPWR VPWR sky130_fd_sc_hd__fill_1
XFILLER_52_41 VPWR VGND VPWR VGND sky130_ef_sc_hd__decap_12
XFILLER_14_156 VGND VGND VPWR VPWR sky130_fd_sc_hd__decap_4
XTAP_TAPCELL_ROW_25_663 VGND VPWR sky130_fd_sc_hd__tapvpwrvgnd_1
X_11643_ _04350_ _04355_ VGND VGND VPWR VPWR _04357_ sky130_fd_sc_hd__xor2_1
XFILLER_52_85 VPWR VGND VPWR VGND sky130_ef_sc_hd__decap_12
Xinput17 w01[7] VGND VGND VPWR VPWR net17 sky130_fd_sc_hd__clkbuf_2
Xinput28 w03[2] VGND VGND VPWR VPWR net28 sky130_fd_sc_hd__buf_1
XFILLER_10_340 VPWR VGND VPWR VGND sky130_ef_sc_hd__decap_12
X_11574_ _04279_ _04280_ VGND VGND VPWR VPWR _04282_ sky130_fd_sc_hd__xor2_1
Xinput39 w10[5] VGND VGND VPWR VPWR net39 sky130_fd_sc_hd__buf_1
X_13313_ _06069_ _06071_ _06175_ VGND VGND VPWR VPWR _06176_ sky130_fd_sc_hd__o21ba_1
XFILLER_6_322 VPWR VGND VPWR VGND sky130_ef_sc_hd__decap_12
X_10525_ _03134_ _03135_ VGND VGND VPWR VPWR _03136_ sky130_fd_sc_hd__nor2_1
XFILLER_109_773 VGND VGND VPWR VPWR sky130_fd_sc_hd__decap_8
X_13244_ _06074_ _06100_ VGND VGND VPWR VPWR _06101_ sky130_fd_sc_hd__and2b_1
X_10456_ _03050_ _03053_ _03055_ _03059_ VGND VGND VPWR VPWR _03061_ sky130_fd_sc_hd__o211ai_1
XFILLER_124_732 VGND VGND VPWR VPWR sky130_fd_sc_hd__fill_1
X_13175_ _05735_ _06025_ VGND VGND VPWR VPWR _06026_ sky130_fd_sc_hd__xor2_2
XTAP_TAPCELL_ROW_94_1665 VGND VPWR sky130_fd_sc_hd__tapvpwrvgnd_1
XFILLER_124_754 VGND VGND VPWR VPWR sky130_fd_sc_hd__fill_2
XFILLER_97_605 VGND VGND VPWR VPWR sky130_fd_sc_hd__decap_8
X_12126_ _04869_ _04872_ _04870_ VGND VGND VPWR VPWR _04880_ sky130_fd_sc_hd__o21ai_1
X_10387_ _02983_ _02984_ VGND VGND VPWR VPWR _02985_ sky130_fd_sc_hd__nor2_1
XFILLER_96_126 VGND VGND VPWR VPWR sky130_fd_sc_hd__fill_1
X_12057_ _04801_ _04803_ VGND VGND VPWR VPWR _04804_ sky130_fd_sc_hd__or2_1
XFILLER_77_71 VGND VGND VPWR VPWR sky130_fd_sc_hd__fill_2
XFILLER_77_362 VGND VGND VPWR VPWR sky130_fd_sc_hd__fill_2
X_11008_ net619 net319 net317 net628 VGND VGND VPWR VPWR _03665_ sky130_fd_sc_hd__a22o_1
XFILLER_92_321 VPWR VGND VPWR VGND sky130_ef_sc_hd__decap_12
XFILLER_93_81 VGND VGND VPWR VPWR sky130_fd_sc_hd__fill_2
X_12959_ _05629_ _05786_ _05787_ VGND VGND VPWR VPWR _05790_ sky130_fd_sc_hd__and3_1
XFILLER_61_741 VPWR VGND VPWR VGND sky130_ef_sc_hd__decap_12
XFILLER_61_785 VPWR VGND VPWR VGND sky130_ef_sc_hd__decap_12
XFILLER_61_774 VGND VGND VPWR VPWR sky130_fd_sc_hd__fill_1
XTAP_TAPCELL_ROW_103_1794 VGND VPWR sky130_fd_sc_hd__tapvpwrvgnd_1
X_08150_ _00623_ _00624_ VGND VGND VPWR VPWR _00626_ sky130_fd_sc_hd__xor2_1
XFILLER_119_526 VGND VGND VPWR VPWR sky130_fd_sc_hd__fill_2
X_07101_ _04406_ _04428_ VGND VGND VPWR VPWR _04438_ sky130_fd_sc_hd__nand2_1
XTAP_TAPCELL_ROW_136_2271 VGND VPWR sky130_fd_sc_hd__tapvpwrvgnd_1
X_08081_ _00466_ _00468_ _00556_ VGND VGND VPWR VPWR _00557_ sky130_fd_sc_hd__o21ba_1
XFILLER_9_182 VPWR VGND VPWR VGND sky130_ef_sc_hd__decap_12
XFILLER_115_710 VPWR VGND VPWR VGND sky130_ef_sc_hd__decap_12
X_07032_ _03587_ _03653_ _01987_ VGND VGND VPWR VPWR _03686_ sky130_fd_sc_hd__a21o_1
XFILLER_114_253 VGND VGND VPWR VPWR sky130_fd_sc_hd__decap_4
XFILLER_88_605 VGND VGND VPWR VPWR sky130_fd_sc_hd__fill_2
X_08983_ _01456_ _01457_ _01312_ VGND VGND VPWR VPWR _01459_ sky130_fd_sc_hd__a21oi_1
XFILLER_130_757 VPWR VGND VPWR VGND sky130_ef_sc_hd__decap_12
X_07934_ _00223_ _00274_ _00273_ VGND VGND VPWR VPWR _00412_ sky130_fd_sc_hd__a21o_1
XFILLER_84_811 VGND VGND VPWR VPWR sky130_fd_sc_hd__fill_1
X_07865_ _00197_ _00342_ net675 VGND VGND VPWR VPWR _00343_ sky130_fd_sc_hd__and3b_1
XTAP_TAPCELL_ROW_3_336 VGND VPWR sky130_fd_sc_hd__tapvpwrvgnd_1
X_09604_ _02130_ _02135_ VGND VGND VPWR VPWR _02136_ sky130_fd_sc_hd__and2b_1
XTAP_TAPCELL_ROW_3_347 VGND VPWR sky130_fd_sc_hd__tapvpwrvgnd_1
XFILLER_113_69 VGND VGND VPWR VPWR sky130_fd_sc_hd__decap_8
XFILLER_83_343 VPWR VGND VPWR VGND sky130_ef_sc_hd__decap_12
XFILLER_71_505 VGND VGND VPWR VPWR sky130_fd_sc_hd__decap_6
X_07796_ _00223_ _00274_ VGND VGND VPWR VPWR _00275_ sky130_fd_sc_hd__xnor2_2
XFILLER_43_207 VGND VGND VPWR VPWR sky130_fd_sc_hd__fill_1
XFILLER_37_760 VPWR VGND VPWR VGND sky130_ef_sc_hd__decap_12
X_09535_ _01894_ _02058_ VGND VGND VPWR VPWR _02060_ sky130_fd_sc_hd__xnor2_1
XFILLER_43_218 VGND VGND VPWR VPWR sky130_fd_sc_hd__decap_6
XFILLER_24_421 VPWR VGND VPWR VGND sky130_ef_sc_hd__decap_12
X_09466_ net614 net372 _01983_ _01984_ VGND VGND VPWR VPWR _01985_ sky130_fd_sc_hd__o2bb2a_1
XTAP_TAPCELL_ROW_65_1244 VGND VPWR sky130_fd_sc_hd__tapvpwrvgnd_1
XFILLER_52_741 VGND VGND VPWR VPWR sky130_fd_sc_hd__decap_3
XTAP_TAPCELL_ROW_42_909 VGND VPWR sky130_fd_sc_hd__tapvpwrvgnd_1
XFILLER_24_465 VGND VGND VPWR VPWR sky130_fd_sc_hd__decap_8
X_08417_ _00889_ _00890_ VGND VGND VPWR VPWR _00891_ sky130_fd_sc_hd__or2_1
X_09397_ _01868_ _01908_ VGND VGND VPWR VPWR _01910_ sky130_fd_sc_hd__xnor2_1
XFILLER_12_638 VGND VGND VPWR VPWR sky130_fd_sc_hd__decap_6
XTAP_TAPCELL_ROW_22_611 VGND VPWR sky130_fd_sc_hd__tapvpwrvgnd_1
XTAP_TAPCELL_ROW_22_622 VGND VPWR sky130_fd_sc_hd__tapvpwrvgnd_1
XFILLER_138_813 VGND VGND VPWR VPWR sky130_fd_sc_hd__decap_8
X_08348_ _00761_ _00773_ _00771_ VGND VGND VPWR VPWR _00822_ sky130_fd_sc_hd__a21o_1
XFILLER_11_148 VGND VGND VPWR VPWR sky130_fd_sc_hd__decap_3
X_08279_ _00642_ _00653_ _00652_ VGND VGND VPWR VPWR _00754_ sky130_fd_sc_hd__a21bo_1
XFILLER_98_15 VPWR VGND VPWR VGND sky130_ef_sc_hd__decap_12
X_10310_ _02891_ _02899_ VGND VGND VPWR VPWR _02901_ sky130_fd_sc_hd__nand2_1
X_11290_ net602 net319 VGND VGND VPWR VPWR _03973_ sky130_fd_sc_hd__nand2_1
X_10241_ net580 net313 net311 net589 VGND VGND VPWR VPWR _02827_ sky130_fd_sc_hd__a22o_1
XFILLER_3_369 VPWR VGND VPWR VGND sky130_ef_sc_hd__decap_12
XFILLER_3_358 VGND VGND VPWR VPWR sky130_fd_sc_hd__decap_4
X_10172_ _02754_ _02753_ VGND VGND VPWR VPWR _02755_ sky130_fd_sc_hd__nand2b_1
XFILLER_105_286 VPWR VGND VPWR VGND sky130_ef_sc_hd__decap_12
XFILLER_78_104 VGND VGND VPWR VPWR sky130_fd_sc_hd__fill_1
XTAP_TAPCELL_ROW_76_1395 VGND VPWR sky130_fd_sc_hd__tapvpwrvgnd_1
XFILLER_121_779 VGND VGND VPWR VPWR sky130_fd_sc_hd__decap_4
XFILLER_94_608 VPWR VGND VPWR VGND sky130_ef_sc_hd__decap_12
XFILLER_120_289 VGND VGND VPWR VPWR sky130_fd_sc_hd__fill_2
XFILLER_87_671 VGND VGND VPWR VPWR sky130_fd_sc_hd__fill_1
XFILLER_75_800 VGND VGND VPWR VPWR sky130_fd_sc_hd__decap_4
XFILLER_86_170 VPWR VGND VPWR VGND sky130_ef_sc_hd__decap_12
XFILLER_19_237 VPWR VGND VPWR VGND sky130_ef_sc_hd__decap_12
XFILLER_74_365 VPWR VGND VPWR VGND sky130_ef_sc_hd__decap_12
XFILLER_34_207 VPWR VGND VPWR VGND sky130_ef_sc_hd__decap_12
X_12813_ net514 net506 net24 net394 VGND VGND VPWR VPWR _05630_ sky130_fd_sc_hd__and4_1
XFILLER_62_538 VGND VGND VPWR VPWR sky130_fd_sc_hd__decap_8
XFILLER_28_793 VPWR VGND VPWR VGND sky130_ef_sc_hd__decap_12
X_12744_ _05552_ _05553_ _05376_ _05378_ VGND VGND VPWR VPWR _05555_ sky130_fd_sc_hd__o211ai_2
XFILLER_63_51 VGND VGND VPWR VPWR sky130_fd_sc_hd__decap_4
XFILLER_27_281 VGND VGND VPWR VPWR sky130_fd_sc_hd__fill_2
XFILLER_97_9 VPWR VGND VPWR VGND sky130_ef_sc_hd__decap_12
XFILLER_43_785 VPWR VGND VPWR VGND sky130_ef_sc_hd__decap_12
X_12675_ _05470_ _05479_ VGND VGND VPWR VPWR _05480_ sky130_fd_sc_hd__xor2_1
X_11626_ _04335_ _04336_ VGND VGND VPWR VPWR _04338_ sky130_fd_sc_hd__xor2_1
XFILLER_30_468 VGND VGND VPWR VPWR sky130_fd_sc_hd__fill_1
XFILLER_128_345 VGND VGND VPWR VPWR sky130_fd_sc_hd__decap_4
X_11557_ net433 net424 net270 VGND VGND VPWR VPWR _04263_ sky130_fd_sc_hd__and3_1
XFILLER_7_664 VGND VGND VPWR VPWR sky130_fd_sc_hd__decap_8
X_10508_ _03115_ _03116_ VGND VGND VPWR VPWR _03118_ sky130_fd_sc_hd__and2b_1
X_11488_ _04050_ _04052_ VGND VGND VPWR VPWR _04189_ sky130_fd_sc_hd__nand2_1
XFILLER_124_540 VGND VGND VPWR VPWR sky130_fd_sc_hd__fill_1
X_13227_ _06076_ _06081_ VGND VGND VPWR VPWR _06082_ sky130_fd_sc_hd__nand2b_1
X_10439_ _03034_ _03040_ _03042_ VGND VGND VPWR VPWR _03043_ sky130_fd_sc_hd__and3_2
XFILLER_112_713 VGND VGND VPWR VPWR sky130_fd_sc_hd__fill_1
X_13158_ _06004_ _06005_ VGND VGND VPWR VPWR _06008_ sky130_fd_sc_hd__xnor2_2
XFILLER_112_757 VPWR VGND VPWR VGND sky130_ef_sc_hd__decap_12
X_13089_ _05892_ _05931_ VGND VGND VPWR VPWR _05932_ sky130_fd_sc_hd__and2b_1
X_12109_ _04858_ _04859_ _04857_ VGND VGND VPWR VPWR _04862_ sky130_fd_sc_hd__a21bo_1
XFILLER_69_137 VGND VGND VPWR VPWR sky130_fd_sc_hd__decap_8
XFILLER_84_118 VGND VGND VPWR VPWR sky130_fd_sc_hd__fill_1
XFILLER_78_682 VPWR VGND VPWR VGND sky130_ef_sc_hd__decap_12
XFILLER_26_3 VPWR VGND VPWR VGND sky130_ef_sc_hd__decap_12
XPHY_EDGE_ROW_108_Left_247 VGND VGND VPWR VPWR sky130_fd_sc_hd__decap_3
XFILLER_93_641 VGND VGND VPWR VPWR sky130_fd_sc_hd__fill_1
XFILLER_77_192 VGND VGND VPWR VPWR sky130_fd_sc_hd__fill_2
XFILLER_65_343 VGND VGND VPWR VPWR sky130_fd_sc_hd__fill_1
XFILLER_53_505 VPWR VGND VPWR VGND sky130_ef_sc_hd__decap_12
X_07650_ _00127_ _00128_ _06781_ VGND VGND VPWR VPWR _00130_ sky130_fd_sc_hd__a21o_1
XTAP_TAPCELL_ROW_0_306 VGND VPWR sky130_fd_sc_hd__tapvpwrvgnd_1
XTAP_TAPCELL_ROW_105_1823 VGND VPWR sky130_fd_sc_hd__tapvpwrvgnd_1
X_07581_ _06809_ _06808_ VGND VGND VPWR VPWR _06810_ sky130_fd_sc_hd__nand2b_1
X_09320_ _01819_ _01825_ _01826_ VGND VGND VPWR VPWR _01827_ sky130_fd_sc_hd__nand3_1
XFILLER_80_335 VGND VGND VPWR VPWR sky130_fd_sc_hd__decap_3
X_09251_ _01749_ _01750_ VGND VGND VPWR VPWR _01751_ sky130_fd_sc_hd__xnor2_1
XTAP_TAPCELL_ROW_138_2311 VGND VPWR sky130_fd_sc_hd__tapvpwrvgnd_1
XTAP_TAPCELL_ROW_138_2300 VGND VPWR sky130_fd_sc_hd__tapvpwrvgnd_1
X_08202_ _00426_ _00554_ VGND VGND VPWR VPWR _00678_ sky130_fd_sc_hd__nand2b_1
XFILLER_21_446 VGND VGND VPWR VPWR sky130_fd_sc_hd__fill_2
XFILLER_138_109 VGND VGND VPWR VPWR sky130_fd_sc_hd__decap_3
X_09182_ _01675_ _01674_ VGND VGND VPWR VPWR _01676_ sky130_fd_sc_hd__and2b_1
XPHY_EDGE_ROW_117_Left_256 VGND VGND VPWR VPWR sky130_fd_sc_hd__decap_3
XFILLER_119_334 VGND VGND VPWR VPWR sky130_fd_sc_hd__fill_2
XTAP_TAPCELL_ROW_60_1174 VGND VPWR sky130_fd_sc_hd__tapvpwrvgnd_1
XTAP_TAPCELL_ROW_60_1163 VGND VPWR sky130_fd_sc_hd__tapvpwrvgnd_1
X_08133_ net665 _06801_ _00608_ VGND VGND VPWR VPWR _00609_ sky130_fd_sc_hd__o21a_1
XFILLER_119_356 VPWR VGND VPWR VGND sky130_ef_sc_hd__decap_12
XFILLER_107_529 VGND VGND VPWR VPWR sky130_fd_sc_hd__decap_6
X_08064_ _00501_ _00540_ VGND VGND VPWR VPWR _00541_ sky130_fd_sc_hd__xnor2_2
X_07015_ _03423_ _03434_ _03489_ VGND VGND VPWR VPWR _03500_ sky130_fd_sc_hd__nand3_1
XTAP_TAPCELL_ROW_116_1985 VGND VPWR sky130_fd_sc_hd__tapvpwrvgnd_1
XTAP_TAPCELL_ROW_116_1974 VGND VPWR sky130_fd_sc_hd__tapvpwrvgnd_1
XTAP_TAPCELL_ROW_8_417 VGND VPWR sky130_fd_sc_hd__tapvpwrvgnd_1
XFILLER_115_573 VGND VGND VPWR VPWR sky130_fd_sc_hd__decap_8
XFILLER_68_29 VPWR VGND VPWR VGND sky130_ef_sc_hd__decap_12
XFILLER_0_317 VGND VGND VPWR VPWR sky130_fd_sc_hd__fill_1
XPHY_EDGE_ROW_126_Left_265 VGND VGND VPWR VPWR sky130_fd_sc_hd__decap_3
X_08966_ net420 net341 VGND VGND VPWR VPWR _01440_ sky130_fd_sc_hd__nand2_1
XFILLER_76_619 VGND VGND VPWR VPWR sky130_fd_sc_hd__decap_3
XFILLER_69_671 VGND VGND VPWR VPWR sky130_fd_sc_hd__fill_1
XFILLER_29_513 VGND VGND VPWR VPWR sky130_fd_sc_hd__fill_2
X_08897_ _01363_ _01364_ VGND VGND VPWR VPWR _00063_ sky130_fd_sc_hd__and2b_1
XFILLER_84_630 VPWR VGND VPWR VGND sky130_ef_sc_hd__decap_12
X_07917_ net618 net705 net704 net627 VGND VGND VPWR VPWR _00395_ sky130_fd_sc_hd__a22oi_1
XFILLER_56_321 VGND VGND VPWR VPWR sky130_fd_sc_hd__fill_1
XFILLER_29_535 VGND VGND VPWR VPWR sky130_fd_sc_hd__fill_1
XFILLER_84_674 VGND VGND VPWR VPWR sky130_fd_sc_hd__fill_1
X_07848_ _00317_ _00325_ VGND VGND VPWR VPWR _00326_ sky130_fd_sc_hd__xnor2_2
XFILLER_17_719 VGND VGND VPWR VPWR sky130_fd_sc_hd__fill_1
XFILLER_71_324 VGND VGND VPWR VPWR sky130_fd_sc_hd__fill_1
XFILLER_56_376 VGND VGND VPWR VPWR sky130_fd_sc_hd__fill_1
XFILLER_17_55 VGND VGND VPWR VPWR sky130_fd_sc_hd__fill_1
X_09518_ _02039_ _02040_ VGND VGND VPWR VPWR _02042_ sky130_fd_sc_hd__and2b_1
XFILLER_71_335 VGND VGND VPWR VPWR sky130_fd_sc_hd__fill_1
X_07779_ net636 _00103_ VGND VGND VPWR VPWR _00258_ sky130_fd_sc_hd__and2_1
X_10790_ net528 net287 VGND VGND VPWR VPWR _03426_ sky130_fd_sc_hd__and2_2
XFILLER_25_785 VPWR VGND VPWR VGND sky130_ef_sc_hd__decap_12
XPHY_EDGE_ROW_135_Left_274 VGND VGND VPWR VPWR sky130_fd_sc_hd__decap_3
X_09449_ _01963_ _01964_ VGND VGND VPWR VPWR _01967_ sky130_fd_sc_hd__xnor2_1
XFILLER_24_273 VGND VGND VPWR VPWR sky130_fd_sc_hd__fill_1
XFILLER_130_3 VPWR VGND VPWR VGND sky130_ef_sc_hd__decap_12
X_12460_ _05244_ _05243_ VGND VGND VPWR VPWR _05245_ sky130_fd_sc_hd__nand2b_1
XFILLER_138_643 VGND VGND VPWR VPWR sky130_fd_sc_hd__fill_1
X_12391_ _05168_ _05169_ VGND VGND VPWR VPWR _05170_ sky130_fd_sc_hd__nor2_1
X_11411_ net442 _00231_ _03964_ net270 VGND VGND VPWR VPWR _04105_ sky130_fd_sc_hd__o211ai_4
XFILLER_138_665 VGND VGND VPWR VPWR sky130_fd_sc_hd__decap_6
XFILLER_126_805 VGND VGND VPWR VPWR sky130_fd_sc_hd__decap_6
XTAP_TAPCELL_ROW_78_1435 VGND VPWR sky130_fd_sc_hd__tapvpwrvgnd_1
XTAP_TAPCELL_ROW_78_1424 VGND VPWR sky130_fd_sc_hd__tapvpwrvgnd_1
X_11342_ _03880_ net299 _00436_ VGND VGND VPWR VPWR _04029_ sky130_fd_sc_hd__and3b_1
XFILLER_137_197 VGND VGND VPWR VPWR sky130_fd_sc_hd__decap_3
XFILLER_125_337 VPWR VGND VPWR VGND sky130_ef_sc_hd__decap_12
XFILLER_3_111 VGND VGND VPWR VPWR sky130_fd_sc_hd__fill_1
XTAP_TAPCELL_ROW_91_1613 VGND VPWR sky130_fd_sc_hd__tapvpwrvgnd_1
X_11273_ net433 net424 net274 net272 VGND VGND VPWR VPWR _03954_ sky130_fd_sc_hd__and4_1
XTAP_TAPCELL_ROW_91_1624 VGND VPWR sky130_fd_sc_hd__tapvpwrvgnd_1
X_13012_ net613 net320 VGND VGND VPWR VPWR _05848_ sky130_fd_sc_hd__nand2_1
XFILLER_3_155 VGND VGND VPWR VPWR sky130_fd_sc_hd__decap_6
X_10224_ net468 net281 VGND VGND VPWR VPWR _02808_ sky130_fd_sc_hd__nand2_1
X_10155_ _02718_ _02734_ VGND VGND VPWR VPWR _02736_ sky130_fd_sc_hd__xnor2_1
XFILLER_121_554 VGND VGND VPWR VPWR sky130_fd_sc_hd__decap_6
XFILLER_121_565 VGND VGND VPWR VPWR sky130_fd_sc_hd__fill_1
XFILLER_58_73 VGND VGND VPWR VPWR sky130_fd_sc_hd__fill_1
XFILLER_48_811 VGND VGND VPWR VPWR sky130_fd_sc_hd__fill_1
X_10086_ _02658_ _02659_ VGND VGND VPWR VPWR _02661_ sky130_fd_sc_hd__xor2_1
XFILLER_87_490 VGND VGND VPWR VPWR sky130_fd_sc_hd__decap_6
XFILLER_35_505 VPWR VGND VPWR VGND sky130_ef_sc_hd__decap_12
XTAP_TAPCELL_ROW_89_1586 VGND VPWR sky130_fd_sc_hd__tapvpwrvgnd_1
XFILLER_47_376 VGND VGND VPWR VPWR sky130_fd_sc_hd__decap_3
XFILLER_62_379 VPWR VGND VPWR VGND sky130_ef_sc_hd__decap_12
XFILLER_62_368 VGND VGND VPWR VPWR sky130_fd_sc_hd__fill_1
XFILLER_43_571 VPWR VGND VPWR VGND sky130_ef_sc_hd__decap_12
X_10988_ net442 net274 _03639_ _03640_ VGND VGND VPWR VPWR _03643_ sky130_fd_sc_hd__nand4_1
X_12727_ _05534_ _05535_ _05536_ VGND VGND VPWR VPWR _05537_ sky130_fd_sc_hd__nand3_1
XTAP_TAPCELL_ROW_100_1753 VGND VPWR sky130_fd_sc_hd__tapvpwrvgnd_1
XTAP_TAPCELL_ROW_100_1742 VGND VPWR sky130_fd_sc_hd__tapvpwrvgnd_1
X_12658_ net506 net23 net24 net514 VGND VGND VPWR VPWR _05462_ sky130_fd_sc_hd__a22o_1
XFILLER_31_777 VGND VGND VPWR VPWR sky130_fd_sc_hd__decap_6
X_11609_ _04317_ _04319_ VGND VGND VPWR VPWR _04320_ sky130_fd_sc_hd__nor2_1
XTAP_TAPCELL_ROW_13_485 VGND VPWR sky130_fd_sc_hd__tapvpwrvgnd_1
XFILLER_30_265 VGND VGND VPWR VPWR sky130_fd_sc_hd__decap_4
XFILLER_128_131 VGND VGND VPWR VPWR sky130_fd_sc_hd__decap_8
XFILLER_117_805 VPWR VGND VPWR VGND sky130_ef_sc_hd__decap_12
X_12589_ _05208_ _05211_ _05384_ VGND VGND VPWR VPWR _05387_ sky130_fd_sc_hd__and3_1
XTAP_TAPCELL_ROW_133_2230 VGND VPWR sky130_fd_sc_hd__tapvpwrvgnd_1
XFILLER_129_698 VGND VGND VPWR VPWR sky130_fd_sc_hd__decap_4
XFILLER_128_197 VGND VGND VPWR VPWR sky130_fd_sc_hd__decap_8
XFILLER_128_186 VGND VGND VPWR VPWR sky130_fd_sc_hd__decap_8
XFILLER_124_392 VPWR VGND VPWR VGND sky130_ef_sc_hd__decap_12
X_08820_ net530 net346 VGND VGND VPWR VPWR _01286_ sky130_fd_sc_hd__nand2_1
XFILLER_98_755 VGND VGND VPWR VPWR sky130_fd_sc_hd__fill_1
XFILLER_85_405 VGND VGND VPWR VPWR sky130_fd_sc_hd__decap_8
XFILLER_57_107 VGND VGND VPWR VPWR sky130_fd_sc_hd__decap_4
X_08751_ _01055_ _01090_ VGND VGND VPWR VPWR _01218_ sky130_fd_sc_hd__and2_1
XFILLER_78_490 VGND VGND VPWR VPWR sky130_fd_sc_hd__fill_1
X_08682_ net464 net455 net340 net337 VGND VGND VPWR VPWR _01149_ sky130_fd_sc_hd__and4_1
X_07702_ _06758_ _06773_ _06772_ VGND VGND VPWR VPWR _00181_ sky130_fd_sc_hd__o21ai_2
XFILLER_81_600 VPWR VGND VPWR VGND sky130_ef_sc_hd__decap_12
X_07633_ _06691_ _06697_ _06696_ VGND VGND VPWR VPWR _00113_ sky130_fd_sc_hd__a21o_1
XTAP_TAPCELL_ROW_49_1014 VGND VPWR sky130_fd_sc_hd__tapvpwrvgnd_1
XTAP_TAPCELL_ROW_49_1003 VGND VPWR sky130_fd_sc_hd__tapvpwrvgnd_1
XFILLER_80_121 VGND VGND VPWR VPWR sky130_fd_sc_hd__fill_1
XFILLER_26_549 VGND VGND VPWR VPWR sky130_fd_sc_hd__decap_6
XFILLER_110_15 VPWR VGND VPWR VGND sky130_ef_sc_hd__decap_12
XFILLER_81_677 VGND VGND VPWR VPWR sky130_fd_sc_hd__fill_1
XTAP_TAPCELL_ROW_62_1203 VGND VPWR sky130_fd_sc_hd__tapvpwrvgnd_1
X_07564_ _06791_ _06792_ VGND VGND VPWR VPWR _06793_ sky130_fd_sc_hd__xnor2_1
XFILLER_41_508 VGND VGND VPWR VPWR sky130_fd_sc_hd__decap_3
XFILLER_0_91 VGND VGND VPWR VPWR sky130_fd_sc_hd__decap_3
X_09303_ _01618_ _01807_ VGND VGND VPWR VPWR _01808_ sky130_fd_sc_hd__xnor2_1
X_07495_ _06562_ _06564_ _06723_ VGND VGND VPWR VPWR _06725_ sky130_fd_sc_hd__and3_1
X_09234_ _01730_ _01731_ VGND VGND VPWR VPWR _01732_ sky130_fd_sc_hd__xnor2_1
XFILLER_70_19 VGND VGND VPWR VPWR sky130_fd_sc_hd__decap_8
XPHY_EDGE_ROW_3_Right_3 VGND VGND VPWR VPWR sky130_fd_sc_hd__decap_3
XFILLER_119_120 VGND VGND VPWR VPWR sky130_fd_sc_hd__decap_4
X_09165_ _01642_ _01655_ VGND VGND VPWR VPWR _01657_ sky130_fd_sc_hd__xor2_1
XTAP_TAPCELL_ROW_32_761 VGND VPWR sky130_fd_sc_hd__tapvpwrvgnd_1
XFILLER_135_613 VGND VGND VPWR VPWR sky130_fd_sc_hd__decap_3
XFILLER_135_602 VGND VGND VPWR VPWR sky130_fd_sc_hd__decap_4
XFILLER_108_805 VGND VGND VPWR VPWR sky130_fd_sc_hd__decap_6
X_08116_ _00561_ _00591_ VGND VGND VPWR VPWR _00592_ sky130_fd_sc_hd__nor2_1
XFILLER_119_57 VPWR VGND VPWR VGND sky130_ef_sc_hd__decap_12
X_09096_ net531 net343 VGND VGND VPWR VPWR _01582_ sky130_fd_sc_hd__nand2_1
XFILLER_135_668 VGND VGND VPWR VPWR sky130_fd_sc_hd__decap_4
XFILLER_102_7 VPWR VGND VPWR VGND sky130_ef_sc_hd__decap_12
X_08047_ _00394_ _00397_ VGND VGND VPWR VPWR _00524_ sky130_fd_sc_hd__nor2_1
XFILLER_122_307 VGND VGND VPWR VPWR sky130_fd_sc_hd__fill_1
XTAP_TAPCELL_ROW_73_1354 VGND VPWR sky130_fd_sc_hd__tapvpwrvgnd_1
XFILLER_0_125 VPWR VGND VPWR VGND sky130_ef_sc_hd__decap_12
X_09998_ _02460_ _02564_ VGND VGND VPWR VPWR _02566_ sky130_fd_sc_hd__xnor2_1
XFILLER_95_27 VPWR VGND VPWR VGND sky130_ef_sc_hd__decap_12
XFILLER_0_169 VGND VGND VPWR VPWR sky130_fd_sc_hd__fill_2
X_08949_ _01411_ _01421_ VGND VGND VPWR VPWR _01422_ sky130_fd_sc_hd__xor2_1
X_11960_ _04669_ _04699_ VGND VGND VPWR VPWR _04700_ sky130_fd_sc_hd__or2_1
X_10911_ _03555_ _03556_ VGND VGND VPWR VPWR _03558_ sky130_fd_sc_hd__xor2_1
XFILLER_17_505 VGND VGND VPWR VPWR sky130_fd_sc_hd__decap_4
XFILLER_56_195 VGND VGND VPWR VPWR sky130_fd_sc_hd__fill_1
X_11891_ _04562_ _04568_ _04567_ VGND VGND VPWR VPWR _04627_ sky130_fd_sc_hd__o21ba_1
X_13630_ _06518_ _06521_ VGND VGND VPWR VPWR _06522_ sky130_fd_sc_hd__xnor2_1
XFILLER_44_53 VPWR VGND VPWR VGND sky130_ef_sc_hd__decap_12
X_10842_ net622 net69 _03480_ _03481_ VGND VGND VPWR VPWR _03483_ sky130_fd_sc_hd__nand4_1
X_13561_ _06076_ _06332_ _05946_ VGND VGND VPWR VPWR _06447_ sky130_fd_sc_hd__o21a_1
X_10773_ _03404_ _03405_ VGND VGND VPWR VPWR _03407_ sky130_fd_sc_hd__nor2_1
XFILLER_12_210 VGND VGND VPWR VPWR sky130_fd_sc_hd__decap_3
XFILLER_40_530 VGND VGND VPWR VPWR sky130_fd_sc_hd__fill_2
X_12512_ _05300_ _05301_ VGND VGND VPWR VPWR _05302_ sky130_fd_sc_hd__or2_1
XFILLER_9_726 VGND VGND VPWR VPWR sky130_fd_sc_hd__fill_2
XFILLER_12_232 VPWR VGND VPWR VGND sky130_ef_sc_hd__decap_12
X_13492_ net247 _06371_ VGND VGND VPWR VPWR _06372_ sky130_fd_sc_hd__nand2_1
XFILLER_8_236 VGND VGND VPWR VPWR sky130_fd_sc_hd__decap_6
XFILLER_12_265 VPWR VGND VPWR VGND sky130_ef_sc_hd__decap_12
XFILLER_138_462 VGND VGND VPWR VPWR sky130_fd_sc_hd__decap_3
X_12443_ net541 net680 VGND VGND VPWR VPWR _05226_ sky130_fd_sc_hd__nand2_1
XFILLER_60_41 VPWR VGND VPWR VGND sky130_ef_sc_hd__decap_12
XFILLER_138_484 VGND VGND VPWR VPWR sky130_fd_sc_hd__fill_2
X_12374_ net453 net383 VGND VGND VPWR VPWR _05151_ sky130_fd_sc_hd__nand2_1
XTAP_TAPCELL_ROW_10_444 VGND VPWR sky130_fd_sc_hd__tapvpwrvgnd_1
XFILLER_125_123 VPWR VGND VPWR VGND sky130_ef_sc_hd__decap_12
XFILLER_114_819 VGND VGND VPWR VPWR sky130_fd_sc_hd__fill_1
X_11325_ _03717_ _03862_ _03860_ VGND VGND VPWR VPWR _04011_ sky130_fd_sc_hd__a21oi_1
XFILLER_5_69 VPWR VGND VPWR VGND sky130_ef_sc_hd__decap_12
X_11256_ net415 net278 _03804_ _03803_ VGND VGND VPWR VPWR _03935_ sky130_fd_sc_hd__a31o_1
X_10207_ _02745_ _02791_ VGND VGND VPWR VPWR _02792_ sky130_fd_sc_hd__xnor2_1
X_11187_ _03858_ _03859_ VGND VGND VPWR VPWR _03860_ sky130_fd_sc_hd__nor2_1
X_10138_ _02606_ _02622_ _02623_ _02626_ VGND VGND VPWR VPWR _02718_ sky130_fd_sc_hd__a31o_1
XFILLER_67_449 VGND VGND VPWR VPWR sky130_fd_sc_hd__fill_1
XFILLER_0_670 VGND VGND VPWR VPWR sky130_fd_sc_hd__fill_2
X_10069_ _02639_ _02640_ VGND VGND VPWR VPWR _02643_ sky130_fd_sc_hd__xnor2_1
XFILLER_82_419 VGND VGND VPWR VPWR sky130_fd_sc_hd__fill_1
XFILLER_90_474 VGND VGND VPWR VPWR sky130_fd_sc_hd__fill_2
XTAP_TAPCELL_ROW_18_555 VGND VPWR sky130_fd_sc_hd__tapvpwrvgnd_1
XTAP_TAPCELL_ROW_18_566 VGND VPWR sky130_fd_sc_hd__tapvpwrvgnd_1
XFILLER_35_357 VGND VGND VPWR VPWR sky130_fd_sc_hd__fill_1
XFILLER_93_3 VPWR VGND VPWR VGND sky130_ef_sc_hd__decap_12
X_07280_ net459 net451 net668 net666 VGND VGND VPWR VPWR _06389_ sky130_fd_sc_hd__and4_1
XFILLER_31_552 VGND VGND VPWR VPWR sky130_fd_sc_hd__fill_1
XFILLER_31_585 VGND VGND VPWR VPWR sky130_fd_sc_hd__decap_6
XFILLER_129_473 VGND VGND VPWR VPWR sky130_fd_sc_hd__decap_8
XFILLER_8_781 VPWR VGND VPWR VGND sky130_ef_sc_hd__decap_12
XFILLER_117_668 VGND VGND VPWR VPWR sky130_fd_sc_hd__decap_4
XFILLER_116_134 VGND VGND VPWR VPWR sky130_fd_sc_hd__decap_6
X_09921_ _02474_ _02479_ VGND VGND VPWR VPWR _02481_ sky130_fd_sc_hd__xor2_1
XTAP_TAPCELL_ROW_113_1933 VGND VPWR sky130_fd_sc_hd__tapvpwrvgnd_1
XTAP_TAPCELL_ROW_113_1944 VGND VPWR sky130_fd_sc_hd__tapvpwrvgnd_1
XFILLER_98_541 VGND VGND VPWR VPWR sky130_fd_sc_hd__fill_2
Xfanout705 net104 VGND VGND VPWR VPWR net705 sky130_fd_sc_hd__buf_2
X_09852_ _02395_ _02406_ VGND VGND VPWR VPWR _02407_ sky130_fd_sc_hd__xnor2_1
XFILLER_105_15 VPWR VGND VPWR VGND sky130_ef_sc_hd__decap_12
XFILLER_98_552 VPWR VGND VPWR VGND sky130_ef_sc_hd__decap_12
XFILLER_86_714 VGND VGND VPWR VPWR sky130_fd_sc_hd__decap_3
Xfanout716 net718 VGND VGND VPWR VPWR net716 sky130_fd_sc_hd__clkbuf_4
X_09783_ net549 net354 VGND VGND VPWR VPWR _02331_ sky130_fd_sc_hd__nand2_1
X_08803_ _01267_ _01268_ VGND VGND VPWR VPWR _01269_ sky130_fd_sc_hd__or2_1
XTAP_TAPCELL_ROW_55_1095 VGND VPWR sky130_fd_sc_hd__tapvpwrvgnd_1
X_08734_ _01162_ _01198_ _01200_ VGND VGND VPWR VPWR _01201_ sky130_fd_sc_hd__nor3_1
XFILLER_65_19 VPWR VGND VPWR VGND sky130_ef_sc_hd__decap_12
X_06995_ net122 net444 _03194_ _03205_ VGND VGND VPWR VPWR _03281_ sky130_fd_sc_hd__o2bb2a_1
XFILLER_39_641 VGND VGND VPWR VPWR sky130_fd_sc_hd__decap_8
XFILLER_66_482 VGND VGND VPWR VPWR sky130_fd_sc_hd__decap_4
XFILLER_26_313 VGND VGND VPWR VPWR sky130_fd_sc_hd__fill_1
X_08665_ _01130_ _01131_ VGND VGND VPWR VPWR _01132_ sky130_fd_sc_hd__or2_1
XFILLER_53_110 VGND VGND VPWR VPWR sky130_fd_sc_hd__fill_2
XFILLER_26_324 VPWR VGND VPWR VGND sky130_ef_sc_hd__decap_12
XTAP_TAPCELL_ROW_37_831 VGND VPWR sky130_fd_sc_hd__tapvpwrvgnd_1
XTAP_TAPCELL_ROW_37_842 VGND VPWR sky130_fd_sc_hd__tapvpwrvgnd_1
X_08596_ net574 net366 _01062_ _01063_ VGND VGND VPWR VPWR _01064_ sky130_fd_sc_hd__and4_1
XFILLER_121_69 VGND VGND VPWR VPWR sky130_fd_sc_hd__decap_8
X_07616_ _00090_ _00094_ VGND VGND VPWR VPWR _00096_ sky130_fd_sc_hd__xnor2_1
XFILLER_53_176 VPWR VGND VPWR VGND sky130_ef_sc_hd__decap_12
X_07547_ _06775_ _06774_ VGND VGND VPWR VPWR _06776_ sky130_fd_sc_hd__nand2b_1
X_07478_ _06677_ _06706_ VGND VGND VPWR VPWR _06708_ sky130_fd_sc_hd__xnor2_1
XFILLER_10_725 VGND VGND VPWR VPWR sky130_fd_sc_hd__decap_6
XFILLER_10_736 VPWR VGND VPWR VGND sky130_ef_sc_hd__decap_12
X_09217_ _01711_ _01712_ VGND VGND VPWR VPWR _01713_ sky130_fd_sc_hd__nand2_1
XFILLER_10_769 VPWR VGND VPWR VGND sky130_ef_sc_hd__decap_12
X_09148_ _01633_ _01636_ _01637_ VGND VGND VPWR VPWR _01639_ sky130_fd_sc_hd__and3_1
XFILLER_135_432 VPWR VGND VPWR VGND sky130_ef_sc_hd__decap_12
X_09079_ _01559_ _01560_ VGND VGND VPWR VPWR _01564_ sky130_fd_sc_hd__xor2_1
XFILLER_123_627 VPWR VGND VPWR VGND sky130_ef_sc_hd__decap_12
XFILLER_107_167 VGND VGND VPWR VPWR sky130_fd_sc_hd__fill_1
X_11110_ _03771_ _03774_ net492 net290 VGND VGND VPWR VPWR _03776_ sky130_fd_sc_hd__nand4b_1
X_12090_ _04826_ _04840_ VGND VGND VPWR VPWR _04841_ sky130_fd_sc_hd__nand2b_1
X_11041_ _03699_ _03700_ VGND VGND VPWR VPWR _03701_ sky130_fd_sc_hd__nand2_1
XFILLER_77_758 VPWR VGND VPWR VGND sky130_ef_sc_hd__decap_12
XFILLER_77_736 VGND VGND VPWR VPWR sky130_fd_sc_hd__decap_4
XFILLER_49_449 VPWR VGND VPWR VGND sky130_ef_sc_hd__decap_12
XFILLER_91_205 VGND VGND VPWR VPWR sky130_fd_sc_hd__decap_4
X_12992_ net445 _05497_ VGND VGND VPWR VPWR _05826_ sky130_fd_sc_hd__nand2_4
XTAP_TAPCELL_ROW_86_1545 VGND VPWR sky130_fd_sc_hd__tapvpwrvgnd_1
X_11943_ net462 net393 _04679_ VGND VGND VPWR VPWR _04681_ sky130_fd_sc_hd__a21oi_1
XFILLER_17_335 VGND VGND VPWR VPWR sky130_fd_sc_hd__fill_1
XFILLER_29_184 VGND VGND VPWR VPWR sky130_fd_sc_hd__decap_3
XFILLER_45_688 VPWR VGND VPWR VGND sky130_ef_sc_hd__decap_12
X_11874_ _04607_ _04608_ VGND VGND VPWR VPWR _04609_ sky130_fd_sc_hd__nor2_1
XFILLER_17_357 VGND VGND VPWR VPWR sky130_fd_sc_hd__fill_1
X_13613_ _06433_ _06436_ VGND VGND VPWR VPWR _06503_ sky130_fd_sc_hd__nand2_1
XFILLER_72_496 VGND VGND VPWR VPWR sky130_fd_sc_hd__fill_1
XTAP_TAPCELL_ROW_15_514 VGND VPWR sky130_fd_sc_hd__tapvpwrvgnd_1
X_10825_ net611 net604 net325 net323 VGND VGND VPWR VPWR _03464_ sky130_fd_sc_hd__and4_1
X_13544_ _06340_ _06344_ _06427_ VGND VGND VPWR VPWR _06428_ sky130_fd_sc_hd__and3_1
X_10756_ _03217_ _03220_ _03386_ VGND VGND VPWR VPWR _03388_ sky130_fd_sc_hd__nand3_1
XTAP_TAPCELL_ROW_117_2000 VGND VPWR sky130_fd_sc_hd__tapvpwrvgnd_1
X_13475_ _06352_ _06330_ VGND VGND VPWR VPWR _06353_ sky130_fd_sc_hd__and2b_1
XFILLER_71_95 VGND VGND VPWR VPWR sky130_fd_sc_hd__fill_2
X_10687_ net622 net324 net69 net631 VGND VGND VPWR VPWR _03313_ sky130_fd_sc_hd__a22o_1
X_12426_ _05058_ _05054_ _05206_ _05207_ VGND VGND VPWR VPWR _05208_ sky130_fd_sc_hd__a211o_4
XFILLER_65_7 VPWR VGND VPWR VGND sky130_ef_sc_hd__decap_12
XFILLER_138_281 VGND VGND VPWR VPWR sky130_fd_sc_hd__fill_2
XFILLER_99_327 VGND VGND VPWR VPWR sky130_fd_sc_hd__decap_8
X_12357_ _05130_ _05131_ VGND VGND VPWR VPWR _05132_ sky130_fd_sc_hd__nor2_1
XFILLER_4_250 VGND VGND VPWR VPWR sky130_fd_sc_hd__fill_2
X_12288_ _04968_ _05053_ _04970_ _05055_ VGND VGND VPWR VPWR _05058_ sky130_fd_sc_hd__or4_4
X_11308_ _03980_ _03991_ VGND VGND VPWR VPWR _03993_ sky130_fd_sc_hd__xor2_1
X_11239_ _03878_ _03916_ VGND VGND VPWR VPWR _03917_ sky130_fd_sc_hd__nand2b_1
XFILLER_110_811 VGND VGND VPWR VPWR sky130_fd_sc_hd__fill_1
XFILLER_68_725 VPWR VGND VPWR VGND sky130_ef_sc_hd__decap_12
XTAP_TAPCELL_ROW_128_2162 VGND VPWR sky130_fd_sc_hd__tapvpwrvgnd_1
XTAP_TAPCELL_ROW_128_2151 VGND VPWR sky130_fd_sc_hd__tapvpwrvgnd_1
XFILLER_95_555 VGND VGND VPWR VPWR sky130_fd_sc_hd__decap_4
XFILLER_68_769 VPWR VGND VPWR VGND sky130_ef_sc_hd__decap_12
XFILLER_82_238 VGND VGND VPWR VPWR sky130_fd_sc_hd__fill_1
XFILLER_76_791 VGND VGND VPWR VPWR sky130_fd_sc_hd__decap_3
XFILLER_35_121 VGND VGND VPWR VPWR sky130_fd_sc_hd__fill_2
X_08450_ _00920_ _00921_ VGND VGND VPWR VPWR _00923_ sky130_fd_sc_hd__xor2_1
XFILLER_35_165 VGND VGND VPWR VPWR sky130_fd_sc_hd__decap_3
X_07401_ net672 net416 _06630_ VGND VGND VPWR VPWR _06631_ sky130_fd_sc_hd__and3_1
XFILLER_51_636 VGND VGND VPWR VPWR sky130_fd_sc_hd__decap_8
XFILLER_23_316 VGND VGND VPWR VPWR sky130_fd_sc_hd__fill_1
XFILLER_36_699 VGND VGND VPWR VPWR sky130_fd_sc_hd__fill_1
X_08381_ _00568_ _00695_ _00854_ VGND VGND VPWR VPWR _00855_ sky130_fd_sc_hd__a21o_1
X_07332_ _06560_ _06561_ _05374_ _05406_ VGND VGND VPWR VPWR _06563_ sky130_fd_sc_hd__o211ai_2
X_07263_ _02466_ _03019_ _04697_ VGND VGND VPWR VPWR _06203_ sky130_fd_sc_hd__nor3_1
XFILLER_31_393 VGND VGND VPWR VPWR sky130_fd_sc_hd__decap_8
X_09002_ _01320_ _01322_ _01321_ VGND VGND VPWR VPWR _01480_ sky130_fd_sc_hd__o21bai_1
X_07194_ _04253_ _05428_ _05439_ VGND VGND VPWR VPWR _05450_ sky130_fd_sc_hd__nor3_1
XFILLER_129_281 VPWR VGND VPWR VGND sky130_ef_sc_hd__decap_12
XFILLER_104_104 VGND VGND VPWR VPWR sky130_fd_sc_hd__decap_6
XTAP_TAPCELL_ROW_57_1124 VGND VPWR sky130_fd_sc_hd__tapvpwrvgnd_1
XFILLER_104_137 VGND VGND VPWR VPWR sky130_fd_sc_hd__decap_3
Xfanout524 net525 VGND VGND VPWR VPWR net524 sky130_fd_sc_hd__buf_2
X_09904_ _02360_ _02387_ _02386_ VGND VGND VPWR VPWR _02462_ sky130_fd_sc_hd__a21oi_1
XTAP_TAPCELL_ROW_70_1313 VGND VPWR sky130_fd_sc_hd__tapvpwrvgnd_1
Xfanout513 net518 VGND VGND VPWR VPWR net513 sky130_fd_sc_hd__clkbuf_4
Xfanout502 net505 VGND VGND VPWR VPWR net502 sky130_fd_sc_hd__clkbuf_4
Xfanout557 net558 VGND VGND VPWR VPWR net557 sky130_fd_sc_hd__clkbuf_2
X_09835_ _02360_ _02387_ VGND VGND VPWR VPWR _02388_ sky130_fd_sc_hd__xor2_1
XFILLER_86_533 VGND VGND VPWR VPWR sky130_fd_sc_hd__fill_2
XFILLER_76_29 VPWR VGND VPWR VGND sky130_ef_sc_hd__decap_12
Xfanout546 net547 VGND VGND VPWR VPWR net546 sky130_fd_sc_hd__clkbuf_4
Xfanout535 net543 VGND VGND VPWR VPWR net535 sky130_fd_sc_hd__buf_2
Xfanout579 net581 VGND VGND VPWR VPWR net579 sky130_fd_sc_hd__buf_2
Xfanout568 net570 VGND VGND VPWR VPWR net568 sky130_fd_sc_hd__clkbuf_4
X_09766_ _02031_ _02167_ _02166_ VGND VGND VPWR VPWR _02313_ sky130_fd_sc_hd__a21oi_2
XFILLER_100_365 VGND VGND VPWR VPWR sky130_fd_sc_hd__decap_6
XFILLER_74_739 VGND VGND VPWR VPWR sky130_fd_sc_hd__decap_4
X_06978_ _03074_ _03084_ VGND VGND VPWR VPWR _03095_ sky130_fd_sc_hd__nor2_1
XFILLER_46_419 VGND VGND VPWR VPWR sky130_fd_sc_hd__fill_1
X_09697_ _02235_ _02236_ VGND VGND VPWR VPWR _02237_ sky130_fd_sc_hd__and2b_1
X_08717_ _01174_ _01181_ _01180_ VGND VGND VPWR VPWR _01184_ sky130_fd_sc_hd__a21oi_1
XFILLER_26_110 VGND VGND VPWR VPWR sky130_fd_sc_hd__fill_1
XFILLER_26_121 VPWR VGND VPWR VGND sky130_ef_sc_hd__decap_12
X_08648_ _01067_ _01114_ VGND VGND VPWR VPWR _01115_ sky130_fd_sc_hd__nor2_1
XFILLER_54_463 VGND VGND VPWR VPWR sky130_fd_sc_hd__fill_1
XFILLER_15_817 VGND VGND VPWR VPWR sky130_fd_sc_hd__decap_3
XTAP_TAPCELL_ROW_68_1286 VGND VPWR sky130_fd_sc_hd__tapvpwrvgnd_1
XFILLER_42_614 VPWR VGND VPWR VGND sky130_ef_sc_hd__decap_12
X_08579_ _00999_ _01011_ _01013_ VGND VGND VPWR VPWR _01047_ sky130_fd_sc_hd__a21oi_1
XFILLER_41_124 VGND VGND VPWR VPWR sky130_fd_sc_hd__fill_1
XFILLER_25_55 VGND VGND VPWR VPWR sky130_fd_sc_hd__fill_1
XTAP_TAPCELL_ROW_81_1475 VGND VPWR sky130_fd_sc_hd__tapvpwrvgnd_1
XFILLER_41_179 VGND VGND VPWR VPWR sky130_fd_sc_hd__decap_3
X_10610_ net579 net305 net302 net588 VGND VGND VPWR VPWR _03229_ sky130_fd_sc_hd__a22o_1
X_11590_ _04020_ _04299_ VGND VGND VPWR VPWR _04300_ sky130_fd_sc_hd__nand2_1
XFILLER_10_533 VPWR VGND VPWR VGND sky130_ef_sc_hd__decap_12
XFILLER_22_382 VGND VGND VPWR VPWR sky130_fd_sc_hd__decap_4
X_10541_ _03152_ _03153_ VGND VGND VPWR VPWR _03154_ sky130_fd_sc_hd__or2_1
X_13260_ _06112_ _06118_ VGND VGND VPWR VPWR _06119_ sky130_fd_sc_hd__and2b_1
XFILLER_6_504 VPWR VGND VPWR VGND sky130_ef_sc_hd__decap_12
XFILLER_136_752 VGND VGND VPWR VPWR sky130_fd_sc_hd__decap_4
XFILLER_108_421 VGND VGND VPWR VPWR sky130_fd_sc_hd__decap_3
X_12211_ net497 net19 VGND VGND VPWR VPWR _04973_ sky130_fd_sc_hd__nand2_1
X_10472_ net562 net554 net312 net76 VGND VGND VPWR VPWR _03078_ sky130_fd_sc_hd__and4_1
XTAP_TAPCELL_ROW_20_583 VGND VPWR sky130_fd_sc_hd__tapvpwrvgnd_1
X_13191_ net548 _05740_ VGND VGND VPWR VPWR _06043_ sky130_fd_sc_hd__nand2_1
XTAP_TAPCELL_ROW_20_594 VGND VPWR sky130_fd_sc_hd__tapvpwrvgnd_1
XFILLER_123_435 VGND VGND VPWR VPWR sky130_fd_sc_hd__decap_6
X_12142_ _04885_ _04894_ _04712_ VGND VGND VPWR VPWR _04898_ sky130_fd_sc_hd__a21o_1
XFILLER_2_732 VPWR VGND VPWR VGND sky130_ef_sc_hd__decap_12
X_12073_ net403 _04685_ _04762_ _04766_ VGND VGND VPWR VPWR _04822_ sky130_fd_sc_hd__o31ai_1
XFILLER_104_693 VGND VGND VPWR VPWR sky130_fd_sc_hd__decap_6
XFILLER_2_15 VPWR VGND VPWR VGND sky130_ef_sc_hd__decap_12
X_11024_ _03679_ _03680_ _03662_ VGND VGND VPWR VPWR _03682_ sky130_fd_sc_hd__a21o_1
XFILLER_89_393 VPWR VGND VPWR VGND sky130_ef_sc_hd__decap_12
XFILLER_77_599 VGND VGND VPWR VPWR sky130_fd_sc_hd__fill_1
XFILLER_64_205 VGND VGND VPWR VPWR sky130_fd_sc_hd__decap_3
X_12975_ _05805_ _05806_ VGND VGND VPWR VPWR _05807_ sky130_fd_sc_hd__or2_1
XFILLER_64_227 VPWR VGND VPWR VGND sky130_ef_sc_hd__decap_12
X_11926_ net470 net658 net404 net393 VGND VGND VPWR VPWR _04663_ sky130_fd_sc_hd__and4_1
XFILLER_73_750 VGND VGND VPWR VPWR sky130_fd_sc_hd__fill_1
XFILLER_17_132 VPWR VGND VPWR VGND sky130_ef_sc_hd__decap_12
XTAP_TAPCELL_ROW_123_2081 VGND VPWR sky130_fd_sc_hd__tapvpwrvgnd_1
XFILLER_73_783 VGND VGND VPWR VPWR sky130_fd_sc_hd__fill_1
XFILLER_45_474 VGND VGND VPWR VPWR sky130_fd_sc_hd__decap_6
XFILLER_18_688 VPWR VGND VPWR VGND sky130_ef_sc_hd__decap_12
XFILLER_82_83 VGND VGND VPWR VPWR sky130_fd_sc_hd__fill_1
X_11857_ _04513_ _04517_ _04589_ VGND VGND VPWR VPWR _04590_ sky130_fd_sc_hd__o21a_1
XFILLER_33_647 VGND VGND VPWR VPWR sky130_fd_sc_hd__fill_1
XFILLER_60_477 VGND VGND VPWR VPWR sky130_fd_sc_hd__decap_4
X_11788_ _04513_ _04514_ VGND VGND VPWR VPWR _04516_ sky130_fd_sc_hd__or2_1
X_10808_ _03268_ _03444_ VGND VGND VPWR VPWR _03446_ sky130_fd_sc_hd__nor2_1
XTAP_TAPCELL_ROW_99_1736 VGND VPWR sky130_fd_sc_hd__tapvpwrvgnd_1
X_13527_ _06218_ _06309_ VGND VGND VPWR VPWR _06409_ sky130_fd_sc_hd__or2_1
XFILLER_41_691 VGND VGND VPWR VPWR sky130_fd_sc_hd__fill_1
X_10739_ net263 net313 VGND VGND VPWR VPWR _03370_ sky130_fd_sc_hd__nor2_1
XFILLER_13_393 VGND VGND VPWR VPWR sky130_fd_sc_hd__decap_4
XFILLER_9_386 VGND VGND VPWR VPWR sky130_fd_sc_hd__decap_6
XFILLER_9_364 VGND VGND VPWR VPWR sky130_fd_sc_hd__fill_1
X_13458_ _06129_ _06237_ VGND VGND VPWR VPWR _06335_ sky130_fd_sc_hd__nor2_1
XFILLER_127_785 VPWR VGND VPWR VGND sky130_ef_sc_hd__decap_12
XFILLER_126_240 VGND VGND VPWR VPWR sky130_fd_sc_hd__decap_8
X_13389_ net522 net395 _06089_ _06088_ VGND VGND VPWR VPWR _06260_ sky130_fd_sc_hd__a31o_1
X_12409_ _05023_ _05032_ _05031_ VGND VGND VPWR VPWR _05190_ sky130_fd_sc_hd__a21bo_1
XFILLER_56_3 VPWR VGND VPWR VGND sky130_ef_sc_hd__decap_12
XFILLER_99_113 VPWR VGND VPWR VGND sky130_ef_sc_hd__decap_12
X_07950_ _00143_ _00290_ _00427_ VGND VGND VPWR VPWR _00428_ sky130_fd_sc_hd__o21a_1
X_06901_ net589 net701 net580 net699 VGND VGND VPWR VPWR _02260_ sky130_fd_sc_hd__and4_1
XFILLER_110_652 VGND VGND VPWR VPWR sky130_fd_sc_hd__decap_8
XFILLER_68_555 VPWR VGND VPWR VGND sky130_ef_sc_hd__decap_12
XFILLER_68_533 VGND VGND VPWR VPWR sky130_fd_sc_hd__fill_2
X_07881_ _00357_ _00358_ VGND VGND VPWR VPWR _00359_ sky130_fd_sc_hd__or2_1
XTAP_TAPCELL_ROW_52_1054 VGND VPWR sky130_fd_sc_hd__tapvpwrvgnd_1
X_09620_ _02150_ _02152_ VGND VGND VPWR VPWR _02154_ sky130_fd_sc_hd__xor2_2
XFILLER_83_503 VGND VGND VPWR VPWR sky130_fd_sc_hd__fill_1
XFILLER_55_216 VGND VGND VPWR VPWR sky130_fd_sc_hd__decap_8
X_06832_ net526 net114 VGND VGND VPWR VPWR _01508_ sky130_fd_sc_hd__nand2_2
X_09551_ net478 net347 net346 net488 VGND VGND VPWR VPWR _02078_ sky130_fd_sc_hd__a22o_1
XTAP_TAPCELL_ROW_108_1865 VGND VPWR sky130_fd_sc_hd__tapvpwrvgnd_1
XFILLER_102_27 VGND VGND VPWR VPWR sky130_fd_sc_hd__fill_1
XFILLER_71_709 VPWR VGND VPWR VGND sky130_ef_sc_hd__decap_12
X_08502_ _00813_ _00902_ _00901_ VGND VGND VPWR VPWR _00974_ sky130_fd_sc_hd__o21a_1
X_09482_ _01971_ _02002_ VGND VGND VPWR VPWR _02003_ sky130_fd_sc_hd__xnor2_1
XFILLER_64_783 VGND VGND VPWR VPWR sky130_fd_sc_hd__fill_1
XTAP_TAPCELL_ROW_47_981 VGND VPWR sky130_fd_sc_hd__tapvpwrvgnd_1
XFILLER_23_113 VGND VGND VPWR VPWR sky130_fd_sc_hd__fill_1
X_08433_ _00812_ _00817_ _00811_ VGND VGND VPWR VPWR _00906_ sky130_fd_sc_hd__a21oi_1
X_08364_ _00836_ _00837_ VGND VGND VPWR VPWR _00838_ sky130_fd_sc_hd__nor2_1
X_07315_ _06543_ _06544_ _06545_ VGND VGND VPWR VPWR _06546_ sky130_fd_sc_hd__nand3_1
XFILLER_32_691 VGND VGND VPWR VPWR sky130_fd_sc_hd__decap_8
XFILLER_109_218 VGND VGND VPWR VPWR sky130_fd_sc_hd__decap_6
X_08295_ _00606_ _00612_ _00611_ VGND VGND VPWR VPWR _00770_ sky130_fd_sc_hd__a21oi_1
X_07246_ _04569_ _05985_ _06007_ VGND VGND VPWR VPWR _06018_ sky130_fd_sc_hd__o21a_1
X_07177_ _03609_ _03631_ _05231_ _05253_ VGND VGND VPWR VPWR _05264_ sky130_fd_sc_hd__a211oi_2
XFILLER_11_57 VPWR VGND VPWR VGND sky130_ef_sc_hd__decap_12
XFILLER_127_57 VPWR VGND VPWR VGND sky130_ef_sc_hd__decap_12
XFILLER_3_529 VPWR VGND VPWR VGND sky130_ef_sc_hd__decap_12
Xfanout332 net63 VGND VGND VPWR VPWR net332 sky130_fd_sc_hd__buf_2
Xfanout321 net7 VGND VGND VPWR VPWR net321 sky130_fd_sc_hd__clkbuf_2
Xfanout310 net76 VGND VGND VPWR VPWR net310 sky130_fd_sc_hd__buf_2
Xfanout354 net49 VGND VGND VPWR VPWR net354 sky130_fd_sc_hd__clkbuf_4
Xfanout365 net43 VGND VGND VPWR VPWR net365 sky130_fd_sc_hd__buf_1
Xfanout343 net57 VGND VGND VPWR VPWR net343 sky130_fd_sc_hd__buf_2
X_09818_ _02363_ _02368_ VGND VGND VPWR VPWR _02370_ sky130_fd_sc_hd__xor2_1
Xfanout376 net35 VGND VGND VPWR VPWR net376 sky130_fd_sc_hd__buf_1
Xfanout398 net22 VGND VGND VPWR VPWR net398 sky130_fd_sc_hd__clkbuf_4
XFILLER_86_352 VPWR VGND VPWR VGND sky130_ef_sc_hd__decap_12
Xfanout387 net3 VGND VGND VPWR VPWR net387 sky130_fd_sc_hd__buf_1
XTAP_TAPCELL_ROW_6_389 VGND VPWR sky130_fd_sc_hd__tapvpwrvgnd_1
X_09749_ _02138_ _02149_ _02148_ VGND VGND VPWR VPWR _02295_ sky130_fd_sc_hd__a21oi_1
XFILLER_100_184 VPWR VGND VPWR VGND sky130_ef_sc_hd__decap_12
XFILLER_86_396 VGND VGND VPWR VPWR sky130_fd_sc_hd__decap_4
XFILLER_46_227 VPWR VGND VPWR VGND sky130_ef_sc_hd__decap_12
XTAP_TAPCELL_ROW_83_1504 VGND VPWR sky130_fd_sc_hd__tapvpwrvgnd_1
XFILLER_27_452 VPWR VGND VPWR VGND sky130_ef_sc_hd__decap_12
X_12760_ _05404_ _05423_ _05422_ VGND VGND VPWR VPWR _05572_ sky130_fd_sc_hd__o21a_1
XFILLER_14_102 VGND VGND VPWR VPWR sky130_fd_sc_hd__decap_6
XFILLER_14_113 VPWR VGND VPWR VGND sky130_ef_sc_hd__decap_12
XFILLER_27_485 VGND VGND VPWR VPWR sky130_fd_sc_hd__fill_1
XFILLER_36_65 VPWR VGND VPWR VGND sky130_ef_sc_hd__decap_12
X_12691_ net461 net453 net382 net380 VGND VGND VPWR VPWR _05498_ sky130_fd_sc_hd__nand4_1
XFILLER_42_433 VPWR VGND VPWR VGND sky130_ef_sc_hd__decap_12
X_11711_ _04341_ _04343_ _04430_ VGND VGND VPWR VPWR _04431_ sky130_fd_sc_hd__o21ba_1
XFILLER_42_477 VPWR VGND VPWR VGND sky130_ef_sc_hd__decap_12
XTAP_TAPCELL_ROW_25_664 VGND VPWR sky130_fd_sc_hd__tapvpwrvgnd_1
X_11642_ _04350_ _04355_ VGND VGND VPWR VPWR _04356_ sky130_fd_sc_hd__and2_1
XFILLER_52_53 VPWR VGND VPWR VGND sky130_ef_sc_hd__decap_12
X_13312_ _05902_ _06049_ _06047_ VGND VGND VPWR VPWR _06175_ sky130_fd_sc_hd__o21a_1
Xinput18 w02[0] VGND VGND VPWR VPWR net18 sky130_fd_sc_hd__clkbuf_2
XFILLER_52_97 VGND VGND VPWR VPWR sky130_fd_sc_hd__fill_1
XFILLER_10_352 VPWR VGND VPWR VGND sky130_ef_sc_hd__decap_12
X_11573_ _04279_ _04280_ VGND VGND VPWR VPWR _04281_ sky130_fd_sc_hd__nor2_1
Xinput29 w03[3] VGND VGND VPWR VPWR net29 sky130_fd_sc_hd__clkbuf_2
XFILLER_6_334 VGND VGND VPWR VPWR sky130_fd_sc_hd__fill_2
X_10524_ net435 net426 net283 net282 VGND VGND VPWR VPWR _03135_ sky130_fd_sc_hd__and4_1
XFILLER_109_785 VPWR VGND VPWR VGND sky130_ef_sc_hd__decap_12
X_13243_ _06075_ _06098_ VGND VGND VPWR VPWR _06100_ sky130_fd_sc_hd__xnor2_1
X_10455_ _03055_ _03059_ _03050_ _03053_ VGND VGND VPWR VPWR _03060_ sky130_fd_sc_hd__a211oi_2
XFILLER_108_273 VGND VGND VPWR VPWR sky130_fd_sc_hd__fill_2
X_13174_ _06022_ _06023_ VGND VGND VPWR VPWR _06025_ sky130_fd_sc_hd__xor2_2
XTAP_TAPCELL_ROW_94_1666 VGND VPWR sky130_fd_sc_hd__tapvpwrvgnd_1
XTAP_TAPCELL_ROW_94_1655 VGND VPWR sky130_fd_sc_hd__tapvpwrvgnd_1
X_12125_ net470 net384 _04876_ _04877_ VGND VGND VPWR VPWR _04879_ sky130_fd_sc_hd__a22o_1
X_10386_ net623 net327 net326 net632 VGND VGND VPWR VPWR _02984_ sky130_fd_sc_hd__a22oi_1
XFILLER_96_149 VGND VGND VPWR VPWR sky130_fd_sc_hd__fill_1
X_12056_ net565 net10 _04802_ VGND VGND VPWR VPWR _04803_ sky130_fd_sc_hd__nand3_1
XTAP_TAPCELL_ROW_125_2110 VGND VPWR sky130_fd_sc_hd__tapvpwrvgnd_1
XFILLER_77_94 VPWR VGND VPWR VGND sky130_ef_sc_hd__decap_12
XFILLER_65_503 VGND VGND VPWR VPWR sky130_fd_sc_hd__fill_1
X_11007_ net628 net619 net319 net317 VGND VGND VPWR VPWR _03663_ sky130_fd_sc_hd__and4_1
XFILLER_37_205 VGND VGND VPWR VPWR sky130_fd_sc_hd__fill_2
XFILLER_92_333 VGND VGND VPWR VPWR sky130_fd_sc_hd__fill_1
XFILLER_46_750 VGND VGND VPWR VPWR sky130_fd_sc_hd__decap_6
X_12958_ _05629_ _05786_ _05787_ VGND VGND VPWR VPWR _05789_ sky130_fd_sc_hd__a21oi_1
XFILLER_18_474 VGND VGND VPWR VPWR sky130_fd_sc_hd__fill_2
XFILLER_18_496 VGND VGND VPWR VPWR sky130_fd_sc_hd__decap_6
X_12889_ _05659_ _05713_ VGND VGND VPWR VPWR _05714_ sky130_fd_sc_hd__xor2_1
XFILLER_61_753 VPWR VGND VPWR VGND sky130_ef_sc_hd__decap_12
XTAP_TAPCELL_ROW_44_940 VGND VPWR sky130_fd_sc_hd__tapvpwrvgnd_1
X_11909_ _04467_ _04564_ _04478_ _04563_ VGND VGND VPWR VPWR _04647_ sky130_fd_sc_hd__a2bb2o_1
XFILLER_61_797 VPWR VGND VPWR VGND sky130_ef_sc_hd__decap_12
XFILLER_20_105 VGND VGND VPWR VPWR sky130_fd_sc_hd__decap_8
XFILLER_21_617 VGND VGND VPWR VPWR sky130_fd_sc_hd__decap_6
XTAP_TAPCELL_ROW_103_1795 VGND VPWR sky130_fd_sc_hd__tapvpwrvgnd_1
XFILLER_60_285 VGND VGND VPWR VPWR sky130_fd_sc_hd__decap_8
XFILLER_119_505 VGND VGND VPWR VPWR sky130_fd_sc_hd__decap_3
XFILLER_9_161 VGND VGND VPWR VPWR sky130_fd_sc_hd__fill_2
XFILLER_13_190 VPWR VGND VPWR VGND sky130_ef_sc_hd__decap_12
XFILLER_20_149 VGND VGND VPWR VPWR sky130_fd_sc_hd__fill_1
X_07100_ _02695_ _02717_ VGND VGND VPWR VPWR _04428_ sky130_fd_sc_hd__or2_1
XTAP_TAPCELL_ROW_136_2272 VGND VPWR sky130_fd_sc_hd__tapvpwrvgnd_1
XFILLER_9_194 VPWR VGND VPWR VGND sky130_ef_sc_hd__decap_12
X_08080_ _00308_ _00449_ _00447_ VGND VGND VPWR VPWR _00556_ sky130_fd_sc_hd__a21oi_1
X_07031_ net469 net669 VGND VGND VPWR VPWR _03675_ sky130_fd_sc_hd__and2_1
XFILLER_115_722 VGND VGND VPWR VPWR sky130_fd_sc_hd__decap_6
X_08982_ _01312_ _01456_ _01457_ VGND VGND VPWR VPWR _01458_ sky130_fd_sc_hd__and3_1
XFILLER_130_769 VPWR VGND VPWR VGND sky130_ef_sc_hd__decap_12
X_07933_ _00364_ _00410_ VGND VGND VPWR VPWR _00411_ sky130_fd_sc_hd__xnor2_2
XFILLER_96_672 VPWR VGND VPWR VGND sky130_ef_sc_hd__decap_12
X_07864_ net514 net506 VGND VGND VPWR VPWR _00342_ sky130_fd_sc_hd__or2_4
XFILLER_29_717 VGND VGND VPWR VPWR sky130_fd_sc_hd__decap_8
XFILLER_113_15 VPWR VGND VPWR VGND sky130_ef_sc_hd__decap_12
X_09603_ _01610_ _02133_ VGND VGND VPWR VPWR _02135_ sky130_fd_sc_hd__xnor2_1
XTAP_TAPCELL_ROW_3_348 VGND VPWR sky130_fd_sc_hd__tapvpwrvgnd_1
XTAP_TAPCELL_ROW_3_337 VGND VPWR sky130_fd_sc_hd__tapvpwrvgnd_1
XFILLER_83_355 VGND VGND VPWR VPWR sky130_fd_sc_hd__decap_4
X_07795_ _00271_ _00272_ VGND VGND VPWR VPWR _00274_ sky130_fd_sc_hd__xnor2_2
X_09534_ _01894_ _02058_ VGND VGND VPWR VPWR _02059_ sky130_fd_sc_hd__nand2_1
XFILLER_37_772 VPWR VGND VPWR VGND sky130_ef_sc_hd__decap_12
X_09465_ net621 net370 net368 net630 VGND VGND VPWR VPWR _01984_ sky130_fd_sc_hd__a22oi_1
XTAP_TAPCELL_ROW_65_1245 VGND VPWR sky130_fd_sc_hd__tapvpwrvgnd_1
XFILLER_52_753 VGND VGND VPWR VPWR sky130_fd_sc_hd__decap_3
XFILLER_24_433 VPWR VGND VPWR VGND sky130_ef_sc_hd__decap_12
XFILLER_24_477 VGND VGND VPWR VPWR sky130_fd_sc_hd__fill_1
X_08416_ _00557_ _00791_ _00789_ VGND VGND VPWR VPWR _00890_ sky130_fd_sc_hd__a21oi_1
X_09396_ _01908_ _01868_ VGND VGND VPWR VPWR _01909_ sky130_fd_sc_hd__nand2b_1
XFILLER_51_285 VGND VGND VPWR VPWR sky130_fd_sc_hd__fill_1
XTAP_TAPCELL_ROW_22_612 VGND VPWR sky130_fd_sc_hd__tapvpwrvgnd_1
XTAP_TAPCELL_ROW_22_623 VGND VPWR sky130_fd_sc_hd__tapvpwrvgnd_1
X_08347_ _00819_ _00820_ VGND VGND VPWR VPWR _00821_ sky130_fd_sc_hd__or2_1
X_08278_ _00605_ _00616_ _00615_ VGND VGND VPWR VPWR _00753_ sky130_fd_sc_hd__a21o_1
X_07229_ _05810_ _05821_ VGND VGND VPWR VPWR _05832_ sky130_fd_sc_hd__nand2_1
XFILLER_4_805 VGND VGND VPWR VPWR sky130_fd_sc_hd__decap_6
XFILLER_98_27 VGND VGND VPWR VPWR sky130_fd_sc_hd__fill_1
XFILLER_3_326 VGND VGND VPWR VPWR sky130_fd_sc_hd__decap_8
X_10240_ _02824_ _02825_ VGND VGND VPWR VPWR _02826_ sky130_fd_sc_hd__nand2_1
XFILLER_133_541 VGND VGND VPWR VPWR sky130_fd_sc_hd__fill_1
XFILLER_106_755 VGND VGND VPWR VPWR sky130_fd_sc_hd__fill_1
XFILLER_3_337 VGND VGND VPWR VPWR sky130_fd_sc_hd__decap_8
XFILLER_133_574 VPWR VGND VPWR VGND sky130_ef_sc_hd__decap_12
X_10171_ _02458_ _02675_ _02673_ VGND VGND VPWR VPWR _02754_ sky130_fd_sc_hd__a21o_1
XTAP_TAPCELL_ROW_76_1396 VGND VPWR sky130_fd_sc_hd__tapvpwrvgnd_1
XPHY_EDGE_ROW_110_Right_110 VGND VGND VPWR VPWR sky130_fd_sc_hd__decap_3
XFILLER_105_298 VGND VGND VPWR VPWR sky130_fd_sc_hd__decap_8
XFILLER_47_503 VGND VGND VPWR VPWR sky130_fd_sc_hd__fill_1
XFILLER_86_182 VGND VGND VPWR VPWR sky130_fd_sc_hd__decap_4
XFILLER_19_249 VPWR VGND VPWR VGND sky130_ef_sc_hd__decap_12
XFILLER_28_750 VGND VGND VPWR VPWR sky130_fd_sc_hd__decap_6
X_12812_ net514 net506 net394 VGND VGND VPWR VPWR _05629_ sky130_fd_sc_hd__nand3_1
XFILLER_74_377 VPWR VGND VPWR VGND sky130_ef_sc_hd__decap_12
XFILLER_34_219 VGND VGND VPWR VPWR sky130_fd_sc_hd__decap_6
XTAP_TAPCELL_ROW_120_2040 VGND VPWR sky130_fd_sc_hd__tapvpwrvgnd_1
XFILLER_103_81 VPWR VGND VPWR VGND sky130_ef_sc_hd__decap_12
X_12743_ _05376_ _05378_ _05552_ _05553_ VGND VGND VPWR VPWR _05554_ sky130_fd_sc_hd__a211o_1
XFILLER_43_742 VPWR VGND VPWR VGND sky130_ef_sc_hd__decap_12
XFILLER_63_63 VGND VGND VPWR VPWR sky130_fd_sc_hd__fill_1
X_12674_ _05471_ _05477_ VGND VGND VPWR VPWR _05479_ sky130_fd_sc_hd__xor2_1
XFILLER_43_797 VPWR VGND VPWR VGND sky130_ef_sc_hd__decap_12
XFILLER_15_499 VGND VGND VPWR VPWR sky130_fd_sc_hd__fill_2
X_11625_ _04196_ _04198_ _04335_ VGND VGND VPWR VPWR _04337_ sky130_fd_sc_hd__a21o_1
XFILLER_11_650 VGND VGND VPWR VPWR sky130_fd_sc_hd__decap_6
XFILLER_30_458 VGND VGND VPWR VPWR sky130_fd_sc_hd__decap_4
XFILLER_7_621 VPWR VGND VPWR VGND sky130_ef_sc_hd__decap_12
X_11556_ _04127_ _04136_ _04135_ VGND VGND VPWR VPWR _04262_ sky130_fd_sc_hd__a21o_1
XFILLER_10_171 VGND VGND VPWR VPWR sky130_fd_sc_hd__decap_8
X_10507_ _03112_ _03113_ _03114_ VGND VGND VPWR VPWR _03116_ sky130_fd_sc_hd__a21o_1
X_13226_ _06079_ _06080_ VGND VGND VPWR VPWR _06081_ sky130_fd_sc_hd__xnor2_1
X_11487_ _04037_ _04186_ VGND VGND VPWR VPWR _04187_ sky130_fd_sc_hd__xnor2_1
XFILLER_136_390 VGND VGND VPWR VPWR sky130_fd_sc_hd__decap_6
XFILLER_6_197 VGND VGND VPWR VPWR sky130_fd_sc_hd__decap_6
X_10438_ _03029_ _03033_ _03032_ VGND VGND VPWR VPWR _03042_ sky130_fd_sc_hd__a21o_1
X_13157_ _06004_ _06005_ VGND VGND VPWR VPWR _06006_ sky130_fd_sc_hd__or2_1
X_10369_ _02963_ _02965_ VGND VGND VPWR VPWR _02966_ sky130_fd_sc_hd__and2b_1
XFILLER_112_769 VPWR VGND VPWR VGND sky130_ef_sc_hd__decap_12
XFILLER_97_447 VGND VGND VPWR VPWR sky130_fd_sc_hd__fill_1
X_13088_ _05893_ _05928_ VGND VGND VPWR VPWR _05931_ sky130_fd_sc_hd__xnor2_1
X_12108_ _04857_ _04858_ _04859_ VGND VGND VPWR VPWR _04861_ sky130_fd_sc_hd__nand3_1
X_12039_ net573 net696 _04782_ _04780_ VGND VGND VPWR VPWR _04785_ sky130_fd_sc_hd__a31o_1
XFILLER_38_503 VPWR VGND VPWR VGND sky130_ef_sc_hd__decap_12
XFILLER_78_694 VGND VGND VPWR VPWR sky130_fd_sc_hd__fill_1
XFILLER_19_3 VPWR VGND VPWR VGND sky130_ef_sc_hd__decap_12
XFILLER_38_525 VGND VGND VPWR VPWR sky130_fd_sc_hd__fill_1
XFILLER_38_547 VPWR VGND VPWR VGND sky130_ef_sc_hd__decap_12
XFILLER_92_141 VGND VGND VPWR VPWR sky130_fd_sc_hd__fill_1
XFILLER_93_686 VGND VGND VPWR VPWR sky130_fd_sc_hd__fill_2
X_07580_ _06645_ _06647_ VGND VGND VPWR VPWR _06809_ sky130_fd_sc_hd__and2_1
XFILLER_53_517 VPWR VGND VPWR VGND sky130_ef_sc_hd__decap_12
XTAP_TAPCELL_ROW_105_1824 VGND VPWR sky130_fd_sc_hd__tapvpwrvgnd_1
X_09250_ net259 net351 VGND VGND VPWR VPWR _01750_ sky130_fd_sc_hd__nor2_1
XTAP_TAPCELL_ROW_138_2312 VGND VPWR sky130_fd_sc_hd__tapvpwrvgnd_1
XTAP_TAPCELL_ROW_138_2301 VGND VPWR sky130_fd_sc_hd__tapvpwrvgnd_1
XFILLER_33_296 VGND VGND VPWR VPWR sky130_fd_sc_hd__fill_1
X_08201_ _00676_ VGND VGND VPWR VPWR _00677_ sky130_fd_sc_hd__inv_2
X_09181_ _01406_ _01501_ _01500_ VGND VGND VPWR VPWR _01675_ sky130_fd_sc_hd__o21ba_1
XFILLER_21_469 VGND VGND VPWR VPWR sky130_fd_sc_hd__fill_2
XTAP_TAPCELL_ROW_60_1175 VGND VPWR sky130_fd_sc_hd__tapvpwrvgnd_1
XTAP_TAPCELL_ROW_60_1164 VGND VPWR sky130_fd_sc_hd__tapvpwrvgnd_1
X_08132_ net665 net256 _06633_ VGND VGND VPWR VPWR _00608_ sky130_fd_sc_hd__o21ai_1
XFILLER_134_305 VGND VGND VPWR VPWR sky130_fd_sc_hd__decap_3
XFILLER_119_368 VGND VGND VPWR VPWR sky130_fd_sc_hd__decap_8
X_08063_ _00537_ _00538_ VGND VGND VPWR VPWR _00540_ sky130_fd_sc_hd__xor2_2
XFILLER_108_15 VPWR VGND VPWR VGND sky130_ef_sc_hd__decap_12
X_07014_ _03456_ _03467_ _03445_ VGND VGND VPWR VPWR _03489_ sky130_fd_sc_hd__a21bo_1
XTAP_TAPCELL_ROW_116_1986 VGND VPWR sky130_fd_sc_hd__tapvpwrvgnd_1
XTAP_TAPCELL_ROW_116_1975 VGND VPWR sky130_fd_sc_hd__tapvpwrvgnd_1
XTAP_TAPCELL_ROW_8_418 VGND VPWR sky130_fd_sc_hd__tapvpwrvgnd_1
XFILLER_130_500 VGND VGND VPWR VPWR sky130_fd_sc_hd__decap_8
XFILLER_103_714 VPWR VGND VPWR VGND sky130_ef_sc_hd__decap_12
XFILLER_0_307 VGND VGND VPWR VPWR sky130_fd_sc_hd__fill_1
X_08965_ _01298_ _01307_ _01305_ VGND VGND VPWR VPWR _01439_ sky130_fd_sc_hd__a21o_1
X_07916_ net627 net618 net705 net704 VGND VGND VPWR VPWR _00394_ sky130_fd_sc_hd__and4_1
XFILLER_29_503 VGND VGND VPWR VPWR sky130_fd_sc_hd__fill_1
X_08896_ _01239_ _01244_ _01361_ _01362_ VGND VGND VPWR VPWR _01364_ sky130_fd_sc_hd__a22o_1
XFILLER_84_29 VPWR VGND VPWR VGND sky130_ef_sc_hd__decap_12
XFILLER_84_642 VGND VGND VPWR VPWR sky130_fd_sc_hd__fill_2
XFILLER_83_130 VGND VGND VPWR VPWR sky130_fd_sc_hd__decap_6
X_07847_ _00318_ _00323_ VGND VGND VPWR VPWR _00325_ sky130_fd_sc_hd__xor2_2
XFILLER_17_709 VGND VGND VPWR VPWR sky130_fd_sc_hd__fill_1
XFILLER_84_697 VGND VGND VPWR VPWR sky130_fd_sc_hd__decap_3
X_07778_ _00255_ _00256_ VGND VGND VPWR VPWR _00257_ sky130_fd_sc_hd__nor2_1
X_09517_ net549 net360 _01872_ _01870_ VGND VGND VPWR VPWR _02040_ sky130_fd_sc_hd__a31o_1
XFILLER_71_347 VGND VGND VPWR VPWR sky130_fd_sc_hd__fill_2
XFILLER_37_580 VGND VGND VPWR VPWR sky130_fd_sc_hd__fill_1
XFILLER_24_241 VGND VGND VPWR VPWR sky130_fd_sc_hd__decap_4
XFILLER_40_701 VPWR VGND VPWR VGND sky130_ef_sc_hd__decap_12
X_09448_ _01963_ _01964_ VGND VGND VPWR VPWR _01966_ sky130_fd_sc_hd__nand2_1
XFILLER_25_797 VPWR VGND VPWR VGND sky130_ef_sc_hd__decap_12
X_09379_ net355 _01726_ _01722_ VGND VGND VPWR VPWR _01891_ sky130_fd_sc_hd__a21oi_1
XFILLER_33_55 VGND VGND VPWR VPWR sky130_fd_sc_hd__fill_1
X_12390_ net472 net607 net404 net381 VGND VGND VPWR VPWR _05169_ sky130_fd_sc_hd__and4_1
X_11410_ _03971_ _03979_ _03978_ VGND VGND VPWR VPWR _04104_ sky130_fd_sc_hd__a21o_1
XFILLER_123_3 VPWR VGND VPWR VGND sky130_ef_sc_hd__decap_12
XTAP_TAPCELL_ROW_78_1436 VGND VPWR sky130_fd_sc_hd__tapvpwrvgnd_1
XTAP_TAPCELL_ROW_78_1425 VGND VPWR sky130_fd_sc_hd__tapvpwrvgnd_1
X_11341_ _03919_ _03950_ _03949_ VGND VGND VPWR VPWR _04028_ sky130_fd_sc_hd__a21oi_1
XFILLER_138_699 VGND VGND VPWR VPWR sky130_fd_sc_hd__fill_1
XFILLER_125_349 VGND VGND VPWR VPWR sky130_fd_sc_hd__decap_8
XFILLER_106_530 VGND VGND VPWR VPWR sky130_fd_sc_hd__fill_2
XTAP_TAPCELL_ROW_91_1614 VGND VPWR sky130_fd_sc_hd__tapvpwrvgnd_1
XFILLER_3_134 VPWR VGND VPWR VGND sky130_ef_sc_hd__decap_12
X_11272_ _03820_ _03829_ _03827_ VGND VGND VPWR VPWR _03953_ sky130_fd_sc_hd__a21oi_1
XTAP_TAPCELL_ROW_91_1625 VGND VPWR sky130_fd_sc_hd__tapvpwrvgnd_1
X_13011_ _05845_ _05846_ VGND VGND VPWR VPWR _05847_ sky130_fd_sc_hd__and2b_1
X_10223_ _02805_ _02806_ VGND VGND VPWR VPWR _02807_ sky130_fd_sc_hd__nor2_1
XFILLER_133_393 VGND VGND VPWR VPWR sky130_fd_sc_hd__decap_6
X_10154_ _02734_ _02718_ VGND VGND VPWR VPWR _02735_ sky130_fd_sc_hd__and2b_1
XFILLER_79_447 VGND VGND VPWR VPWR sky130_fd_sc_hd__fill_1
XFILLER_79_469 VGND VGND VPWR VPWR sky130_fd_sc_hd__decap_3
XFILLER_58_41 VPWR VGND VPWR VGND sky130_ef_sc_hd__decap_12
X_10085_ _02658_ _02659_ VGND VGND VPWR VPWR _02660_ sky130_fd_sc_hd__nand2b_1
XFILLER_74_141 VGND VGND VPWR VPWR sky130_fd_sc_hd__fill_2
XTAP_TAPCELL_ROW_89_1587 VGND VPWR sky130_fd_sc_hd__tapvpwrvgnd_1
XFILLER_35_517 VPWR VGND VPWR VGND sky130_ef_sc_hd__decap_12
XFILLER_90_634 VGND VGND VPWR VPWR sky130_fd_sc_hd__decap_8
XFILLER_16_720 VPWR VGND VPWR VGND sky130_ef_sc_hd__decap_12
XFILLER_90_678 VPWR VGND VPWR VGND sky130_ef_sc_hd__decap_12
XFILLER_43_561 VGND VGND VPWR VPWR sky130_fd_sc_hd__decap_4
X_10987_ net442 net274 _03639_ _03640_ VGND VGND VPWR VPWR _03641_ sky130_fd_sc_hd__a22o_1
X_12726_ _05353_ _05356_ _05355_ VGND VGND VPWR VPWR _05536_ sky130_fd_sc_hd__a21o_1
XFILLER_43_583 VPWR VGND VPWR VGND sky130_ef_sc_hd__decap_12
XTAP_TAPCELL_ROW_100_1754 VGND VPWR sky130_fd_sc_hd__tapvpwrvgnd_1
XTAP_TAPCELL_ROW_100_1743 VGND VPWR sky130_fd_sc_hd__tapvpwrvgnd_1
X_12657_ net514 net506 net23 net24 VGND VGND VPWR VPWR _05460_ sky130_fd_sc_hd__and4_1
XFILLER_129_644 VGND VGND VPWR VPWR sky130_fd_sc_hd__fill_1
XFILLER_128_121 VGND VGND VPWR VPWR sky130_fd_sc_hd__decap_4
XFILLER_90_83 VGND VGND VPWR VPWR sky130_fd_sc_hd__fill_1
X_11608_ _04175_ _04179_ _04180_ VGND VGND VPWR VPWR _04319_ sky130_fd_sc_hd__a21o_1
XFILLER_117_817 VGND VGND VPWR VPWR sky130_fd_sc_hd__decap_3
X_12588_ _05208_ _05211_ _05384_ VGND VGND VPWR VPWR _05386_ sky130_fd_sc_hd__a21oi_1
XFILLER_11_480 VPWR VGND VPWR VGND sky130_ef_sc_hd__decap_12
XTAP_TAPCELL_ROW_13_486 VGND VPWR sky130_fd_sc_hd__tapvpwrvgnd_1
XTAP_TAPCELL_ROW_133_2231 VGND VPWR sky130_fd_sc_hd__tapvpwrvgnd_1
X_11539_ _04242_ _04243_ VGND VGND VPWR VPWR _04244_ sky130_fd_sc_hd__nand2_1
XFILLER_99_81 VPWR VGND VPWR VGND sky130_ef_sc_hd__decap_12
XFILLER_131_319 VGND VGND VPWR VPWR sky130_fd_sc_hd__decap_4
XFILLER_98_723 VGND VGND VPWR VPWR sky130_fd_sc_hd__decap_8
X_13209_ _06052_ _06060_ VGND VGND VPWR VPWR _06063_ sky130_fd_sc_hd__xor2_1
XFILLER_112_533 VGND VGND VPWR VPWR sky130_fd_sc_hd__decap_3
XFILLER_112_522 VGND VGND VPWR VPWR sky130_fd_sc_hd__decap_8
XFILLER_97_233 VGND VGND VPWR VPWR sky130_fd_sc_hd__fill_1
XFILLER_112_577 VGND VGND VPWR VPWR sky130_fd_sc_hd__decap_8
XFILLER_100_717 VGND VGND VPWR VPWR sky130_fd_sc_hd__fill_1
XFILLER_112_599 VGND VGND VPWR VPWR sky130_fd_sc_hd__fill_1
X_08750_ _01209_ _01215_ _01216_ VGND VGND VPWR VPWR _01217_ sky130_fd_sc_hd__and3_1
X_08681_ _01144_ _01147_ VGND VGND VPWR VPWR _01148_ sky130_fd_sc_hd__xnor2_1
X_07701_ _00169_ _00179_ VGND VGND VPWR VPWR _00180_ sky130_fd_sc_hd__xor2_1
XFILLER_81_612 VGND VGND VPWR VPWR sky130_fd_sc_hd__decap_4
XFILLER_80_100 VGND VGND VPWR VPWR sky130_fd_sc_hd__fill_1
X_07632_ _00109_ _00110_ _00102_ VGND VGND VPWR VPWR _00112_ sky130_fd_sc_hd__a21o_1
XTAP_TAPCELL_ROW_49_1015 VGND VPWR sky130_fd_sc_hd__tapvpwrvgnd_1
XTAP_TAPCELL_ROW_49_1004 VGND VPWR sky130_fd_sc_hd__tapvpwrvgnd_1
X_09302_ net375 net600 VGND VGND VPWR VPWR _01807_ sky130_fd_sc_hd__nand2b_1
XTAP_TAPCELL_ROW_62_1204 VGND VPWR sky130_fd_sc_hd__tapvpwrvgnd_1
XFILLER_53_358 VPWR VGND VPWR VGND sky130_ef_sc_hd__decap_12
X_07563_ net682 net493 VGND VGND VPWR VPWR _06792_ sky130_fd_sc_hd__nand2_1
XFILLER_22_701 VPWR VGND VPWR VGND sky130_ef_sc_hd__decap_12
XFILLER_34_561 VPWR VGND VPWR VGND sky130_ef_sc_hd__decap_12
XFILLER_110_27 VGND VGND VPWR VPWR sky130_fd_sc_hd__fill_1
X_07494_ _06562_ _06564_ _06723_ VGND VGND VPWR VPWR _06724_ sky130_fd_sc_hd__a21oi_1
X_09233_ net481 net351 _01553_ _01552_ VGND VGND VPWR VPWR _01731_ sky130_fd_sc_hd__a31o_1
X_09164_ _01642_ _01655_ VGND VGND VPWR VPWR _01656_ sky130_fd_sc_hd__nor2_1
XTAP_TAPCELL_ROW_32_762 VGND VPWR sky130_fd_sc_hd__tapvpwrvgnd_1
XFILLER_119_143 VGND VGND VPWR VPWR sky130_fd_sc_hd__fill_1
X_08115_ _00576_ _00590_ VGND VGND VPWR VPWR _00591_ sky130_fd_sc_hd__xnor2_1
XFILLER_21_299 VGND VGND VPWR VPWR sky130_fd_sc_hd__fill_1
XFILLER_119_69 VPWR VGND VPWR VGND sky130_ef_sc_hd__decap_12
X_09095_ net531 net343 VGND VGND VPWR VPWR _01581_ sky130_fd_sc_hd__and2_1
X_08046_ _06659_ _00388_ _00387_ VGND VGND VPWR VPWR _00523_ sky130_fd_sc_hd__o21bai_1
XFILLER_115_360 VGND VGND VPWR VPWR sky130_fd_sc_hd__decap_4
XTAP_TAPCELL_ROW_73_1355 VGND VPWR sky130_fd_sc_hd__tapvpwrvgnd_1
XFILLER_135_57 VPWR VGND VPWR VGND sky130_ef_sc_hd__decap_12
X_09997_ _02562_ _02563_ VGND VGND VPWR VPWR _02564_ sky130_fd_sc_hd__and2b_1
XFILLER_130_363 VGND VGND VPWR VPWR sky130_fd_sc_hd__fill_1
XFILLER_130_352 VGND VGND VPWR VPWR sky130_fd_sc_hd__fill_1
XFILLER_95_39 VPWR VGND VPWR VGND sky130_ef_sc_hd__decap_12
XFILLER_0_137 VGND VGND VPWR VPWR sky130_fd_sc_hd__decap_3
X_08948_ _01418_ _01419_ VGND VGND VPWR VPWR _01421_ sky130_fd_sc_hd__xnor2_1
XFILLER_69_480 VPWR VGND VPWR VGND sky130_ef_sc_hd__decap_12
XFILLER_29_311 VGND VGND VPWR VPWR sky130_fd_sc_hd__fill_1
X_08879_ _01341_ _01342_ _01295_ VGND VGND VPWR VPWR _01346_ sky130_fd_sc_hd__o21ai_1
XFILLER_84_461 VGND VGND VPWR VPWR sky130_fd_sc_hd__fill_1
XFILLER_56_141 VGND VGND VPWR VPWR sky130_fd_sc_hd__decap_6
X_10910_ _03555_ _03556_ VGND VGND VPWR VPWR _03557_ sky130_fd_sc_hd__nand2b_1
X_11890_ _04559_ _04560_ _04572_ VGND VGND VPWR VPWR _04626_ sky130_fd_sc_hd__o21a_1
XFILLER_72_678 VGND VGND VPWR VPWR sky130_fd_sc_hd__decap_8
XFILLER_71_155 VPWR VGND VPWR VGND sky130_ef_sc_hd__decap_12
XFILLER_71_144 VGND VGND VPWR VPWR sky130_fd_sc_hd__fill_2
XFILLER_44_358 VGND VGND VPWR VPWR sky130_fd_sc_hd__fill_1
XFILLER_25_561 VGND VGND VPWR VPWR sky130_fd_sc_hd__decap_6
X_10841_ net622 net69 _03480_ _03481_ VGND VGND VPWR VPWR _03482_ sky130_fd_sc_hd__a22o_1
X_13560_ _06444_ _06445_ VGND VGND VPWR VPWR _06446_ sky130_fd_sc_hd__nand2_1
XFILLER_71_177 VGND VGND VPWR VPWR sky130_fd_sc_hd__fill_1
XFILLER_44_65 VPWR VGND VPWR VGND sky130_ef_sc_hd__decap_12
X_10772_ _03404_ _03405_ VGND VGND VPWR VPWR _03406_ sky130_fd_sc_hd__nand2_1
X_13491_ _06253_ _06254_ _06251_ VGND VGND VPWR VPWR _06371_ sky130_fd_sc_hd__a21o_1
X_12511_ _05298_ _05299_ _05294_ VGND VGND VPWR VPWR _05301_ sky130_fd_sc_hd__a21oi_1
XFILLER_12_244 VGND VGND VPWR VPWR sky130_fd_sc_hd__decap_8
X_12442_ _05138_ _05140_ VGND VGND VPWR VPWR _05225_ sky130_fd_sc_hd__nor2_1
XFILLER_12_277 VGND VGND VPWR VPWR sky130_fd_sc_hd__decap_8
XFILLER_138_441 VGND VGND VPWR VPWR sky130_fd_sc_hd__decap_3
XFILLER_60_53 VPWR VGND VPWR VGND sky130_ef_sc_hd__decap_12
XFILLER_8_248 VGND VGND VPWR VPWR sky130_fd_sc_hd__decap_4
XFILLER_125_113 VGND VGND VPWR VPWR sky130_fd_sc_hd__decap_3
X_12373_ net446 net29 VGND VGND VPWR VPWR _05150_ sky130_fd_sc_hd__nand2_1
XTAP_TAPCELL_ROW_10_445 VGND VPWR sky130_fd_sc_hd__tapvpwrvgnd_1
XFILLER_125_135 VGND VGND VPWR VPWR sky130_fd_sc_hd__decap_8
X_11324_ _03877_ _04009_ VGND VGND VPWR VPWR _04010_ sky130_fd_sc_hd__xnor2_1
XFILLER_5_15 VPWR VGND VPWR VGND sky130_ef_sc_hd__decap_12
X_11255_ net521 net287 _03787_ _03786_ net410 VGND VGND VPWR VPWR _03934_ sky130_fd_sc_hd__a32o_1
X_10206_ _02763_ _02790_ VGND VGND VPWR VPWR _02791_ sky130_fd_sc_hd__xnor2_1
X_11186_ _03592_ _03693_ _03692_ VGND VGND VPWR VPWR _03859_ sky130_fd_sc_hd__o21ba_1
X_10137_ _02646_ _02661_ _02660_ VGND VGND VPWR VPWR _02716_ sky130_fd_sc_hd__o21ai_1
XFILLER_95_737 VGND VGND VPWR VPWR sky130_fd_sc_hd__fill_2
X_10068_ _02639_ _02640_ VGND VGND VPWR VPWR _02642_ sky130_fd_sc_hd__and2b_1
XPHY_EDGE_ROW_13_Right_13 VGND VGND VPWR VPWR sky130_fd_sc_hd__decap_3
XFILLER_75_461 VGND VGND VPWR VPWR sky130_fd_sc_hd__decap_4
XFILLER_63_623 VGND VGND VPWR VPWR sky130_fd_sc_hd__fill_1
XFILLER_63_601 VGND VGND VPWR VPWR sky130_fd_sc_hd__decap_3
XFILLER_35_314 VPWR VGND VPWR VGND sky130_ef_sc_hd__decap_12
XFILLER_63_678 VGND VGND VPWR VPWR sky130_fd_sc_hd__decap_8
XFILLER_16_550 VGND VGND VPWR VPWR sky130_fd_sc_hd__fill_2
XTAP_TAPCELL_ROW_18_556 VGND VPWR sky130_fd_sc_hd__tapvpwrvgnd_1
XTAP_TAPCELL_ROW_18_567 VGND VPWR sky130_fd_sc_hd__tapvpwrvgnd_1
XFILLER_90_486 VGND VGND VPWR VPWR sky130_fd_sc_hd__decap_6
XFILLER_62_188 VGND VGND VPWR VPWR sky130_fd_sc_hd__decap_4
X_12709_ _05315_ _05515_ VGND VGND VPWR VPWR _05518_ sky130_fd_sc_hd__xnor2_1
XFILLER_31_531 VGND VGND VPWR VPWR sky130_fd_sc_hd__decap_4
X_13689_ clknet_3_3__leaf_clk _00048_ net714 VGND VGND VPWR VPWR net224 sky130_fd_sc_hd__dfrtp_1
XPHY_EDGE_ROW_22_Right_22 VGND VGND VPWR VPWR sky130_fd_sc_hd__decap_3
XFILLER_105_809 VPWR VGND VPWR VGND sky130_ef_sc_hd__decap_12
XFILLER_8_793 VPWR VGND VPWR VGND sky130_ef_sc_hd__decap_12
XFILLER_7_281 VPWR VGND VPWR VGND sky130_ef_sc_hd__decap_12
XFILLER_131_105 VGND VGND VPWR VPWR sky130_fd_sc_hd__decap_6
X_09920_ _02474_ _02479_ VGND VGND VPWR VPWR _02480_ sky130_fd_sc_hd__and2_1
XTAP_TAPCELL_ROW_113_1934 VGND VPWR sky130_fd_sc_hd__tapvpwrvgnd_1
Xfanout706 net103 VGND VGND VPWR VPWR net706 sky130_fd_sc_hd__buf_2
Xfanout717 net718 VGND VGND VPWR VPWR net717 sky130_fd_sc_hd__buf_4
X_09851_ _02396_ _02405_ VGND VGND VPWR VPWR _02406_ sky130_fd_sc_hd__xor2_1
XFILLER_98_564 VGND VGND VPWR VPWR sky130_fd_sc_hd__decap_8
X_09782_ net549 net356 _02188_ _02034_ VGND VGND VPWR VPWR _02330_ sky130_fd_sc_hd__a31o_1
X_08802_ _01140_ _01266_ VGND VGND VPWR VPWR _01268_ sky130_fd_sc_hd__nor2_1
XFILLER_105_27 VPWR VGND VPWR VGND sky130_ef_sc_hd__decap_12
X_06994_ _03128_ _03248_ VGND VGND VPWR VPWR _03270_ sky130_fd_sc_hd__xnor2_1
XTAP_TAPCELL_ROW_55_1096 VGND VPWR sky130_fd_sc_hd__tapvpwrvgnd_1
XPHY_EDGE_ROW_31_Right_31 VGND VGND VPWR VPWR sky130_fd_sc_hd__decap_3
X_08733_ _01190_ _01191_ _01197_ VGND VGND VPWR VPWR _01200_ sky130_fd_sc_hd__a21oi_1
XFILLER_73_409 VGND VGND VPWR VPWR sky130_fd_sc_hd__fill_2
XFILLER_66_450 VGND VGND VPWR VPWR sky130_fd_sc_hd__fill_1
XFILLER_54_601 VGND VGND VPWR VPWR sky130_fd_sc_hd__fill_2
XFILLER_121_15 VPWR VGND VPWR VGND sky130_ef_sc_hd__decap_12
X_08664_ _01079_ _01129_ VGND VGND VPWR VPWR _01131_ sky130_fd_sc_hd__nor2_1
XFILLER_54_645 VGND VGND VPWR VPWR sky130_fd_sc_hd__decap_8
XFILLER_53_100 VGND VGND VPWR VPWR sky130_fd_sc_hd__fill_2
XFILLER_26_336 VGND VGND VPWR VPWR sky130_fd_sc_hd__decap_8
XTAP_TAPCELL_ROW_37_832 VGND VPWR sky130_fd_sc_hd__tapvpwrvgnd_1
X_08595_ net586 net364 net363 net596 VGND VGND VPWR VPWR _01063_ sky130_fd_sc_hd__a22o_1
X_07615_ _00090_ _00094_ VGND VGND VPWR VPWR _00095_ sky130_fd_sc_hd__and2b_1
XFILLER_53_188 VGND VGND VPWR VPWR sky130_fd_sc_hd__fill_1
X_07546_ _05832_ _06612_ _06610_ VGND VGND VPWR VPWR _06775_ sky130_fd_sc_hd__o21a_1
XFILLER_22_531 VGND VGND VPWR VPWR sky130_fd_sc_hd__fill_1
X_09216_ _01699_ _01701_ _01710_ VGND VGND VPWR VPWR _01712_ sky130_fd_sc_hd__o21ai_1
X_07477_ _06677_ _06706_ VGND VGND VPWR VPWR _06707_ sky130_fd_sc_hd__nand2_1
XPHY_EDGE_ROW_40_Right_40 VGND VGND VPWR VPWR sky130_fd_sc_hd__decap_3
XFILLER_10_748 VGND VGND VPWR VPWR sky130_fd_sc_hd__decap_8
XFILLER_108_603 VGND VGND VPWR VPWR sky130_fd_sc_hd__fill_1
X_09147_ net625 net373 _01634_ _01635_ VGND VGND VPWR VPWR _01637_ sky130_fd_sc_hd__nand4_1
XFILLER_135_444 VGND VGND VPWR VPWR sky130_fd_sc_hd__fill_1
X_09078_ _01559_ _01560_ VGND VGND VPWR VPWR _01563_ sky130_fd_sc_hd__nor2_1
X_08029_ net425 net663 net661 net434 VGND VGND VPWR VPWR _00506_ sky130_fd_sc_hd__a22oi_1
XFILLER_123_639 VGND VGND VPWR VPWR sky130_fd_sc_hd__decap_6
XFILLER_122_138 VGND VGND VPWR VPWR sky130_fd_sc_hd__fill_2
XFILLER_1_435 VGND VGND VPWR VPWR sky130_fd_sc_hd__fill_2
XFILLER_131_661 VGND VGND VPWR VPWR sky130_fd_sc_hd__decap_8
XFILLER_103_341 VGND VGND VPWR VPWR sky130_fd_sc_hd__fill_1
X_11040_ _03696_ _03698_ _03538_ VGND VGND VPWR VPWR _03700_ sky130_fd_sc_hd__a21o_1
XFILLER_130_160 VPWR VGND VPWR VGND sky130_ef_sc_hd__decap_12
XFILLER_77_726 VGND VGND VPWR VPWR sky130_fd_sc_hd__fill_2
XFILLER_76_258 VGND VGND VPWR VPWR sky130_fd_sc_hd__fill_1
X_12991_ _05667_ _05824_ VGND VGND VPWR VPWR _05825_ sky130_fd_sc_hd__xnor2_1
XTAP_TAPCELL_ROW_86_1546 VGND VPWR sky130_fd_sc_hd__tapvpwrvgnd_1
X_11942_ net462 net393 _04679_ VGND VGND VPWR VPWR _04680_ sky130_fd_sc_hd__and3_1
XFILLER_55_31 VPWR VGND VPWR VGND sky130_ef_sc_hd__decap_12
XFILLER_45_645 VGND VGND VPWR VPWR sky130_fd_sc_hd__decap_8
XFILLER_44_122 VPWR VGND VPWR VGND sky130_ef_sc_hd__decap_12
X_11873_ _04524_ _04527_ _04606_ VGND VGND VPWR VPWR _04608_ sky130_fd_sc_hd__and3_1
X_13612_ _06494_ _06501_ VGND VGND VPWR VPWR _06502_ sky130_fd_sc_hd__xnor2_1
XFILLER_72_475 VGND VGND VPWR VPWR sky130_fd_sc_hd__fill_1
XTAP_TAPCELL_ROW_15_515 VGND VPWR sky130_fd_sc_hd__tapvpwrvgnd_1
X_10824_ net604 net323 VGND VGND VPWR VPWR _03463_ sky130_fd_sc_hd__nand2_1
XFILLER_32_306 VGND VGND VPWR VPWR sky130_fd_sc_hd__fill_2
XFILLER_32_317 VGND VGND VPWR VPWR sky130_fd_sc_hd__decap_3
XFILLER_111_81 VGND VGND VPWR VPWR sky130_fd_sc_hd__decap_6
X_13543_ _06341_ _06426_ VGND VGND VPWR VPWR _06427_ sky130_fd_sc_hd__xor2_1
XFILLER_71_63 VGND VGND VPWR VPWR sky130_fd_sc_hd__fill_1
X_10755_ _03217_ _03220_ _03386_ VGND VGND VPWR VPWR _03387_ sky130_fd_sc_hd__a21o_1
XTAP_TAPCELL_ROW_117_2001 VGND VPWR sky130_fd_sc_hd__tapvpwrvgnd_1
X_13474_ _06331_ _06350_ VGND VGND VPWR VPWR _06352_ sky130_fd_sc_hd__xor2_1
X_10686_ net631 net622 net324 net69 VGND VGND VPWR VPWR _03312_ sky130_fd_sc_hd__and4_1
X_12425_ _05204_ _05205_ _05112_ VGND VGND VPWR VPWR _05207_ sky130_fd_sc_hd__o21a_1
X_12356_ _04999_ _05128_ _05129_ VGND VGND VPWR VPWR _05131_ sky130_fd_sc_hd__and3_1
XFILLER_5_741 VPWR VGND VPWR VGND sky130_ef_sc_hd__decap_12
XFILLER_126_477 VGND VGND VPWR VPWR sky130_fd_sc_hd__decap_8
X_11307_ _03988_ _03989_ VGND VGND VPWR VPWR _03991_ sky130_fd_sc_hd__xnor2_1
XFILLER_107_680 VGND VGND VPWR VPWR sky130_fd_sc_hd__fill_2
X_12287_ _04968_ _04970_ _05053_ _05055_ VGND VGND VPWR VPWR _05056_ sky130_fd_sc_hd__nor4_1
XFILLER_5_785 VPWR VGND VPWR VGND sky130_ef_sc_hd__decap_12
XFILLER_106_190 VGND VGND VPWR VPWR sky130_fd_sc_hd__fill_2
X_11238_ _03879_ _03913_ VGND VGND VPWR VPWR _03916_ sky130_fd_sc_hd__xnor2_1
XFILLER_68_737 VPWR VGND VPWR VGND sky130_ef_sc_hd__decap_12
X_11169_ _03668_ _03674_ _03673_ VGND VGND VPWR VPWR _03841_ sky130_fd_sc_hd__a21boi_1
XTAP_TAPCELL_ROW_128_2152 VGND VPWR sky130_fd_sc_hd__tapvpwrvgnd_1
XFILLER_83_729 VGND VGND VPWR VPWR sky130_fd_sc_hd__decap_4
XFILLER_36_645 VPWR VGND VPWR VGND sky130_ef_sc_hd__decap_12
XPHY_EDGE_ROW_11_Left_150 VGND VGND VPWR VPWR sky130_fd_sc_hd__decap_3
X_07400_ net674 net411 VGND VGND VPWR VPWR _06630_ sky130_fd_sc_hd__and2b_1
XFILLER_51_615 VGND VGND VPWR VPWR sky130_fd_sc_hd__fill_1
X_08380_ _00692_ _00853_ VGND VGND VPWR VPWR _00854_ sky130_fd_sc_hd__xor2_1
X_07331_ _05406_ _05374_ _06560_ _06561_ VGND VGND VPWR VPWR _06562_ sky130_fd_sc_hd__a211o_4
XFILLER_16_391 VGND VGND VPWR VPWR sky130_fd_sc_hd__fill_1
XFILLER_31_350 VGND VGND VPWR VPWR sky130_fd_sc_hd__fill_2
X_07262_ _06171_ _06181_ VGND VGND VPWR VPWR _06192_ sky130_fd_sc_hd__nor2_1
X_09001_ _01476_ _01477_ _01474_ VGND VGND VPWR VPWR _01479_ sky130_fd_sc_hd__o21ai_1
X_07193_ _05395_ _05417_ _03992_ _04014_ VGND VGND VPWR VPWR _05439_ sky130_fd_sc_hd__o211a_1
XFILLER_129_293 VGND VGND VPWR VPWR sky130_fd_sc_hd__decap_6
XTAP_TAPCELL_ROW_57_1125 VGND VPWR sky130_fd_sc_hd__tapvpwrvgnd_1
XFILLER_116_15 VPWR VGND VPWR VGND sky130_ef_sc_hd__decap_12
X_09903_ _02340_ _02353_ _02352_ VGND VGND VPWR VPWR _02461_ sky130_fd_sc_hd__o21ai_1
Xfanout514 net518 VGND VGND VPWR VPWR net514 sky130_fd_sc_hd__buf_2
XTAP_TAPCELL_ROW_70_1314 VGND VPWR sky130_fd_sc_hd__tapvpwrvgnd_1
Xfanout503 net505 VGND VGND VPWR VPWR net503 sky130_fd_sc_hd__clkbuf_4
X_09834_ _02361_ _02385_ VGND VGND VPWR VPWR _02387_ sky130_fd_sc_hd__xnor2_1
Xfanout525 net147 VGND VGND VPWR VPWR net525 sky130_fd_sc_hd__clkbuf_4
Xfanout547 net551 VGND VGND VPWR VPWR net547 sky130_fd_sc_hd__buf_2
Xfanout536 net543 VGND VGND VPWR VPWR net536 sky130_fd_sc_hd__dlymetal6s2s_1
Xfanout558 net559 VGND VGND VPWR VPWR net558 sky130_fd_sc_hd__buf_2
XFILLER_58_225 VGND VGND VPWR VPWR sky130_fd_sc_hd__fill_1
Xfanout569 net570 VGND VGND VPWR VPWR net569 sky130_fd_sc_hd__buf_2
X_09765_ _02185_ _02311_ VGND VGND VPWR VPWR _02312_ sky130_fd_sc_hd__xnor2_2
XFILLER_86_589 VGND VGND VPWR VPWR sky130_fd_sc_hd__decap_4
X_06977_ _01508_ _01725_ _02162_ _02499_ _02532_ VGND VGND VPWR VPWR _03084_ sky130_fd_sc_hd__o41a_1
X_09696_ _02232_ _02234_ VGND VGND VPWR VPWR _02236_ sky130_fd_sc_hd__nand2_1
X_08716_ net634 net378 VGND VGND VPWR VPWR _01183_ sky130_fd_sc_hd__nand2_1
XFILLER_39_483 VPWR VGND VPWR VGND sky130_ef_sc_hd__decap_12
X_08647_ _01109_ _01113_ VGND VGND VPWR VPWR _01114_ sky130_fd_sc_hd__or2_1
XFILLER_92_29 VPWR VGND VPWR VGND sky130_ef_sc_hd__decap_12
XFILLER_82_751 VGND VGND VPWR VPWR sky130_fd_sc_hd__decap_4
XFILLER_26_133 VGND VGND VPWR VPWR sky130_fd_sc_hd__decap_6
XTAP_TAPCELL_ROW_68_1287 VGND VPWR sky130_fd_sc_hd__tapvpwrvgnd_1
XFILLER_54_497 VPWR VGND VPWR VGND sky130_ef_sc_hd__decap_12
XFILLER_54_475 VGND VGND VPWR VPWR sky130_fd_sc_hd__fill_1
XFILLER_42_626 VPWR VGND VPWR VGND sky130_ef_sc_hd__decap_12
XFILLER_27_689 VGND VGND VPWR VPWR sky130_fd_sc_hd__fill_1
X_08578_ _01042_ _01045_ VGND VGND VPWR VPWR _01046_ sky130_fd_sc_hd__xnor2_1
XTAP_TAPCELL_ROW_81_1476 VGND VPWR sky130_fd_sc_hd__tapvpwrvgnd_1
X_07529_ _05996_ _06606_ _06608_ _06603_ VGND VGND VPWR VPWR _06758_ sky130_fd_sc_hd__o2bb2a_1
XFILLER_41_169 VGND VGND VPWR VPWR sky130_fd_sc_hd__decap_6
XFILLER_50_681 VGND VGND VPWR VPWR sky130_fd_sc_hd__decap_4
X_10540_ net466 net275 _02983_ VGND VGND VPWR VPWR _03153_ sky130_fd_sc_hd__a21oi_1
XFILLER_6_516 VGND VGND VPWR VPWR sky130_fd_sc_hd__decap_6
XFILLER_10_545 VPWR VGND VPWR VGND sky130_ef_sc_hd__decap_12
X_10471_ _02903_ _02935_ _02939_ VGND VGND VPWR VPWR _03077_ sky130_fd_sc_hd__a21o_1
XFILLER_41_55 VGND VGND VPWR VPWR sky130_fd_sc_hd__fill_1
XFILLER_108_444 VGND VGND VPWR VPWR sky130_fd_sc_hd__decap_6
X_12210_ net489 net407 VGND VGND VPWR VPWR _04972_ sky130_fd_sc_hd__nand2_1
XTAP_TAPCELL_ROW_20_584 VGND VPWR sky130_fd_sc_hd__tapvpwrvgnd_1
XFILLER_108_466 VGND VGND VPWR VPWR sky130_fd_sc_hd__fill_1
X_13190_ net548 _05740_ VGND VGND VPWR VPWR _06042_ sky130_fd_sc_hd__and2_1
XTAP_TAPCELL_ROW_20_595 VGND VPWR sky130_fd_sc_hd__tapvpwrvgnd_1
X_12141_ _04844_ _04896_ VGND VGND VPWR VPWR _04897_ sky130_fd_sc_hd__nor2_1
XFILLER_96_309 VGND VGND VPWR VPWR sky130_fd_sc_hd__decap_4
X_12072_ _04814_ _04820_ VGND VGND VPWR VPWR _04821_ sky130_fd_sc_hd__xnor2_1
XFILLER_2_744 VPWR VGND VPWR VGND sky130_ef_sc_hd__decap_12
XFILLER_1_232 VGND VGND VPWR VPWR sky130_fd_sc_hd__fill_2
XFILLER_110_119 VPWR VGND VPWR VGND sky130_ef_sc_hd__decap_12
XFILLER_77_523 VGND VGND VPWR VPWR sky130_fd_sc_hd__fill_2
X_11023_ _03662_ _03679_ _03680_ VGND VGND VPWR VPWR _03681_ sky130_fd_sc_hd__nand3_1
XFILLER_49_225 VPWR VGND VPWR VGND sky130_ef_sc_hd__decap_12
XFILLER_2_27 VGND VGND VPWR VPWR sky130_fd_sc_hd__fill_1
XFILLER_66_41 VPWR VGND VPWR VGND sky130_ef_sc_hd__decap_12
XFILLER_65_729 VGND VGND VPWR VPWR sky130_fd_sc_hd__decap_8
XFILLER_49_269 VGND VGND VPWR VPWR sky130_fd_sc_hd__fill_1
XFILLER_92_559 VGND VGND VPWR VPWR sky130_fd_sc_hd__decap_6
X_12974_ _05641_ _05649_ _05648_ VGND VGND VPWR VPWR _05806_ sky130_fd_sc_hd__a21oi_1
XFILLER_64_239 VGND VGND VPWR VPWR sky130_fd_sc_hd__fill_2
XFILLER_17_100 VPWR VGND VPWR VGND sky130_ef_sc_hd__decap_12
XFILLER_18_645 VGND VGND VPWR VPWR sky130_fd_sc_hd__fill_2
X_11925_ _04661_ VGND VGND VPWR VPWR _04662_ sky130_fd_sc_hd__inv_2
XFILLER_17_144 VGND VGND VPWR VPWR sky130_fd_sc_hd__decap_4
XTAP_TAPCELL_ROW_123_2082 VGND VPWR sky130_fd_sc_hd__tapvpwrvgnd_1
XFILLER_72_261 VGND VGND VPWR VPWR sky130_fd_sc_hd__decap_6
XFILLER_72_283 VGND VGND VPWR VPWR sky130_fd_sc_hd__fill_2
X_11856_ _04586_ _04587_ VGND VGND VPWR VPWR _04589_ sky130_fd_sc_hd__xnor2_1
X_11787_ _04078_ _04389_ _04512_ VGND VGND VPWR VPWR _04514_ sky130_fd_sc_hd__nor3_1
XFILLER_20_309 VPWR VGND VPWR VGND sky130_ef_sc_hd__decap_12
X_10807_ _03122_ _03269_ VGND VGND VPWR VPWR _03444_ sky130_fd_sc_hd__nor2_1
X_13526_ _06407_ _06408_ VGND VGND VPWR VPWR _00031_ sky130_fd_sc_hd__xor2_1
X_10738_ _03213_ _03365_ _03367_ VGND VGND VPWR VPWR _03369_ sky130_fd_sc_hd__o21ai_1
XTAP_TAPCELL_ROW_99_1737 VGND VPWR sky130_fd_sc_hd__tapvpwrvgnd_1
X_13457_ _06076_ _06332_ VGND VGND VPWR VPWR _06333_ sky130_fd_sc_hd__xnor2_4
XFILLER_127_742 VGND VGND VPWR VPWR sky130_fd_sc_hd__fill_1
XPHY_EDGE_ROW_124_Right_124 VGND VGND VPWR VPWR sky130_fd_sc_hd__decap_3
X_12408_ _05185_ _05186_ _05178_ VGND VGND VPWR VPWR _05189_ sky130_fd_sc_hd__a21o_1
X_10669_ _03290_ _03291_ _03288_ VGND VGND VPWR VPWR _03294_ sky130_fd_sc_hd__o21ai_1
XFILLER_126_230 VGND VGND VPWR VPWR sky130_fd_sc_hd__decap_4
X_13388_ _06256_ _06257_ VGND VGND VPWR VPWR _06259_ sky130_fd_sc_hd__nor2_1
XFILLER_127_797 VPWR VGND VPWR VGND sky130_ef_sc_hd__decap_12
XFILLER_99_125 VGND VGND VPWR VPWR sky130_fd_sc_hd__fill_1
X_12339_ _04987_ _04988_ _04992_ VGND VGND VPWR VPWR _05113_ sky130_fd_sc_hd__a21oi_1
XFILLER_99_147 VGND VGND VPWR VPWR sky130_fd_sc_hd__decap_6
XFILLER_49_3 VPWR VGND VPWR VGND sky130_ef_sc_hd__decap_12
X_06900_ _01769_ _02227_ VGND VGND VPWR VPWR _02249_ sky130_fd_sc_hd__xor2_1
X_07880_ _00208_ _00214_ _00213_ VGND VGND VPWR VPWR _00358_ sky130_fd_sc_hd__a21oi_1
XTAP_TAPCELL_ROW_52_1055 VGND VPWR sky130_fd_sc_hd__tapvpwrvgnd_1
XFILLER_68_589 VGND VGND VPWR VPWR sky130_fd_sc_hd__decap_8
XFILLER_68_567 VPWR VGND VPWR VGND sky130_ef_sc_hd__decap_12
X_06831_ net467 net674 net655 net269 VGND VGND VPWR VPWR _01497_ sky130_fd_sc_hd__and4_1
X_09550_ net488 net478 net347 net346 VGND VGND VPWR VPWR _02077_ sky130_fd_sc_hd__and4_1
XFILLER_83_526 VPWR VGND VPWR VGND sky130_ef_sc_hd__decap_12
XFILLER_49_781 VGND VGND VPWR VPWR sky130_fd_sc_hd__decap_3
XTAP_TAPCELL_ROW_108_1866 VGND VPWR sky130_fd_sc_hd__tapvpwrvgnd_1
X_09481_ _01999_ _02000_ VGND VGND VPWR VPWR _02002_ sky130_fd_sc_hd__xor2_1
XFILLER_83_559 VGND VGND VPWR VPWR sky130_fd_sc_hd__fill_1
X_08501_ _00927_ _00972_ VGND VGND VPWR VPWR _00973_ sky130_fd_sc_hd__xnor2_1
X_08432_ _00899_ _00903_ VGND VGND VPWR VPWR _00905_ sky130_fd_sc_hd__xor2_1
XTAP_TAPCELL_ROW_47_982 VGND VPWR sky130_fd_sc_hd__tapvpwrvgnd_1
X_08363_ _00763_ _00766_ _00768_ VGND VGND VPWR VPWR _00837_ sky130_fd_sc_hd__o21a_1
XFILLER_23_169 VPWR VGND VPWR VGND sky130_ef_sc_hd__decap_12
X_07314_ _05068_ _05155_ _05144_ VGND VGND VPWR VPWR _06545_ sky130_fd_sc_hd__a21bo_1
X_08294_ _00762_ _00767_ VGND VGND VPWR VPWR _00769_ sky130_fd_sc_hd__xnor2_1
XFILLER_20_821 VGND VGND VPWR VPWR sky130_fd_sc_hd__decap_3
X_07245_ net687 net485 net476 net114 VGND VGND VPWR VPWR _06007_ sky130_fd_sc_hd__a22o_1
XFILLER_31_180 VGND VGND VPWR VPWR sky130_fd_sc_hd__decap_8
XFILLER_118_775 VPWR VGND VPWR VGND sky130_ef_sc_hd__decap_12
X_07176_ _05199_ _05220_ _05013_ VGND VGND VPWR VPWR _05253_ sky130_fd_sc_hd__o21a_1
XFILLER_117_296 VPWR VGND VPWR VGND sky130_ef_sc_hd__decap_12
XFILLER_11_69 VPWR VGND VPWR VGND sky130_ef_sc_hd__decap_12
XFILLER_132_233 VPWR VGND VPWR VGND sky130_ef_sc_hd__decap_12
XFILLER_127_69 VPWR VGND VPWR VGND sky130_ef_sc_hd__decap_12
XFILLER_105_447 VGND VGND VPWR VPWR sky130_fd_sc_hd__fill_1
Xfanout311 net75 VGND VGND VPWR VPWR net311 sky130_fd_sc_hd__buf_2
Xfanout300 net81 VGND VGND VPWR VPWR net300 sky130_fd_sc_hd__buf_1
Xfanout322 net69 VGND VGND VPWR VPWR net322 sky130_fd_sc_hd__clkbuf_4
Xfanout355 net356 VGND VGND VPWR VPWR net355 sky130_fd_sc_hd__buf_2
Xfanout366 net42 VGND VGND VPWR VPWR net366 sky130_fd_sc_hd__buf_2
Xfanout344 net56 VGND VGND VPWR VPWR net344 sky130_fd_sc_hd__clkbuf_4
Xfanout333 net62 VGND VGND VPWR VPWR net333 sky130_fd_sc_hd__clkbuf_4
X_09817_ _02366_ _02367_ VGND VGND VPWR VPWR _02368_ sky130_fd_sc_hd__xnor2_1
Xfanout377 net34 VGND VGND VPWR VPWR net377 sky130_fd_sc_hd__clkbuf_4
XFILLER_100_141 VPWR VGND VPWR VGND sky130_ef_sc_hd__decap_12
Xfanout399 net22 VGND VGND VPWR VPWR net399 sky130_fd_sc_hd__clkbuf_2
Xfanout388 net29 VGND VGND VPWR VPWR net388 sky130_fd_sc_hd__buf_2
XFILLER_59_578 VGND VGND VPWR VPWR sky130_fd_sc_hd__decap_6
XFILLER_47_729 VGND VGND VPWR VPWR sky130_fd_sc_hd__fill_1
XFILLER_47_707 VPWR VGND VPWR VGND sky130_ef_sc_hd__decap_12
XTAP_TAPCELL_ROW_6_379 VGND VPWR sky130_fd_sc_hd__tapvpwrvgnd_1
X_09748_ _02281_ _02292_ VGND VGND VPWR VPWR _02294_ sky130_fd_sc_hd__xnor2_2
XFILLER_74_537 VPWR VGND VPWR VGND sky130_ef_sc_hd__decap_12
XFILLER_46_239 VPWR VGND VPWR VGND sky130_ef_sc_hd__decap_12
X_09679_ _02214_ _02215_ VGND VGND VPWR VPWR _02218_ sky130_fd_sc_hd__xnor2_1
XTAP_TAPCELL_ROW_83_1505 VGND VPWR sky130_fd_sc_hd__tapvpwrvgnd_1
X_11710_ _04173_ _04322_ _04321_ VGND VGND VPWR VPWR _04430_ sky130_fd_sc_hd__a21oi_1
XFILLER_15_615 VGND VGND VPWR VPWR sky130_fd_sc_hd__fill_1
XFILLER_27_464 VGND VGND VPWR VPWR sky130_fd_sc_hd__fill_2
XFILLER_36_77 VGND VGND VPWR VPWR sky130_fd_sc_hd__decap_6
X_12690_ net461 net453 net380 VGND VGND VPWR VPWR _05497_ sky130_fd_sc_hd__and3_1
XFILLER_42_445 VGND VGND VPWR VPWR sky130_fd_sc_hd__decap_8
XFILLER_14_125 VGND VGND VPWR VPWR sky130_fd_sc_hd__decap_8
XFILLER_42_489 VGND VGND VPWR VPWR sky130_fd_sc_hd__decap_4
XTAP_TAPCELL_ROW_25_665 VGND VPWR sky130_fd_sc_hd__tapvpwrvgnd_1
X_11641_ _03457_ _04354_ VGND VGND VPWR VPWR _04355_ sky130_fd_sc_hd__xnor2_1
XFILLER_52_65 VPWR VGND VPWR VGND sky130_ef_sc_hd__decap_12
XFILLER_11_821 VGND VGND VPWR VPWR sky130_fd_sc_hd__decap_3
X_11572_ _04102_ _04146_ _04144_ VGND VGND VPWR VPWR _04280_ sky130_fd_sc_hd__a21oi_1
X_13311_ _06165_ _06173_ VGND VGND VPWR VPWR _00029_ sky130_fd_sc_hd__xnor2_1
Xinput19 w02[1] VGND VGND VPWR VPWR net19 sky130_fd_sc_hd__clkbuf_2
X_10523_ net426 net283 net282 net435 VGND VGND VPWR VPWR _03134_ sky130_fd_sc_hd__a22oi_1
XFILLER_124_701 VGND VGND VPWR VPWR sky130_fd_sc_hd__fill_2
X_13242_ _06098_ _06075_ VGND VGND VPWR VPWR _06099_ sky130_fd_sc_hd__and2b_1
X_10454_ _03055_ _03057_ _03058_ VGND VGND VPWR VPWR _03059_ sky130_fd_sc_hd__nand3_2
XFILLER_109_797 VPWR VGND VPWR VGND sky130_ef_sc_hd__decap_12
X_13173_ _06022_ _06023_ VGND VGND VPWR VPWR _06024_ sky130_fd_sc_hd__nor2_1
XTAP_TAPCELL_ROW_94_1656 VGND VPWR sky130_fd_sc_hd__tapvpwrvgnd_1
X_10385_ net632 net623 net327 net326 VGND VGND VPWR VPWR _02983_ sky130_fd_sc_hd__and4_1
XTAP_TAPCELL_ROW_94_1667 VGND VPWR sky130_fd_sc_hd__tapvpwrvgnd_1
X_12124_ net470 net384 _04876_ _04877_ VGND VGND VPWR VPWR _04878_ sky130_fd_sc_hd__nand4_1
XFILLER_123_288 VGND VGND VPWR VPWR sky130_fd_sc_hd__fill_2
X_12055_ _04743_ _04795_ VGND VGND VPWR VPWR _04802_ sky130_fd_sc_hd__xor2_1
X_11006_ _03654_ _03661_ VGND VGND VPWR VPWR _03662_ sky130_fd_sc_hd__xor2_1
XTAP_TAPCELL_ROW_125_2111 VGND VPWR sky130_fd_sc_hd__tapvpwrvgnd_1
XFILLER_77_397 VGND VGND VPWR VPWR sky130_fd_sc_hd__fill_1
XFILLER_65_559 VGND VGND VPWR VPWR sky130_fd_sc_hd__fill_1
X_12957_ net495 net396 VGND VGND VPWR VPWR _05787_ sky130_fd_sc_hd__and2_1
XFILLER_80_529 VGND VGND VPWR VPWR sky130_fd_sc_hd__decap_3
X_12888_ _05709_ _05710_ VGND VGND VPWR VPWR _05713_ sky130_fd_sc_hd__xnor2_1
XTAP_TAPCELL_ROW_44_941 VGND VPWR sky130_fd_sc_hd__tapvpwrvgnd_1
XTAP_TAPCELL_ROW_44_930 VGND VPWR sky130_fd_sc_hd__tapvpwrvgnd_1
X_11908_ _04595_ _04598_ VGND VGND VPWR VPWR _04646_ sky130_fd_sc_hd__nor2_1
X_11839_ _04562_ _04570_ VGND VGND VPWR VPWR _04571_ sky130_fd_sc_hd__xnor2_1
XFILLER_21_607 VGND VGND VPWR VPWR sky130_fd_sc_hd__decap_8
XFILLER_21_629 VPWR VGND VPWR VGND sky130_ef_sc_hd__decap_12
XTAP_TAPCELL_ROW_103_1796 VGND VPWR sky130_fd_sc_hd__tapvpwrvgnd_1
XFILLER_14_670 VGND VGND VPWR VPWR sky130_fd_sc_hd__decap_3
XFILLER_13_180 VGND VGND VPWR VPWR sky130_fd_sc_hd__decap_3
X_13509_ _06358_ _06390_ VGND VGND VPWR VPWR _06391_ sky130_fd_sc_hd__nand2b_1
XTAP_TAPCELL_ROW_136_2273 VGND VPWR sky130_fd_sc_hd__tapvpwrvgnd_1
XFILLER_127_561 VPWR VGND VPWR VGND sky130_ef_sc_hd__decap_12
X_07030_ _01987_ _03587_ _03653_ VGND VGND VPWR VPWR _03664_ sky130_fd_sc_hd__nand3_1
XFILLER_115_756 VGND VGND VPWR VPWR sky130_fd_sc_hd__decap_8
X_08981_ _01454_ _01455_ _01445_ VGND VGND VPWR VPWR _01457_ sky130_fd_sc_hd__a21o_1
XFILLER_87_128 VGND VGND VPWR VPWR sky130_fd_sc_hd__decap_6
X_07932_ _00407_ _00408_ VGND VGND VPWR VPWR _00410_ sky130_fd_sc_hd__xnor2_2
XFILLER_84_813 VGND VGND VPWR VPWR sky130_fd_sc_hd__decap_4
X_07863_ _00339_ _00340_ VGND VGND VPWR VPWR _00341_ sky130_fd_sc_hd__nor2_1
XFILLER_3_81 VPWR VGND VPWR VGND sky130_ef_sc_hd__decap_12
XFILLER_29_729 VPWR VGND VPWR VGND sky130_ef_sc_hd__decap_12
XFILLER_113_27 VPWR VGND VPWR VGND sky130_ef_sc_hd__decap_12
X_09602_ _01611_ _02133_ VGND VGND VPWR VPWR _02134_ sky130_fd_sc_hd__nor2_1
XFILLER_96_684 VPWR VGND VPWR VGND sky130_ef_sc_hd__decap_12
XFILLER_83_323 VGND VGND VPWR VPWR sky130_fd_sc_hd__fill_1
XTAP_TAPCELL_ROW_3_349 VGND VPWR sky130_fd_sc_hd__tapvpwrvgnd_1
XTAP_TAPCELL_ROW_3_338 VGND VPWR sky130_fd_sc_hd__tapvpwrvgnd_1
X_09533_ _01915_ _01917_ _01914_ VGND VGND VPWR VPWR _02058_ sky130_fd_sc_hd__a21o_1
X_07794_ _00272_ _00271_ VGND VGND VPWR VPWR _00273_ sky130_fd_sc_hd__and2b_1
XFILLER_24_401 VPWR VGND VPWR VGND sky130_ef_sc_hd__decap_12
X_09464_ net629 net621 net370 net368 VGND VGND VPWR VPWR _01983_ sky130_fd_sc_hd__and4_1
XTAP_TAPCELL_ROW_65_1246 VGND VPWR sky130_fd_sc_hd__tapvpwrvgnd_1
XTAP_TAPCELL_ROW_65_1235 VGND VPWR sky130_fd_sc_hd__tapvpwrvgnd_1
XFILLER_24_445 VGND VGND VPWR VPWR sky130_fd_sc_hd__decap_4
X_09395_ _01869_ _01906_ VGND VGND VPWR VPWR _01908_ sky130_fd_sc_hd__xnor2_1
X_08415_ _00687_ _00887_ VGND VGND VPWR VPWR _00889_ sky130_fd_sc_hd__xnor2_1
X_08346_ _00737_ _00749_ _00818_ VGND VGND VPWR VPWR _00820_ sky130_fd_sc_hd__and3_1
XFILLER_11_117 VGND VGND VPWR VPWR sky130_fd_sc_hd__decap_6
XTAP_TAPCELL_ROW_22_613 VGND VPWR sky130_fd_sc_hd__tapvpwrvgnd_1
XTAP_TAPCELL_ROW_22_624 VGND VPWR sky130_fd_sc_hd__tapvpwrvgnd_1
X_08277_ _00750_ _00751_ VGND VGND VPWR VPWR _00752_ sky130_fd_sc_hd__xnor2_1
XFILLER_20_673 VGND VGND VPWR VPWR sky130_fd_sc_hd__fill_1
XFILLER_138_57 VPWR VGND VPWR VGND sky130_ef_sc_hd__decap_12
XFILLER_106_701 VPWR VGND VPWR VGND sky130_ef_sc_hd__decap_12
X_07228_ net571 net697 _04373_ _04362_ VGND VGND VPWR VPWR _05821_ sky130_fd_sc_hd__a31o_1
XFILLER_118_572 VGND VGND VPWR VPWR sky130_fd_sc_hd__fill_1
XFILLER_105_211 VGND VGND VPWR VPWR sky130_fd_sc_hd__decap_3
X_07159_ _05024_ _05057_ VGND VGND VPWR VPWR _05068_ sky130_fd_sc_hd__xnor2_1
XFILLER_105_222 VGND VGND VPWR VPWR sky130_fd_sc_hd__fill_2
X_10170_ _02578_ _02752_ VGND VGND VPWR VPWR _02753_ sky130_fd_sc_hd__xnor2_1
XFILLER_133_586 VPWR VGND VPWR VGND sky130_ef_sc_hd__decap_12
XFILLER_79_629 VGND VGND VPWR VPWR sky130_fd_sc_hd__decap_6
XTAP_TAPCELL_ROW_76_1397 VGND VPWR sky130_fd_sc_hd__tapvpwrvgnd_1
XFILLER_121_748 VGND VGND VPWR VPWR sky130_fd_sc_hd__decap_8
XFILLER_78_128 VPWR VGND VPWR VGND sky130_ef_sc_hd__decap_12
XFILLER_59_331 VGND VGND VPWR VPWR sky130_fd_sc_hd__decap_4
XFILLER_87_673 VGND VGND VPWR VPWR sky130_fd_sc_hd__decap_8
XFILLER_74_301 VGND VGND VPWR VPWR sky130_fd_sc_hd__fill_1
XFILLER_47_515 VPWR VGND VPWR VGND sky130_ef_sc_hd__decap_12
XFILLER_90_805 VGND VGND VPWR VPWR sky130_fd_sc_hd__decap_6
XFILLER_62_507 VGND VGND VPWR VPWR sky130_fd_sc_hd__decap_6
X_12811_ net514 net506 net394 VGND VGND VPWR VPWR _05628_ sky130_fd_sc_hd__and3_1
XFILLER_74_389 VGND VGND VPWR VPWR sky130_fd_sc_hd__fill_1
XFILLER_15_401 VPWR VGND VPWR VGND sky130_ef_sc_hd__decap_12
XFILLER_103_93 VPWR VGND VPWR VGND sky130_ef_sc_hd__decap_12
X_12742_ _05550_ _05551_ _05451_ VGND VGND VPWR VPWR _05553_ sky130_fd_sc_hd__o21a_1
XFILLER_43_754 VPWR VGND VPWR VGND sky130_ef_sc_hd__decap_12
XTAP_TAPCELL_ROW_120_2041 VGND VPWR sky130_fd_sc_hd__tapvpwrvgnd_1
X_12673_ _05471_ _05477_ VGND VGND VPWR VPWR _05478_ sky130_fd_sc_hd__and2_1
XPHY_EDGE_ROW_69_Right_69 VGND VGND VPWR VPWR sky130_fd_sc_hd__decap_3
XFILLER_42_253 VGND VGND VPWR VPWR sky130_fd_sc_hd__decap_4
XTAP_TAPCELL_ROW_41_900 VGND VPWR sky130_fd_sc_hd__tapvpwrvgnd_1
XFILLER_8_15 VPWR VGND VPWR VGND sky130_ef_sc_hd__decap_12
X_11624_ _04196_ _04198_ VGND VGND VPWR VPWR _04336_ sky130_fd_sc_hd__nand2_1
XFILLER_30_415 VGND VGND VPWR VPWR sky130_fd_sc_hd__decap_4
XFILLER_7_633 VGND VGND VPWR VPWR sky130_fd_sc_hd__decap_4
XFILLER_11_673 VGND VGND VPWR VPWR sky130_fd_sc_hd__decap_8
X_11555_ _03964_ _04111_ VGND VGND VPWR VPWR _04261_ sky130_fd_sc_hd__nand2_1
X_11486_ _04184_ _04185_ VGND VGND VPWR VPWR _04186_ sky130_fd_sc_hd__nand2_1
XFILLER_10_194 VGND VGND VPWR VPWR sky130_fd_sc_hd__fill_2
X_10506_ _03112_ _03113_ _03114_ VGND VGND VPWR VPWR _03115_ sky130_fd_sc_hd__and3_1
XFILLER_109_561 VGND VGND VPWR VPWR sky130_fd_sc_hd__fill_1
X_13225_ net259 net397 VGND VGND VPWR VPWR _06080_ sky130_fd_sc_hd__nor2_1
X_10437_ _02849_ _02852_ _02848_ VGND VGND VPWR VPWR _03040_ sky130_fd_sc_hd__a21o_1
XFILLER_124_531 VGND VGND VPWR VPWR sky130_fd_sc_hd__fill_1
XPHY_EDGE_ROW_78_Right_78 VGND VGND VPWR VPWR sky130_fd_sc_hd__decap_3
XTAP_TAPCELL_ROW_131_2192 VGND VPWR sky130_fd_sc_hd__tapvpwrvgnd_1
XFILLER_112_726 VPWR VGND VPWR VGND sky130_ef_sc_hd__decap_12
X_13156_ _05842_ _05853_ _05852_ VGND VGND VPWR VPWR _06005_ sky130_fd_sc_hd__a21oi_1
X_10368_ net450 net279 net278 net458 VGND VGND VPWR VPWR _02965_ sky130_fd_sc_hd__a22o_1
XFILLER_111_225 VGND VGND VPWR VPWR sky130_fd_sc_hd__decap_4
X_13087_ _05893_ _05928_ VGND VGND VPWR VPWR _05929_ sky130_fd_sc_hd__and2b_1
XFILLER_88_83 VGND VGND VPWR VPWR sky130_fd_sc_hd__fill_1
X_12107_ net647 net369 net353 net656 VGND VGND VPWR VPWR _04859_ sky130_fd_sc_hd__a22o_1
XFILLER_2_371 VGND VGND VPWR VPWR sky130_fd_sc_hd__fill_2
X_10299_ net511 net503 net297 VGND VGND VPWR VPWR _02889_ sky130_fd_sc_hd__and3_1
X_12038_ _04780_ _04782_ VGND VGND VPWR VPWR _04784_ sky130_fd_sc_hd__and2b_1
XFILLER_66_813 VGND VGND VPWR VPWR sky130_fd_sc_hd__decap_6
XFILLER_66_802 VGND VGND VPWR VPWR sky130_fd_sc_hd__decap_8
XFILLER_77_183 VGND VGND VPWR VPWR sky130_fd_sc_hd__fill_2
XFILLER_38_515 VGND VGND VPWR VPWR sky130_fd_sc_hd__fill_1
XFILLER_93_654 VGND VGND VPWR VPWR sky130_fd_sc_hd__fill_1
XFILLER_38_559 VPWR VGND VPWR VGND sky130_ef_sc_hd__decap_12
XFILLER_53_529 VGND VGND VPWR VPWR sky130_fd_sc_hd__fill_1
XTAP_TAPCELL_ROW_105_1825 VGND VPWR sky130_fd_sc_hd__tapvpwrvgnd_1
XFILLER_92_197 VPWR VGND VPWR VGND sky130_ef_sc_hd__decap_12
XPHY_EDGE_ROW_87_Right_87 VGND VGND VPWR VPWR sky130_fd_sc_hd__decap_3
XFILLER_46_581 VGND VGND VPWR VPWR sky130_fd_sc_hd__fill_1
XFILLER_61_551 VGND VGND VPWR VPWR sky130_fd_sc_hd__fill_2
XTAP_TAPCELL_ROW_138_2313 VGND VPWR sky130_fd_sc_hd__tapvpwrvgnd_1
XTAP_TAPCELL_ROW_138_2302 VGND VPWR sky130_fd_sc_hd__tapvpwrvgnd_1
X_08200_ _00673_ _00674_ VGND VGND VPWR VPWR _00676_ sky130_fd_sc_hd__xnor2_2
XFILLER_33_275 VGND VGND VPWR VPWR sky130_fd_sc_hd__decap_4
X_09180_ _01569_ _01672_ VGND VGND VPWR VPWR _01674_ sky130_fd_sc_hd__xor2_1
XTAP_TAPCELL_ROW_60_1176 VGND VPWR sky130_fd_sc_hd__tapvpwrvgnd_1
XTAP_TAPCELL_ROW_60_1165 VGND VPWR sky130_fd_sc_hd__tapvpwrvgnd_1
X_08131_ _00506_ _00508_ _00505_ VGND VGND VPWR VPWR _00607_ sky130_fd_sc_hd__o21ba_1
X_08062_ _00537_ _00538_ VGND VGND VPWR VPWR _00539_ sky130_fd_sc_hd__nor2_1
XFILLER_134_317 VGND VGND VPWR VPWR sky130_fd_sc_hd__decap_3
XPHY_EDGE_ROW_96_Right_96 VGND VGND VPWR VPWR sky130_fd_sc_hd__decap_3
X_07013_ _03445_ _03456_ _03467_ VGND VGND VPWR VPWR _03478_ sky130_fd_sc_hd__nand3_1
XTAP_TAPCELL_ROW_116_1976 VGND VPWR sky130_fd_sc_hd__tapvpwrvgnd_1
XFILLER_108_27 VGND VGND VPWR VPWR sky130_fd_sc_hd__fill_1
XTAP_TAPCELL_ROW_8_419 VGND VPWR sky130_fd_sc_hd__tapvpwrvgnd_1
XTAP_TAPCELL_ROW_8_408 VGND VPWR sky130_fd_sc_hd__tapvpwrvgnd_1
XFILLER_1_809 VPWR VGND VPWR VGND sky130_ef_sc_hd__decap_12
XTAP_TAPCELL_ROW_116_1987 VGND VPWR sky130_fd_sc_hd__tapvpwrvgnd_1
XFILLER_115_553 VGND VGND VPWR VPWR sky130_fd_sc_hd__decap_6
XFILLER_103_726 VGND VGND VPWR VPWR sky130_fd_sc_hd__fill_2
XFILLER_88_404 VPWR VGND VPWR VGND sky130_ef_sc_hd__decap_12
X_08964_ _01436_ _01437_ VGND VGND VPWR VPWR _01438_ sky130_fd_sc_hd__nor2_1
XFILLER_124_15 VPWR VGND VPWR VGND sky130_ef_sc_hd__decap_12
X_07915_ _00258_ _00260_ VGND VGND VPWR VPWR _00393_ sky130_fd_sc_hd__nand2b_2
X_08895_ _01239_ _01244_ _01361_ _01362_ VGND VGND VPWR VPWR _01363_ sky130_fd_sc_hd__and4_1
XFILLER_96_470 VGND VGND VPWR VPWR sky130_fd_sc_hd__decap_6
XFILLER_69_673 VPWR VGND VPWR VGND sky130_ef_sc_hd__decap_12
XFILLER_110_280 VPWR VGND VPWR VGND sky130_ef_sc_hd__decap_12
XFILLER_72_805 VGND VGND VPWR VPWR sky130_fd_sc_hd__decap_6
X_07846_ _00318_ _00323_ VGND VGND VPWR VPWR _00324_ sky130_fd_sc_hd__and2_1
XPHY_EDGE_ROW_3_Left_142 VGND VGND VPWR VPWR sky130_fd_sc_hd__decap_3
XFILLER_29_559 VGND VGND VPWR VPWR sky130_fd_sc_hd__fill_1
XFILLER_84_687 VGND VGND VPWR VPWR sky130_fd_sc_hd__decap_6
X_07777_ _00253_ _00254_ net708 net610 VGND VGND VPWR VPWR _00256_ sky130_fd_sc_hd__and4bb_1
XFILLER_56_389 VGND VGND VPWR VPWR sky130_fd_sc_hd__decap_8
XFILLER_44_518 VPWR VGND VPWR VGND sky130_ef_sc_hd__decap_12
X_09516_ _02037_ _02038_ VGND VGND VPWR VPWR _02039_ sky130_fd_sc_hd__xnor2_1
XFILLER_71_337 VGND VGND VPWR VPWR sky130_fd_sc_hd__decap_6
XFILLER_17_57 VPWR VGND VPWR VGND sky130_ef_sc_hd__decap_12
X_09447_ _01790_ _01794_ VGND VGND VPWR VPWR _01964_ sky130_fd_sc_hd__nand2_1
XFILLER_24_253 VPWR VGND VPWR VGND sky130_ef_sc_hd__decap_12
XFILLER_40_713 VPWR VGND VPWR VGND sky130_ef_sc_hd__decap_12
X_09378_ _01752_ _01761_ _01760_ VGND VGND VPWR VPWR _01890_ sky130_fd_sc_hd__a21oi_1
XFILLER_40_757 VGND VGND VPWR VPWR sky130_fd_sc_hd__decap_3
XFILLER_138_645 VGND VGND VPWR VPWR sky130_fd_sc_hd__fill_2
XFILLER_138_623 VGND VGND VPWR VPWR sky130_fd_sc_hd__decap_3
XFILLER_137_111 VGND VGND VPWR VPWR sky130_fd_sc_hd__fill_1
X_08329_ _06658_ _00802_ VGND VGND VPWR VPWR _00803_ sky130_fd_sc_hd__nand2_1
XTAP_TAPCELL_ROW_78_1437 VGND VPWR sky130_fd_sc_hd__tapvpwrvgnd_1
XTAP_TAPCELL_ROW_78_1426 VGND VPWR sky130_fd_sc_hd__tapvpwrvgnd_1
XPHY_EDGE_ROW_49_Left_188 VGND VGND VPWR VPWR sky130_fd_sc_hd__decap_3
X_11340_ _03898_ _03912_ _03911_ VGND VGND VPWR VPWR _04027_ sky130_fd_sc_hd__o21a_1
XFILLER_137_177 VGND VGND VPWR VPWR sky130_fd_sc_hd__fill_1
XFILLER_116_3 VPWR VGND VPWR VGND sky130_ef_sc_hd__decap_12
X_13010_ net620 net303 net284 net629 VGND VGND VPWR VPWR _05846_ sky130_fd_sc_hd__a22o_1
X_11271_ _03808_ _03814_ _03813_ VGND VGND VPWR VPWR _03952_ sky130_fd_sc_hd__o21ai_1
XTAP_TAPCELL_ROW_91_1615 VGND VPWR sky130_fd_sc_hd__tapvpwrvgnd_1
XFILLER_3_146 VGND VGND VPWR VPWR sky130_fd_sc_hd__decap_3
X_10222_ net654 net643 net328 net325 VGND VGND VPWR VPWR _02806_ sky130_fd_sc_hd__and4_1
X_10153_ _02732_ _02733_ VGND VGND VPWR VPWR _02734_ sky130_fd_sc_hd__nand2_1
XFILLER_94_418 VGND VGND VPWR VPWR sky130_fd_sc_hd__fill_2
XFILLER_66_109 VGND VGND VPWR VPWR sky130_fd_sc_hd__decap_4
XFILLER_58_53 VPWR VGND VPWR VGND sky130_ef_sc_hd__decap_12
X_10084_ _02473_ _02481_ _02480_ VGND VGND VPWR VPWR _02659_ sky130_fd_sc_hd__a21o_1
XFILLER_102_781 VPWR VGND VPWR VGND sky130_ef_sc_hd__decap_12
XFILLER_94_429 VGND VGND VPWR VPWR sky130_fd_sc_hd__decap_3
XPHY_EDGE_ROW_58_Left_197 VGND VGND VPWR VPWR sky130_fd_sc_hd__decap_3
XFILLER_48_813 VGND VGND VPWR VPWR sky130_fd_sc_hd__decap_8
XFILLER_75_643 VGND VGND VPWR VPWR sky130_fd_sc_hd__decap_3
XTAP_TAPCELL_ROW_89_1588 VGND VPWR sky130_fd_sc_hd__tapvpwrvgnd_1
XFILLER_74_41 VPWR VGND VPWR VGND sky130_ef_sc_hd__decap_12
XFILLER_35_529 VPWR VGND VPWR VGND sky130_ef_sc_hd__decap_12
XFILLER_74_85 VGND VGND VPWR VPWR sky130_fd_sc_hd__decap_6
XFILLER_16_732 VGND VGND VPWR VPWR sky130_fd_sc_hd__decap_8
XFILLER_28_581 VGND VGND VPWR VPWR sky130_fd_sc_hd__fill_1
X_10986_ net449 net273 net271 net457 VGND VGND VPWR VPWR _03640_ sky130_fd_sc_hd__a22o_1
X_12725_ _05532_ _05533_ _05526_ VGND VGND VPWR VPWR _05535_ sky130_fd_sc_hd__a21o_1
XFILLER_43_595 VPWR VGND VPWR VGND sky130_ef_sc_hd__decap_12
XTAP_TAPCELL_ROW_100_1744 VGND VPWR sky130_fd_sc_hd__tapvpwrvgnd_1
X_12656_ _05458_ VGND VGND VPWR VPWR _05459_ sky130_fd_sc_hd__inv_2
XFILLER_129_623 VPWR VGND VPWR VGND sky130_ef_sc_hd__decap_12
XTAP_TAPCELL_ROW_100_1755 VGND VPWR sky130_fd_sc_hd__tapvpwrvgnd_1
X_12587_ _05223_ _05382_ VGND VGND VPWR VPWR _05384_ sky130_fd_sc_hd__xnor2_1
X_11607_ _04315_ _04316_ VGND VGND VPWR VPWR _04317_ sky130_fd_sc_hd__and2_1
XFILLER_11_492 VGND VGND VPWR VPWR sky130_fd_sc_hd__decap_6
XTAP_TAPCELL_ROW_13_487 VGND VPWR sky130_fd_sc_hd__tapvpwrvgnd_1
XTAP_TAPCELL_ROW_133_2232 VGND VPWR sky130_fd_sc_hd__tapvpwrvgnd_1
XTAP_TAPCELL_ROW_133_2221 VGND VPWR sky130_fd_sc_hd__tapvpwrvgnd_1
XFILLER_129_689 VGND VGND VPWR VPWR sky130_fd_sc_hd__decap_6
X_11538_ _03982_ _04121_ _03836_ VGND VGND VPWR VPWR _04243_ sky130_fd_sc_hd__o21ai_1
XFILLER_116_339 VGND VGND VPWR VPWR sky130_fd_sc_hd__decap_8
X_11469_ _04063_ _04065_ _04167_ VGND VGND VPWR VPWR _04168_ sky130_fd_sc_hd__o21ba_1
XFILLER_99_93 VPWR VGND VPWR VGND sky130_ef_sc_hd__decap_12
X_13208_ _06060_ _06052_ VGND VGND VPWR VPWR _06062_ sky130_fd_sc_hd__nand2b_1
XFILLER_98_757 VPWR VGND VPWR VGND sky130_ef_sc_hd__decap_12
X_13139_ net613 net303 VGND VGND VPWR VPWR _05987_ sky130_fd_sc_hd__nand2_1
XFILLER_31_3 VPWR VGND VPWR VGND sky130_ef_sc_hd__decap_12
XFILLER_97_245 VGND VGND VPWR VPWR sky130_fd_sc_hd__decap_8
XFILLER_2_190 VGND VGND VPWR VPWR sky130_fd_sc_hd__fill_1
XFILLER_66_621 VGND VGND VPWR VPWR sky130_fd_sc_hd__fill_1
X_07700_ _00170_ _00177_ VGND VGND VPWR VPWR _00179_ sky130_fd_sc_hd__xor2_1
X_08680_ _01145_ _01146_ VGND VGND VPWR VPWR _01147_ sky130_fd_sc_hd__and2b_1
X_07631_ _00102_ _00109_ _00110_ VGND VGND VPWR VPWR _00111_ sky130_fd_sc_hd__nand3_1
XTAP_TAPCELL_ROW_49_1016 VGND VPWR sky130_fd_sc_hd__tapvpwrvgnd_1
XTAP_TAPCELL_ROW_49_1005 VGND VPWR sky130_fd_sc_hd__tapvpwrvgnd_1
XFILLER_38_356 VGND VGND VPWR VPWR sky130_fd_sc_hd__decap_3
XFILLER_65_197 VGND VGND VPWR VPWR sky130_fd_sc_hd__decap_6
XFILLER_53_337 VGND VGND VPWR VPWR sky130_fd_sc_hd__fill_1
X_07562_ _06789_ _06790_ VGND VGND VPWR VPWR _06791_ sky130_fd_sc_hd__and2b_1
X_09301_ _01644_ _01646_ VGND VGND VPWR VPWR _01806_ sky130_fd_sc_hd__nor2_1
XTAP_TAPCELL_ROW_62_1205 VGND VPWR sky130_fd_sc_hd__tapvpwrvgnd_1
XFILLER_61_381 VGND VGND VPWR VPWR sky130_fd_sc_hd__decap_8
X_07493_ _06575_ _06721_ VGND VGND VPWR VPWR _06723_ sky130_fd_sc_hd__xnor2_1
XFILLER_22_713 VGND VGND VPWR VPWR sky130_fd_sc_hd__decap_3
XFILLER_34_573 VGND VGND VPWR VPWR sky130_fd_sc_hd__fill_1
X_09232_ _01721_ _01727_ VGND VGND VPWR VPWR _01730_ sky130_fd_sc_hd__xor2_1
XFILLER_21_223 VGND VGND VPWR VPWR sky130_fd_sc_hd__fill_1
XFILLER_119_111 VGND VGND VPWR VPWR sky130_fd_sc_hd__fill_1
X_09163_ _01652_ _01653_ VGND VGND VPWR VPWR _01655_ sky130_fd_sc_hd__xor2_1
XTAP_TAPCELL_ROW_32_763 VGND VPWR sky130_fd_sc_hd__tapvpwrvgnd_1
XFILLER_119_15 VPWR VGND VPWR VGND sky130_ef_sc_hd__decap_12
X_08114_ _00587_ _00588_ VGND VGND VPWR VPWR _00590_ sky130_fd_sc_hd__xor2_1
XFILLER_135_637 VGND VGND VPWR VPWR sky130_fd_sc_hd__decap_8
X_09094_ _01577_ _01578_ VGND VGND VPWR VPWR _01580_ sky130_fd_sc_hd__xnor2_1
XFILLER_107_317 VGND VGND VPWR VPWR sky130_fd_sc_hd__decap_8
XFILLER_135_659 VGND VGND VPWR VPWR sky130_fd_sc_hd__fill_2
X_08045_ _00519_ _00520_ VGND VGND VPWR VPWR _00522_ sky130_fd_sc_hd__xor2_1
XFILLER_122_309 VGND VGND VPWR VPWR sky130_fd_sc_hd__decap_8
XFILLER_89_702 VGND VGND VPWR VPWR sky130_fd_sc_hd__decap_4
XFILLER_1_617 VGND VGND VPWR VPWR sky130_fd_sc_hd__fill_1
XFILLER_131_821 VGND VGND VPWR VPWR sky130_fd_sc_hd__decap_3
XFILLER_115_372 VPWR VGND VPWR VGND sky130_ef_sc_hd__decap_12
XTAP_TAPCELL_ROW_73_1356 VGND VPWR sky130_fd_sc_hd__tapvpwrvgnd_1
XFILLER_135_69 VPWR VGND VPWR VGND sky130_ef_sc_hd__decap_12
X_09996_ _02560_ _02561_ VGND VGND VPWR VPWR _02563_ sky130_fd_sc_hd__nand2_1
XFILLER_0_149 VGND VGND VPWR VPWR sky130_fd_sc_hd__fill_1
X_08947_ _01275_ _01277_ VGND VGND VPWR VPWR _01419_ sky130_fd_sc_hd__nand2_1
XFILLER_103_589 VGND VGND VPWR VPWR sky130_fd_sc_hd__decap_4
XFILLER_57_621 VPWR VGND VPWR VGND sky130_ef_sc_hd__decap_12
X_08878_ _01342_ _01341_ _01295_ VGND VGND VPWR VPWR _01345_ sky130_fd_sc_hd__or3_4
XFILLER_69_492 VPWR VGND VPWR VGND sky130_ef_sc_hd__decap_12
XFILLER_56_131 VGND VGND VPWR VPWR sky130_fd_sc_hd__decap_8
XFILLER_44_304 VGND VGND VPWR VPWR sky130_fd_sc_hd__decap_4
X_07829_ _00304_ _00305_ VGND VGND VPWR VPWR _00307_ sky130_fd_sc_hd__xnor2_1
XFILLER_56_197 VGND VGND VPWR VPWR sky130_fd_sc_hd__decap_8
X_10840_ net631 net70 net318 net636 VGND VGND VPWR VPWR _03481_ sky130_fd_sc_hd__a22o_1
XFILLER_71_167 VGND VGND VPWR VPWR sky130_fd_sc_hd__fill_1
XFILLER_60_819 VGND VGND VPWR VPWR sky130_fd_sc_hd__fill_1
XFILLER_44_77 VGND VGND VPWR VPWR sky130_fd_sc_hd__decap_6
X_10771_ _03091_ _03093_ _03236_ _03235_ _03225_ VGND VGND VPWR VPWR _03405_ sky130_fd_sc_hd__a32o_1
XFILLER_13_713 VGND VGND VPWR VPWR sky130_fd_sc_hd__fill_1
XFILLER_13_724 VGND VGND VPWR VPWR sky130_fd_sc_hd__fill_1
X_13490_ net247 _06251_ VGND VGND VPWR VPWR _06370_ sky130_fd_sc_hd__nor2_1
X_12510_ _05294_ _05298_ _05299_ VGND VGND VPWR VPWR _05300_ sky130_fd_sc_hd__and3_1
X_12441_ _05088_ _05107_ _05105_ VGND VGND VPWR VPWR _05224_ sky130_fd_sc_hd__o21bai_1
XFILLER_100_83 VGND VGND VPWR VPWR sky130_fd_sc_hd__fill_1
XFILLER_60_65 VGND VGND VPWR VPWR sky130_fd_sc_hd__decap_8
X_12372_ _05145_ _05148_ VGND VGND VPWR VPWR _05149_ sky130_fd_sc_hd__xnor2_1
XFILLER_4_400 VGND VGND VPWR VPWR sky130_fd_sc_hd__fill_1
XTAP_TAPCELL_ROW_10_446 VGND VPWR sky130_fd_sc_hd__tapvpwrvgnd_1
X_11323_ _04006_ _04007_ VGND VGND VPWR VPWR _04009_ sky130_fd_sc_hd__xnor2_1
XFILLER_5_27 VPWR VGND VPWR VGND sky130_ef_sc_hd__decap_12
XFILLER_4_477 VPWR VGND VPWR VGND sky130_ef_sc_hd__decap_12
X_11254_ _03925_ _03932_ VGND VGND VPWR VPWR _03933_ sky130_fd_sc_hd__xnor2_1
X_10205_ _02783_ _02789_ VGND VGND VPWR VPWR _02790_ sky130_fd_sc_hd__xnor2_1
XFILLER_122_821 VGND VGND VPWR VPWR sky130_fd_sc_hd__decap_3
XFILLER_106_361 VGND VGND VPWR VPWR sky130_fd_sc_hd__decap_3
XFILLER_79_212 VGND VGND VPWR VPWR sky130_fd_sc_hd__decap_6
XFILLER_133_191 VPWR VGND VPWR VGND sky130_ef_sc_hd__decap_12
XPHY_EDGE_ROW_66_Left_205 VGND VGND VPWR VPWR sky130_fd_sc_hd__decap_3
X_11185_ _03761_ _03857_ VGND VGND VPWR VPWR _03858_ sky130_fd_sc_hd__xnor2_1
X_10136_ _02711_ _02712_ VGND VGND VPWR VPWR _02715_ sky130_fd_sc_hd__xnor2_1
X_10067_ _02463_ _02467_ _02333_ VGND VGND VPWR VPWR _02640_ sky130_fd_sc_hd__a21bo_1
XFILLER_94_259 VGND VGND VPWR VPWR sky130_fd_sc_hd__fill_1
XFILLER_85_51 VGND VGND VPWR VPWR sky130_fd_sc_hd__decap_4
XFILLER_48_643 VGND VGND VPWR VPWR sky130_fd_sc_hd__fill_1
XFILLER_85_73 VGND VGND VPWR VPWR sky130_fd_sc_hd__fill_1
XFILLER_47_164 VGND VGND VPWR VPWR sky130_fd_sc_hd__fill_1
XFILLER_36_805 VGND VGND VPWR VPWR sky130_fd_sc_hd__decap_6
XFILLER_47_197 VGND VGND VPWR VPWR sky130_fd_sc_hd__fill_1
XFILLER_35_326 VGND VGND VPWR VPWR sky130_fd_sc_hd__decap_8
XFILLER_35_337 VPWR VGND VPWR VGND sky130_ef_sc_hd__decap_12
XTAP_TAPCELL_ROW_18_557 VGND VPWR sky130_fd_sc_hd__tapvpwrvgnd_1
XFILLER_16_584 VGND VGND VPWR VPWR sky130_fd_sc_hd__decap_4
X_10969_ _03612_ _03621_ VGND VGND VPWR VPWR _03622_ sky130_fd_sc_hd__xor2_1
XPHY_EDGE_ROW_75_Left_214 VGND VGND VPWR VPWR sky130_fd_sc_hd__decap_3
X_12708_ _05316_ _05515_ VGND VGND VPWR VPWR _05517_ sky130_fd_sc_hd__nor2_1
X_13688_ clknet_3_3__leaf_clk _00040_ net713 VGND VGND VPWR VPWR net223 sky130_fd_sc_hd__dfrtp_1
X_12639_ _05426_ _05438_ VGND VGND VPWR VPWR _05441_ sky130_fd_sc_hd__xnor2_1
XFILLER_12_790 VPWR VGND VPWR VGND sky130_ef_sc_hd__decap_12
XFILLER_117_615 VGND VGND VPWR VPWR sky130_fd_sc_hd__fill_1
XFILLER_116_103 VGND VGND VPWR VPWR sky130_fd_sc_hd__fill_1
XFILLER_132_618 VGND VGND VPWR VPWR sky130_fd_sc_hd__fill_2
XFILLER_125_670 VGND VGND VPWR VPWR sky130_fd_sc_hd__fill_2
XFILLER_113_821 VGND VGND VPWR VPWR sky130_fd_sc_hd__decap_3
XTAP_TAPCELL_ROW_113_1935 VGND VPWR sky130_fd_sc_hd__tapvpwrvgnd_1
XPHY_EDGE_ROW_84_Left_223 VGND VGND VPWR VPWR sky130_fd_sc_hd__decap_3
X_09850_ _02397_ _02403_ VGND VGND VPWR VPWR _02405_ sky130_fd_sc_hd__xor2_1
Xfanout718 net719 VGND VGND VPWR VPWR net718 sky130_fd_sc_hd__clkbuf_4
Xfanout707 net103 VGND VGND VPWR VPWR net707 sky130_fd_sc_hd__clkbuf_2
X_09781_ _02327_ _02328_ VGND VGND VPWR VPWR _02329_ sky130_fd_sc_hd__nor2_1
X_08801_ _01140_ _01266_ VGND VGND VPWR VPWR _01267_ sky130_fd_sc_hd__and2_1
XFILLER_105_39 VPWR VGND VPWR VGND sky130_ef_sc_hd__decap_12
XFILLER_100_504 VGND VGND VPWR VPWR sky130_fd_sc_hd__fill_2
X_06993_ net122 net435 _03248_ VGND VGND VPWR VPWR _03259_ sky130_fd_sc_hd__and3_1
XFILLER_58_418 VGND VGND VPWR VPWR sky130_fd_sc_hd__fill_2
XTAP_TAPCELL_ROW_55_1097 VGND VPWR sky130_fd_sc_hd__tapvpwrvgnd_1
X_08732_ _01198_ VGND VGND VPWR VPWR _01199_ sky130_fd_sc_hd__inv_2
X_08663_ _01079_ _01129_ VGND VGND VPWR VPWR _01130_ sky130_fd_sc_hd__and2_1
XFILLER_93_281 VGND VGND VPWR VPWR sky130_fd_sc_hd__fill_2
XFILLER_53_123 VGND VGND VPWR VPWR sky130_fd_sc_hd__fill_1
XTAP_TAPCELL_ROW_37_833 VGND VPWR sky130_fd_sc_hd__tapvpwrvgnd_1
XFILLER_38_197 VGND VGND VPWR VPWR sky130_fd_sc_hd__decap_3
XFILLER_39_698 VGND VGND VPWR VPWR sky130_fd_sc_hd__decap_4
X_08594_ _01061_ VGND VGND VPWR VPWR _01062_ sky130_fd_sc_hd__inv_2
XFILLER_121_27 VPWR VGND VPWR VGND sky130_ef_sc_hd__decap_12
X_07614_ _06658_ _00092_ VGND VGND VPWR VPWR _00094_ sky130_fd_sc_hd__xnor2_1
XFILLER_42_819 VGND VGND VPWR VPWR sky130_fd_sc_hd__fill_1
XPHY_EDGE_ROW_138_Right_138 VGND VGND VPWR VPWR sky130_fd_sc_hd__decap_3
XPHY_EDGE_ROW_93_Left_232 VGND VGND VPWR VPWR sky130_fd_sc_hd__decap_3
X_07545_ _06758_ _06773_ VGND VGND VPWR VPWR _06774_ sky130_fd_sc_hd__xor2_1
X_07476_ _06703_ _06704_ VGND VGND VPWR VPWR _06706_ sky130_fd_sc_hd__xnor2_1
X_09215_ _01699_ _01701_ _01710_ VGND VGND VPWR VPWR _01711_ sky130_fd_sc_hd__or3_1
XFILLER_22_587 VGND VGND VPWR VPWR sky130_fd_sc_hd__fill_1
X_09146_ net625 net373 _01634_ _01635_ VGND VGND VPWR VPWR _01636_ sky130_fd_sc_hd__a22o_1
X_09077_ _01559_ _01560_ VGND VGND VPWR VPWR _01561_ sky130_fd_sc_hd__nand2_1
XFILLER_135_456 VGND VGND VPWR VPWR sky130_fd_sc_hd__decap_8
XFILLER_100_6 VPWR VGND VPWR VGND sky130_ef_sc_hd__decap_12
X_08028_ net434 net425 net663 net661 VGND VGND VPWR VPWR _00505_ sky130_fd_sc_hd__and4_1
XFILLER_116_681 VGND VGND VPWR VPWR sky130_fd_sc_hd__decap_8
XFILLER_104_821 VGND VGND VPWR VPWR sky130_fd_sc_hd__decap_3
XFILLER_131_673 VGND VGND VPWR VPWR sky130_fd_sc_hd__fill_1
X_09979_ _02536_ _02544_ VGND VGND VPWR VPWR _02545_ sky130_fd_sc_hd__xnor2_1
XFILLER_39_55 VGND VGND VPWR VPWR sky130_fd_sc_hd__fill_1
XFILLER_130_172 VPWR VGND VPWR VGND sky130_ef_sc_hd__decap_12
X_12990_ net445 net380 VGND VGND VPWR VPWR _05824_ sky130_fd_sc_hd__nand2_1
XFILLER_18_805 VGND VGND VPWR VPWR sky130_fd_sc_hd__decap_6
XFILLER_29_142 VGND VGND VPWR VPWR sky130_fd_sc_hd__decap_8
XTAP_TAPCELL_ROW_86_1547 VGND VPWR sky130_fd_sc_hd__tapvpwrvgnd_1
X_11941_ _04663_ _04677_ VGND VGND VPWR VPWR _04679_ sky130_fd_sc_hd__xnor2_1
XFILLER_72_421 VGND VGND VPWR VPWR sky130_fd_sc_hd__decap_8
XFILLER_55_43 VPWR VGND VPWR VGND sky130_ef_sc_hd__decap_12
XFILLER_17_315 VPWR VGND VPWR VGND sky130_ef_sc_hd__decap_12
XFILLER_29_197 VPWR VGND VPWR VGND sky130_ef_sc_hd__decap_12
XFILLER_44_134 VGND VGND VPWR VPWR sky130_fd_sc_hd__decap_6
X_11872_ _04524_ _04527_ _04606_ VGND VGND VPWR VPWR _04607_ sky130_fd_sc_hd__a21oi_1
XPHY_EDGE_ROW_105_Right_105 VGND VGND VPWR VPWR sky130_fd_sc_hd__decap_3
X_13611_ _06499_ _06500_ VGND VGND VPWR VPWR _06501_ sky130_fd_sc_hd__xnor2_1
XTAP_TAPCELL_ROW_15_516 VGND VPWR sky130_fd_sc_hd__tapvpwrvgnd_1
X_10823_ _03289_ _03461_ VGND VGND VPWR VPWR _03462_ sky130_fd_sc_hd__xor2_1
X_13542_ _05476_ _06338_ _06337_ VGND VGND VPWR VPWR _06426_ sky130_fd_sc_hd__o21a_1
XFILLER_71_31 VPWR VGND VPWR VGND sky130_ef_sc_hd__decap_12
XFILLER_60_649 VGND VGND VPWR VPWR sky130_fd_sc_hd__fill_1
XFILLER_53_690 VGND VGND VPWR VPWR sky130_fd_sc_hd__fill_1
XFILLER_25_381 VGND VGND VPWR VPWR sky130_fd_sc_hd__decap_8
XFILLER_9_525 VGND VGND VPWR VPWR sky130_fd_sc_hd__fill_1
XFILLER_9_503 VGND VGND VPWR VPWR sky130_fd_sc_hd__fill_1
X_10754_ _03376_ _03385_ VGND VGND VPWR VPWR _03386_ sky130_fd_sc_hd__xnor2_1
XTAP_TAPCELL_ROW_117_2002 VGND VPWR sky130_fd_sc_hd__tapvpwrvgnd_1
X_13473_ _06350_ _06331_ VGND VGND VPWR VPWR _06351_ sky130_fd_sc_hd__and2b_1
XFILLER_9_536 VGND VGND VPWR VPWR sky130_fd_sc_hd__decap_6
X_10685_ net611 net325 VGND VGND VPWR VPWR _03311_ sky130_fd_sc_hd__nand2_1
X_12424_ _05112_ _05204_ _05205_ VGND VGND VPWR VPWR _05206_ sky130_fd_sc_hd__nor3_1
XFILLER_138_294 VGND VGND VPWR VPWR sky130_fd_sc_hd__decap_3
X_12355_ _05128_ _05129_ _04999_ VGND VGND VPWR VPWR _05130_ sky130_fd_sc_hd__a21oi_1
XFILLER_5_753 VPWR VGND VPWR VGND sky130_ef_sc_hd__decap_12
X_11306_ _03988_ _03989_ VGND VGND VPWR VPWR _03990_ sky130_fd_sc_hd__and2b_1
XFILLER_114_629 VPWR VGND VPWR VGND sky130_ef_sc_hd__decap_12
XFILLER_113_106 VGND VGND VPWR VPWR sky130_fd_sc_hd__decap_6
X_12286_ _05051_ _05052_ _04900_ _04902_ VGND VGND VPWR VPWR _05055_ sky130_fd_sc_hd__a211oi_1
XFILLER_5_797 VPWR VGND VPWR VGND sky130_ef_sc_hd__decap_12
X_11237_ _03879_ _03913_ VGND VGND VPWR VPWR _03914_ sky130_fd_sc_hd__nand2b_1
XFILLER_110_813 VGND VGND VPWR VPWR sky130_fd_sc_hd__decap_8
XFILLER_67_215 VGND VGND VPWR VPWR sky130_fd_sc_hd__fill_1
X_11168_ _03835_ _03838_ VGND VGND VPWR VPWR _03840_ sky130_fd_sc_hd__xnor2_2
XTAP_TAPCELL_ROW_128_2153 VGND VPWR sky130_fd_sc_hd__tapvpwrvgnd_1
X_10119_ _02696_ _02694_ VGND VGND VPWR VPWR _02697_ sky130_fd_sc_hd__and2b_1
XFILLER_96_83 VGND VGND VPWR VPWR sky130_fd_sc_hd__fill_1
XFILLER_95_535 VGND VGND VPWR VPWR sky130_fd_sc_hd__decap_4
XFILLER_68_749 VGND VGND VPWR VPWR sky130_fd_sc_hd__decap_6
X_11099_ _03630_ _03650_ _03649_ VGND VGND VPWR VPWR _03764_ sky130_fd_sc_hd__o21ba_1
XFILLER_48_484 VGND VGND VPWR VPWR sky130_fd_sc_hd__decap_4
XFILLER_90_240 VGND VGND VPWR VPWR sky130_fd_sc_hd__fill_2
XFILLER_75_292 VGND VGND VPWR VPWR sky130_fd_sc_hd__decap_3
XFILLER_24_819 VGND VGND VPWR VPWR sky130_fd_sc_hd__fill_1
XFILLER_36_657 VPWR VGND VPWR VGND sky130_ef_sc_hd__decap_12
XFILLER_36_679 VPWR VGND VPWR VGND sky130_ef_sc_hd__decap_12
XFILLER_91_785 VPWR VGND VPWR VGND sky130_ef_sc_hd__decap_12
XFILLER_63_487 VGND VGND VPWR VPWR sky130_fd_sc_hd__fill_1
X_07330_ _06558_ _06559_ _05963_ VGND VGND VPWR VPWR _06561_ sky130_fd_sc_hd__o21a_1
X_09000_ _01474_ _01476_ _01477_ VGND VGND VPWR VPWR _01478_ sky130_fd_sc_hd__or3_1
X_07261_ _06149_ _06160_ _04838_ VGND VGND VPWR VPWR _06181_ sky130_fd_sc_hd__a21oi_1
XFILLER_31_384 VGND VGND VPWR VPWR sky130_fd_sc_hd__fill_1
XFILLER_129_261 VGND VGND VPWR VPWR sky130_fd_sc_hd__fill_1
X_07192_ _03992_ _04014_ _05395_ _05417_ VGND VGND VPWR VPWR _05428_ sky130_fd_sc_hd__a211oi_2
XTAP_TAPCELL_ROW_57_1126 VGND VPWR sky130_fd_sc_hd__tapvpwrvgnd_1
X_09902_ _02458_ _02459_ VGND VGND VPWR VPWR _02460_ sky130_fd_sc_hd__and2b_1
Xfanout515 net518 VGND VGND VPWR VPWR net515 sky130_fd_sc_hd__clkbuf_2
XFILLER_116_27 VGND VGND VPWR VPWR sky130_fd_sc_hd__fill_1
Xfanout504 net505 VGND VGND VPWR VPWR net504 sky130_fd_sc_hd__clkbuf_2
X_09833_ _02361_ _02385_ VGND VGND VPWR VPWR _02386_ sky130_fd_sc_hd__and2b_1
Xfanout548 net551 VGND VGND VPWR VPWR net548 sky130_fd_sc_hd__clkbuf_4
XFILLER_98_362 VGND VGND VPWR VPWR sky130_fd_sc_hd__fill_2
XTAP_TAPCELL_ROW_70_1315 VGND VPWR sky130_fd_sc_hd__tapvpwrvgnd_1
XFILLER_59_727 VGND VGND VPWR VPWR sky130_fd_sc_hd__fill_1
Xfanout526 net527 VGND VGND VPWR VPWR net526 sky130_fd_sc_hd__buf_2
Xfanout537 net543 VGND VGND VPWR VPWR net537 sky130_fd_sc_hd__clkbuf_4
XFILLER_113_695 VGND VGND VPWR VPWR sky130_fd_sc_hd__fill_1
Xfanout559 net142 VGND VGND VPWR VPWR net559 sky130_fd_sc_hd__clkbuf_4
XFILLER_132_15 VPWR VGND VPWR VGND sky130_ef_sc_hd__decap_12
X_09764_ _02308_ _02309_ VGND VGND VPWR VPWR _02311_ sky130_fd_sc_hd__xor2_2
XFILLER_74_708 VGND VGND VPWR VPWR sky130_fd_sc_hd__decap_8
X_06976_ _02997_ _03063_ VGND VGND VPWR VPWR _03074_ sky130_fd_sc_hd__xnor2_1
X_09695_ _02232_ _02234_ VGND VGND VPWR VPWR _02235_ sky130_fd_sc_hd__nor2_2
X_08715_ _01174_ _01180_ _01181_ VGND VGND VPWR VPWR _01182_ sky130_fd_sc_hd__and3_1
XFILLER_66_281 VPWR VGND VPWR VGND sky130_ef_sc_hd__decap_12
XFILLER_54_421 VGND VGND VPWR VPWR sky130_fd_sc_hd__decap_3
XFILLER_39_495 VGND VGND VPWR VPWR sky130_fd_sc_hd__decap_8
X_08646_ _01061_ _01064_ _01108_ VGND VGND VPWR VPWR _01113_ sky130_fd_sc_hd__nor3_1
XFILLER_54_454 VGND VGND VPWR VPWR sky130_fd_sc_hd__decap_3
XFILLER_81_251 VPWR VGND VPWR VGND sky130_ef_sc_hd__decap_12
XTAP_TAPCELL_ROW_68_1288 VGND VPWR sky130_fd_sc_hd__tapvpwrvgnd_1
XFILLER_42_638 VGND VGND VPWR VPWR sky130_fd_sc_hd__decap_6
XFILLER_14_318 VPWR VGND VPWR VGND sky130_ef_sc_hd__decap_12
X_08577_ _01043_ _01044_ VGND VGND VPWR VPWR _01045_ sky130_fd_sc_hd__nor2_1
XFILLER_25_57 VGND VGND VPWR VPWR sky130_fd_sc_hd__fill_2
XTAP_TAPCELL_ROW_81_1477 VGND VPWR sky130_fd_sc_hd__tapvpwrvgnd_1
X_07528_ _06740_ _06756_ VGND VGND VPWR VPWR _06757_ sky130_fd_sc_hd__xor2_1
X_07459_ net644 net104 _06687_ _06688_ VGND VGND VPWR VPWR _06689_ sky130_fd_sc_hd__o2bb2a_1
XFILLER_10_557 VGND VGND VPWR VPWR sky130_fd_sc_hd__decap_8
X_10470_ _03070_ _03076_ VGND VGND VPWR VPWR _00020_ sky130_fd_sc_hd__xor2_1
X_09129_ net607 net374 VGND VGND VPWR VPWR _01618_ sky130_fd_sc_hd__nand2_1
X_12140_ _04717_ _04843_ VGND VGND VPWR VPWR _04896_ sky130_fd_sc_hd__nor2_1
XTAP_TAPCELL_ROW_20_585 VGND VPWR sky130_fd_sc_hd__tapvpwrvgnd_1
XTAP_TAPCELL_ROW_20_596 VGND VPWR sky130_fd_sc_hd__tapvpwrvgnd_1
XFILLER_2_701 VGND VGND VPWR VPWR sky130_fd_sc_hd__decap_8
XFILLER_1_200 VGND VGND VPWR VPWR sky130_fd_sc_hd__fill_1
X_12071_ _04818_ _04819_ VGND VGND VPWR VPWR _04820_ sky130_fd_sc_hd__xor2_1
XFILLER_9_3 VPWR VGND VPWR VGND sky130_ef_sc_hd__decap_12
XFILLER_110_109 VGND VGND VPWR VPWR sky130_fd_sc_hd__decap_3
XFILLER_103_150 VGND VGND VPWR VPWR sky130_fd_sc_hd__fill_2
XFILLER_1_244 VGND VGND VPWR VPWR sky130_fd_sc_hd__fill_1
X_11022_ _03676_ _03677_ _03678_ VGND VGND VPWR VPWR _03680_ sky130_fd_sc_hd__a21o_1
XFILLER_77_535 VPWR VGND VPWR VGND sky130_ef_sc_hd__decap_12
XFILLER_49_237 VPWR VGND VPWR VGND sky130_ef_sc_hd__decap_12
XFILLER_1_288 VGND VGND VPWR VPWR sky130_fd_sc_hd__fill_2
XFILLER_66_53 VPWR VGND VPWR VGND sky130_ef_sc_hd__decap_12
X_12973_ _05796_ _05804_ VGND VGND VPWR VPWR _05805_ sky130_fd_sc_hd__xnor2_1
XFILLER_57_281 VGND VGND VPWR VPWR sky130_fd_sc_hd__decap_8
X_11924_ net657 net404 net393 net470 VGND VGND VPWR VPWR _04661_ sky130_fd_sc_hd__a22o_1
XFILLER_73_763 VPWR VGND VPWR VGND sky130_ef_sc_hd__decap_12
XTAP_TAPCELL_ROW_123_2083 VGND VPWR sky130_fd_sc_hd__tapvpwrvgnd_1
XFILLER_82_41 VPWR VGND VPWR VGND sky130_ef_sc_hd__decap_12
XFILLER_73_785 VPWR VGND VPWR VGND sky130_ef_sc_hd__decap_12
XFILLER_72_251 VGND VGND VPWR VPWR sky130_fd_sc_hd__fill_1
X_11855_ _04587_ VGND VGND VPWR VPWR _04588_ sky130_fd_sc_hd__inv_2
XFILLER_26_690 VGND VGND VPWR VPWR sky130_fd_sc_hd__decap_8
XFILLER_82_85 VPWR VGND VPWR VGND sky130_ef_sc_hd__decap_12
X_11786_ _04078_ _04389_ _04512_ VGND VGND VPWR VPWR _04513_ sky130_fd_sc_hd__o21a_1
X_10806_ _03267_ _03442_ VGND VGND VPWR VPWR _03443_ sky130_fd_sc_hd__xor2_1
X_13525_ _06163_ _06294_ _06174_ _06296_ VGND VGND VPWR VPWR _06408_ sky130_fd_sc_hd__o31ai_4
X_10737_ net537 net311 net76 net546 VGND VGND VPWR VPWR _03367_ sky130_fd_sc_hd__a22o_1
XFILLER_13_384 VGND VGND VPWR VPWR sky130_fd_sc_hd__fill_1
XTAP_TAPCELL_ROW_99_1738 VGND VPWR sky130_fd_sc_hd__tapvpwrvgnd_1
X_13456_ net259 net395 _06251_ _06252_ VGND VGND VPWR VPWR _06332_ sky130_fd_sc_hd__o22a_2
XFILLER_70_7 VPWR VGND VPWR VGND sky130_ef_sc_hd__decap_12
X_12407_ _05178_ _05185_ _05186_ VGND VGND VPWR VPWR _05187_ sky130_fd_sc_hd__nand3_1
X_10668_ _03288_ _03290_ _03291_ VGND VGND VPWR VPWR _03293_ sky130_fd_sc_hd__or3_1
X_13387_ _06076_ _06255_ VGND VGND VPWR VPWR _06257_ sky130_fd_sc_hd__nor2_1
X_10599_ _03216_ _03214_ VGND VGND VPWR VPWR _03217_ sky130_fd_sc_hd__nand2b_1
XFILLER_126_275 VGND VGND VPWR VPWR sky130_fd_sc_hd__fill_2
X_12338_ _05071_ _05109_ VGND VGND VPWR VPWR _05112_ sky130_fd_sc_hd__xor2_1
XFILLER_5_561 VGND VGND VPWR VPWR sky130_fd_sc_hd__decap_4
X_12269_ _05033_ _05034_ _05036_ VGND VGND VPWR VPWR _05037_ sky130_fd_sc_hd__and3_1
XFILLER_96_800 VPWR VGND VPWR VGND sky130_ef_sc_hd__decap_12
XFILLER_110_643 VGND VGND VPWR VPWR sky130_fd_sc_hd__fill_1
XFILLER_110_621 VGND VGND VPWR VPWR sky130_fd_sc_hd__decap_4
XTAP_TAPCELL_ROW_52_1056 VGND VPWR sky130_fd_sc_hd__tapvpwrvgnd_1
XFILLER_68_579 VGND VGND VPWR VPWR sky130_fd_sc_hd__decap_8
X_06830_ _01475_ VGND VGND VPWR VPWR _01486_ sky130_fd_sc_hd__inv_2
XFILLER_56_708 VPWR VGND VPWR VGND sky130_ef_sc_hd__decap_12
XFILLER_83_538 VGND VGND VPWR VPWR sky130_fd_sc_hd__decap_8
XTAP_TAPCELL_ROW_108_1867 VGND VPWR sky130_fd_sc_hd__tapvpwrvgnd_1
X_09480_ _01999_ _02000_ VGND VGND VPWR VPWR _02001_ sky130_fd_sc_hd__and2_1
X_08500_ _00933_ _00934_ _00932_ VGND VGND VPWR VPWR _00972_ sky130_fd_sc_hd__a21oi_1
XFILLER_36_421 VPWR VGND VPWR VGND sky130_ef_sc_hd__decap_12
XFILLER_102_29 VPWR VGND VPWR VGND sky130_ef_sc_hd__decap_12
X_08431_ _00903_ VGND VGND VPWR VPWR _00904_ sky130_fd_sc_hd__inv_2
XTAP_TAPCELL_ROW_47_983 VGND VPWR sky130_fd_sc_hd__tapvpwrvgnd_1
XFILLER_23_104 VGND VGND VPWR VPWR sky130_fd_sc_hd__decap_8
XFILLER_36_487 VGND VGND VPWR VPWR sky130_fd_sc_hd__decap_4
XFILLER_63_284 VGND VGND VPWR VPWR sky130_fd_sc_hd__decap_3
XFILLER_24_649 VGND VGND VPWR VPWR sky130_fd_sc_hd__decap_8
X_08362_ _00834_ _00835_ VGND VGND VPWR VPWR _00836_ sky130_fd_sc_hd__xor2_1
XFILLER_32_660 VGND VGND VPWR VPWR sky130_fd_sc_hd__fill_1
X_07313_ _06541_ _06542_ _06534_ VGND VGND VPWR VPWR _06544_ sky130_fd_sc_hd__a21o_1
X_08293_ _00762_ _00767_ VGND VGND VPWR VPWR _00768_ sky130_fd_sc_hd__nand2_1
XFILLER_20_811 VGND VGND VPWR VPWR sky130_fd_sc_hd__fill_1
X_07244_ _04569_ _05985_ VGND VGND VPWR VPWR _05996_ sky130_fd_sc_hd__nor2_1
XFILLER_11_15 VPWR VGND VPWR VGND sky130_ef_sc_hd__decap_12
XFILLER_127_15 VPWR VGND VPWR VGND sky130_ef_sc_hd__decap_12
XFILLER_117_231 VPWR VGND VPWR VGND sky130_ef_sc_hd__decap_12
X_07175_ _05013_ _05199_ _05220_ VGND VGND VPWR VPWR _05242_ sky130_fd_sc_hd__or3_1
XFILLER_118_787 VPWR VGND VPWR VGND sky130_ef_sc_hd__decap_12
XFILLER_132_245 VGND VGND VPWR VPWR sky130_fd_sc_hd__decap_6
XFILLER_87_19 VPWR VGND VPWR VGND sky130_ef_sc_hd__decap_12
XFILLER_132_256 VGND VGND VPWR VPWR sky130_fd_sc_hd__fill_2
Xfanout301 net80 VGND VGND VPWR VPWR net301 sky130_fd_sc_hd__buf_2
Xfanout312 net75 VGND VGND VPWR VPWR net312 sky130_fd_sc_hd__dlymetal6s2s_1
Xfanout323 net68 VGND VGND VPWR VPWR net323 sky130_fd_sc_hd__clkbuf_4
Xfanout356 net48 VGND VGND VPWR VPWR net356 sky130_fd_sc_hd__buf_2
Xfanout345 net56 VGND VGND VPWR VPWR net345 sky130_fd_sc_hd__clkbuf_2
XFILLER_113_470 VPWR VGND VPWR VGND sky130_ef_sc_hd__decap_12
Xfanout334 net62 VGND VGND VPWR VPWR net334 sky130_fd_sc_hd__clkbuf_2
XFILLER_101_632 VGND VGND VPWR VPWR sky130_fd_sc_hd__decap_8
X_09816_ net260 net346 VGND VGND VPWR VPWR _02367_ sky130_fd_sc_hd__nor2_1
Xfanout378 net34 VGND VGND VPWR VPWR net378 sky130_fd_sc_hd__buf_1
Xfanout367 net41 VGND VGND VPWR VPWR net367 sky130_fd_sc_hd__buf_2
XFILLER_101_654 VPWR VGND VPWR VGND sky130_ef_sc_hd__decap_12
Xfanout389 net28 VGND VGND VPWR VPWR net389 sky130_fd_sc_hd__clkbuf_4
XFILLER_47_719 VGND VGND VPWR VPWR sky130_fd_sc_hd__decap_8
X_09747_ _02283_ _02291_ VGND VGND VPWR VPWR _02292_ sky130_fd_sc_hd__xor2_2
XFILLER_100_153 VPWR VGND VPWR VGND sky130_ef_sc_hd__decap_12
XFILLER_74_549 VPWR VGND VPWR VGND sky130_ef_sc_hd__decap_12
XFILLER_27_410 VGND VGND VPWR VPWR sky130_fd_sc_hd__fill_1
X_06959_ _02802_ _02877_ VGND VGND VPWR VPWR _02887_ sky130_fd_sc_hd__nor2_1
XFILLER_100_197 VGND VGND VPWR VPWR sky130_fd_sc_hd__fill_1
XFILLER_55_752 VGND VGND VPWR VPWR sky130_fd_sc_hd__decap_4
XFILLER_55_741 VGND VGND VPWR VPWR sky130_fd_sc_hd__decap_3
X_09678_ _02214_ _02215_ VGND VGND VPWR VPWR _02217_ sky130_fd_sc_hd__or2_1
XTAP_TAPCELL_ROW_83_1506 VGND VPWR sky130_fd_sc_hd__tapvpwrvgnd_1
XFILLER_54_251 VGND VGND VPWR VPWR sky130_fd_sc_hd__fill_1
X_08629_ net595 net585 net359 net361 VGND VGND VPWR VPWR _01096_ sky130_fd_sc_hd__and4_1
XFILLER_70_755 VGND VGND VPWR VPWR sky130_fd_sc_hd__fill_1
XTAP_TAPCELL_ROW_25_655 VGND VPWR sky130_fd_sc_hd__tapvpwrvgnd_1
XTAP_TAPCELL_ROW_25_666 VGND VPWR sky130_fd_sc_hd__tapvpwrvgnd_1
X_11640_ _04352_ _04353_ VGND VGND VPWR VPWR _04354_ sky130_fd_sc_hd__nor2_1
X_11571_ _04239_ _04278_ VGND VGND VPWR VPWR _04279_ sky130_fd_sc_hd__xnor2_1
XFILLER_23_671 VGND VGND VPWR VPWR sky130_fd_sc_hd__fill_1
XFILLER_23_682 VGND VGND VPWR VPWR sky130_fd_sc_hd__fill_2
X_13310_ _06167_ _06172_ _06168_ _06165_ VGND VGND VPWR VPWR _06174_ sky130_fd_sc_hd__o31a_4
XFILLER_52_77 VGND VGND VPWR VPWR sky130_fd_sc_hd__decap_6
XFILLER_10_321 VPWR VGND VPWR VGND sky130_ef_sc_hd__decap_12
X_10522_ _03131_ _03132_ VGND VGND VPWR VPWR _03133_ sky130_fd_sc_hd__or2_1
XPHY_EDGE_ROW_30_Left_169 VGND VGND VPWR VPWR sky130_fd_sc_hd__decap_3
XFILLER_10_365 VPWR VGND VPWR VGND sky130_ef_sc_hd__decap_12
XFILLER_108_253 VPWR VGND VPWR VGND sky130_ef_sc_hd__decap_12
X_13241_ _06084_ _06097_ VGND VGND VPWR VPWR _06098_ sky130_fd_sc_hd__xnor2_1
XFILLER_6_347 VPWR VGND VPWR VGND sky130_ef_sc_hd__decap_12
X_10453_ _03047_ _03054_ _02856_ _02865_ VGND VGND VPWR VPWR _03058_ sky130_fd_sc_hd__o211ai_2
XFILLER_136_562 VGND VGND VPWR VPWR sky130_fd_sc_hd__decap_3
X_13172_ _05737_ _05871_ _05870_ VGND VGND VPWR VPWR _06023_ sky130_fd_sc_hd__a21oi_2
XTAP_TAPCELL_ROW_94_1657 VGND VPWR sky130_fd_sc_hd__tapvpwrvgnd_1
X_10384_ _02980_ _02981_ VGND VGND VPWR VPWR _02982_ sky130_fd_sc_hd__or2_1
XTAP_TAPCELL_ROW_94_1668 VGND VPWR sky130_fd_sc_hd__tapvpwrvgnd_1
X_12123_ _04865_ _04866_ _04874_ VGND VGND VPWR VPWR _04877_ sky130_fd_sc_hd__a21o_1
XFILLER_2_531 VGND VGND VPWR VPWR sky130_fd_sc_hd__fill_1
XFILLER_123_278 VGND VGND VPWR VPWR sky130_fd_sc_hd__fill_2
XFILLER_123_256 VGND VGND VPWR VPWR sky130_fd_sc_hd__fill_2
X_12054_ _04769_ _04800_ VGND VGND VPWR VPWR _04801_ sky130_fd_sc_hd__xor2_1
XFILLER_111_429 VPWR VGND VPWR VGND sky130_ef_sc_hd__decap_12
XFILLER_89_181 VPWR VGND VPWR VGND sky130_ef_sc_hd__decap_12
XFILLER_77_321 VGND VGND VPWR VPWR sky130_fd_sc_hd__fill_2
XFILLER_65_505 VGND VGND VPWR VPWR sky130_fd_sc_hd__decap_6
X_11005_ _03655_ _03659_ VGND VGND VPWR VPWR _03661_ sky130_fd_sc_hd__xnor2_1
XTAP_TAPCELL_ROW_125_2112 VGND VPWR sky130_fd_sc_hd__tapvpwrvgnd_1
XFILLER_65_527 VGND VGND VPWR VPWR sky130_fd_sc_hd__fill_1
XFILLER_93_51 VGND VGND VPWR VPWR sky130_fd_sc_hd__decap_4
XFILLER_46_741 VGND VGND VPWR VPWR sky130_fd_sc_hd__decap_6
XFILLER_46_730 VGND VGND VPWR VPWR sky130_fd_sc_hd__fill_2
XFILLER_18_421 VGND VGND VPWR VPWR sky130_fd_sc_hd__decap_3
X_12956_ net514 net506 net394 VGND VGND VPWR VPWR _05786_ sky130_fd_sc_hd__o21a_1
XFILLER_45_240 VGND VGND VPWR VPWR sky130_fd_sc_hd__decap_8
X_12887_ _05709_ _05710_ VGND VGND VPWR VPWR _05711_ sky130_fd_sc_hd__nand2b_1
XTAP_TAPCELL_ROW_44_942 VGND VPWR sky130_fd_sc_hd__tapvpwrvgnd_1
XTAP_TAPCELL_ROW_44_931 VGND VPWR sky130_fd_sc_hd__tapvpwrvgnd_1
X_11907_ _04636_ _04643_ VGND VGND VPWR VPWR _04644_ sky130_fd_sc_hd__xnor2_1
X_11838_ _04567_ _04568_ VGND VGND VPWR VPWR _04570_ sky130_fd_sc_hd__nor2_1
XTAP_TAPCELL_ROW_103_1797 VGND VPWR sky130_fd_sc_hd__tapvpwrvgnd_1
XTAP_TAPCELL_ROW_103_1786 VGND VPWR sky130_fd_sc_hd__tapvpwrvgnd_1
XFILLER_14_693 VGND VGND VPWR VPWR sky130_fd_sc_hd__fill_1
X_13508_ _06359_ _06387_ VGND VGND VPWR VPWR _06390_ sky130_fd_sc_hd__xnor2_1
XFILLER_9_141 VPWR VGND VPWR VGND sky130_ef_sc_hd__decap_12
X_11769_ _04491_ _04492_ VGND VGND VPWR VPWR _04495_ sky130_fd_sc_hd__xor2_1
XTAP_TAPCELL_ROW_136_2274 VGND VPWR sky130_fd_sc_hd__tapvpwrvgnd_1
X_13439_ _06218_ _06313_ VGND VGND VPWR VPWR _06314_ sky130_fd_sc_hd__and2_1
XFILLER_127_584 VGND VGND VPWR VPWR sky130_fd_sc_hd__decap_3
XFILLER_127_573 VGND VGND VPWR VPWR sky130_fd_sc_hd__decap_3
XFILLER_115_735 VGND VGND VPWR VPWR sky130_fd_sc_hd__fill_1
XFILLER_114_201 VGND VGND VPWR VPWR sky130_fd_sc_hd__fill_1
XFILLER_5_391 VGND VGND VPWR VPWR sky130_fd_sc_hd__fill_1
XFILLER_130_716 VGND VGND VPWR VPWR sky130_fd_sc_hd__decap_3
X_08980_ _01445_ _01454_ _01455_ VGND VGND VPWR VPWR _01456_ sky130_fd_sc_hd__nand3_1
XFILLER_68_321 VGND VGND VPWR VPWR sky130_fd_sc_hd__decap_6
X_07931_ _00407_ _00408_ VGND VGND VPWR VPWR _00409_ sky130_fd_sc_hd__and2b_1
XFILLER_96_652 VGND VGND VPWR VPWR sky130_fd_sc_hd__decap_8
XFILLER_84_803 VGND VGND VPWR VPWR sky130_fd_sc_hd__decap_8
XFILLER_68_365 VPWR VGND VPWR VGND sky130_ef_sc_hd__decap_12
XFILLER_56_505 VGND VGND VPWR VPWR sky130_fd_sc_hd__fill_1
X_07862_ net684 net258 _00337_ _00338_ VGND VGND VPWR VPWR _00340_ sky130_fd_sc_hd__nor4_1
XFILLER_110_462 VPWR VGND VPWR VGND sky130_ef_sc_hd__decap_12
X_09601_ _02131_ _02132_ VGND VGND VPWR VPWR _02133_ sky130_fd_sc_hd__xnor2_1
XFILLER_96_696 VGND VGND VPWR VPWR sky130_fd_sc_hd__decap_4
XTAP_TAPCELL_ROW_3_339 VGND VPWR sky130_fd_sc_hd__tapvpwrvgnd_1
XFILLER_3_93 VPWR VGND VPWR VGND sky130_ef_sc_hd__decap_12
XFILLER_28_229 VPWR VGND VPWR VGND sky130_ef_sc_hd__decap_12
X_09532_ _01722_ _01726_ VGND VGND VPWR VPWR _02057_ sky130_fd_sc_hd__or2_4
XFILLER_113_39 VPWR VGND VPWR VGND sky130_ef_sc_hd__decap_12
XFILLER_95_195 VGND VGND VPWR VPWR sky130_fd_sc_hd__fill_2
XFILLER_83_335 VGND VGND VPWR VPWR sky130_fd_sc_hd__fill_1
X_07793_ _00088_ _00120_ _00118_ VGND VGND VPWR VPWR _00272_ sky130_fd_sc_hd__a21oi_1
XFILLER_83_379 VPWR VGND VPWR VGND sky130_ef_sc_hd__decap_12
XFILLER_37_785 VPWR VGND VPWR VGND sky130_ef_sc_hd__decap_12
X_09463_ _01972_ _01981_ VGND VGND VPWR VPWR _01982_ sky130_fd_sc_hd__xor2_1
XTAP_TAPCELL_ROW_65_1247 VGND VPWR sky130_fd_sc_hd__tapvpwrvgnd_1
XTAP_TAPCELL_ROW_65_1236 VGND VPWR sky130_fd_sc_hd__tapvpwrvgnd_1
XFILLER_64_582 VGND VGND VPWR VPWR sky130_fd_sc_hd__decap_6
XFILLER_24_413 VGND VGND VPWR VPWR sky130_fd_sc_hd__decap_6
XFILLER_36_284 VPWR VGND VPWR VGND sky130_ef_sc_hd__decap_12
X_09394_ _01869_ _01906_ VGND VGND VPWR VPWR _01907_ sky130_fd_sc_hd__nand2_1
XFILLER_52_777 VPWR VGND VPWR VGND sky130_ef_sc_hd__decap_12
XFILLER_51_254 VPWR VGND VPWR VGND sky130_ef_sc_hd__decap_12
XFILLER_51_232 VGND VGND VPWR VPWR sky130_fd_sc_hd__decap_3
X_08414_ _00687_ _00887_ VGND VGND VPWR VPWR _00888_ sky130_fd_sc_hd__nand2_1
X_08345_ _00737_ _00749_ _00818_ VGND VGND VPWR VPWR _00819_ sky130_fd_sc_hd__a21oi_1
XTAP_TAPCELL_ROW_22_614 VGND VPWR sky130_fd_sc_hd__tapvpwrvgnd_1
XTAP_TAPCELL_ROW_22_625 VGND VPWR sky130_fd_sc_hd__tapvpwrvgnd_1
XFILLER_20_641 VGND VGND VPWR VPWR sky130_fd_sc_hd__decap_3
XFILLER_137_326 VGND VGND VPWR VPWR sky130_fd_sc_hd__decap_3
X_08276_ _00639_ _00640_ _00655_ VGND VGND VPWR VPWR _00751_ sky130_fd_sc_hd__o21a_1
XFILLER_20_663 VGND VGND VPWR VPWR sky130_fd_sc_hd__fill_1
X_07227_ _05788_ _05799_ VGND VGND VPWR VPWR _05810_ sky130_fd_sc_hd__xnor2_1
XFILLER_138_69 VPWR VGND VPWR VGND sky130_ef_sc_hd__decap_12
XFILLER_106_713 VPWR VGND VPWR VGND sky130_ef_sc_hd__decap_12
XFILLER_98_29 VPWR VGND VPWR VGND sky130_ef_sc_hd__decap_12
X_07158_ _05035_ _05046_ VGND VGND VPWR VPWR _05057_ sky130_fd_sc_hd__nor2_1
XFILLER_106_757 VPWR VGND VPWR VGND sky130_ef_sc_hd__decap_12
XFILLER_121_727 VGND VGND VPWR VPWR sky130_fd_sc_hd__fill_1
XFILLER_120_204 VPWR VGND VPWR VGND sky130_ef_sc_hd__decap_12
XTAP_TAPCELL_ROW_76_1398 VGND VPWR sky130_fd_sc_hd__tapvpwrvgnd_1
X_07089_ net703 net546 VGND VGND VPWR VPWR _04307_ sky130_fd_sc_hd__nand2_1
XFILLER_133_598 VGND VGND VPWR VPWR sky130_fd_sc_hd__fill_1
XFILLER_120_237 VGND VGND VPWR VPWR sky130_fd_sc_hd__fill_1
XFILLER_47_505 VGND VGND VPWR VPWR sky130_fd_sc_hd__decap_3
XFILLER_87_685 VPWR VGND VPWR VGND sky130_ef_sc_hd__decap_12
XFILLER_59_365 VGND VGND VPWR VPWR sky130_fd_sc_hd__decap_8
XFILLER_47_527 VGND VGND VPWR VPWR sky130_fd_sc_hd__fill_1
XFILLER_47_55 VGND VGND VPWR VPWR sky130_fd_sc_hd__fill_1
XFILLER_19_207 VPWR VGND VPWR VGND sky130_ef_sc_hd__decap_12
X_12810_ _05625_ _05626_ VGND VGND VPWR VPWR _05627_ sky130_fd_sc_hd__xnor2_1
XFILLER_27_262 VGND VGND VPWR VPWR sky130_fd_sc_hd__fill_1
X_12741_ _05451_ _05550_ _05551_ VGND VGND VPWR VPWR _05552_ sky130_fd_sc_hd__nor3_1
XFILLER_42_221 VPWR VGND VPWR VGND sky130_ef_sc_hd__decap_12
XFILLER_15_413 VGND VGND VPWR VPWR sky130_fd_sc_hd__decap_3
XFILLER_27_273 VGND VGND VPWR VPWR sky130_fd_sc_hd__decap_6
XFILLER_27_295 VGND VGND VPWR VPWR sky130_fd_sc_hd__decap_8
XTAP_TAPCELL_ROW_120_2042 VGND VPWR sky130_fd_sc_hd__tapvpwrvgnd_1
X_12672_ _05475_ _05476_ VGND VGND VPWR VPWR _05477_ sky130_fd_sc_hd__xnor2_1
XFILLER_43_766 VPWR VGND VPWR VGND sky130_ef_sc_hd__decap_12
X_11623_ _04333_ _04334_ VGND VGND VPWR VPWR _04335_ sky130_fd_sc_hd__or2_1
XFILLER_8_27 VGND VGND VPWR VPWR sky130_fd_sc_hd__fill_1
X_11554_ _04258_ _04259_ VGND VGND VPWR VPWR _04260_ sky130_fd_sc_hd__xnor2_1
X_11485_ _04032_ _04040_ _04183_ VGND VGND VPWR VPWR _04185_ sky130_fd_sc_hd__nand3_1
XFILLER_11_696 VPWR VGND VPWR VGND sky130_ef_sc_hd__decap_12
X_10505_ net494 net82 _02944_ _02889_ net296 VGND VGND VPWR VPWR _03114_ sky130_fd_sc_hd__a32o_1
XFILLER_136_370 VGND VGND VPWR VPWR sky130_fd_sc_hd__decap_8
X_13224_ _06077_ _06078_ VGND VGND VPWR VPWR _06079_ sky130_fd_sc_hd__nand2b_1
XFILLER_6_177 VGND VGND VPWR VPWR sky130_fd_sc_hd__decap_4
X_10436_ _03035_ _03036_ _02960_ VGND VGND VPWR VPWR _03039_ sky130_fd_sc_hd__o21ai_2
XTAP_TAPCELL_ROW_131_2193 VGND VPWR sky130_fd_sc_hd__tapvpwrvgnd_1
XFILLER_97_416 VGND VGND VPWR VPWR sky130_fd_sc_hd__decap_3
X_13155_ _05992_ _06003_ VGND VGND VPWR VPWR _06004_ sky130_fd_sc_hd__xnor2_2
X_10367_ net458 net450 net279 net278 VGND VGND VPWR VPWR _02963_ sky130_fd_sc_hd__and4_1
XFILLER_124_587 VGND VGND VPWR VPWR sky130_fd_sc_hd__fill_1
XFILLER_112_738 VPWR VGND VPWR VGND sky130_ef_sc_hd__decap_12
XFILLER_97_449 VPWR VGND VPWR VGND sky130_ef_sc_hd__decap_12
X_13086_ _05911_ _05927_ VGND VGND VPWR VPWR _05928_ sky130_fd_sc_hd__xnor2_1
X_12106_ net640 net387 VGND VGND VPWR VPWR _04858_ sky130_fd_sc_hd__and2_1
X_10298_ net503 net298 net297 net511 VGND VGND VPWR VPWR _02888_ sky130_fd_sc_hd__a22oi_1
X_12037_ net584 net679 net659 net594 VGND VGND VPWR VPWR _04782_ sky130_fd_sc_hd__a22o_1
XFILLER_65_313 VGND VGND VPWR VPWR sky130_fd_sc_hd__fill_2
XFILLER_92_132 VGND VGND VPWR VPWR sky130_fd_sc_hd__fill_1
XFILLER_65_357 VGND VGND VPWR VPWR sky130_fd_sc_hd__fill_1
XFILLER_18_251 VGND VGND VPWR VPWR sky130_fd_sc_hd__fill_1
XFILLER_19_752 VPWR VGND VPWR VGND sky130_ef_sc_hd__decap_12
XFILLER_19_785 VPWR VGND VPWR VGND sky130_ef_sc_hd__decap_12
XTAP_TAPCELL_ROW_105_1826 VGND VPWR sky130_fd_sc_hd__tapvpwrvgnd_1
XTAP_TAPCELL_ROW_105_1815 VGND VPWR sky130_fd_sc_hd__tapvpwrvgnd_1
X_12939_ _05760_ _05765_ VGND VGND VPWR VPWR _05768_ sky130_fd_sc_hd__xor2_1
XFILLER_80_327 VGND VGND VPWR VPWR sky130_fd_sc_hd__decap_8
XFILLER_33_221 VGND VGND VPWR VPWR sky130_fd_sc_hd__decap_3
XTAP_TAPCELL_ROW_138_2314 VGND VPWR sky130_fd_sc_hd__tapvpwrvgnd_1
XTAP_TAPCELL_ROW_138_2303 VGND VPWR sky130_fd_sc_hd__tapvpwrvgnd_1
X_08130_ net667 _06801_ _06803_ _00489_ VGND VGND VPWR VPWR _00606_ sky130_fd_sc_hd__a2bb2o_1
XFILLER_21_449 VPWR VGND VPWR VGND sky130_ef_sc_hd__decap_12
XFILLER_119_337 VGND VGND VPWR VPWR sky130_fd_sc_hd__decap_4
XFILLER_119_326 VGND VGND VPWR VPWR sky130_fd_sc_hd__decap_8
XTAP_TAPCELL_ROW_60_1166 VGND VPWR sky130_fd_sc_hd__tapvpwrvgnd_1
XFILLER_119_348 VGND VGND VPWR VPWR sky130_fd_sc_hd__fill_1
X_08061_ _00382_ _00406_ _00405_ VGND VGND VPWR VPWR _00538_ sky130_fd_sc_hd__a21boi_2
X_07012_ net649 net100 net709 net655 VGND VGND VPWR VPWR _03467_ sky130_fd_sc_hd__a22o_1
XFILLER_127_381 VGND VGND VPWR VPWR sky130_fd_sc_hd__fill_1
XTAP_TAPCELL_ROW_116_1977 VGND VPWR sky130_fd_sc_hd__tapvpwrvgnd_1
XTAP_TAPCELL_ROW_8_409 VGND VPWR sky130_fd_sc_hd__tapvpwrvgnd_1
XTAP_TAPCELL_ROW_116_1988 VGND VPWR sky130_fd_sc_hd__tapvpwrvgnd_1
XFILLER_88_416 VGND VGND VPWR VPWR sky130_fd_sc_hd__decap_4
XFILLER_0_309 VGND VGND VPWR VPWR sky130_fd_sc_hd__decap_8
X_08963_ _01435_ _01407_ VGND VGND VPWR VPWR _01437_ sky130_fd_sc_hd__and2b_1
XFILLER_88_427 VGND VGND VPWR VPWR sky130_fd_sc_hd__decap_4
XFILLER_124_27 VGND VGND VPWR VPWR sky130_fd_sc_hd__fill_1
XFILLER_69_641 VPWR VGND VPWR VGND sky130_ef_sc_hd__decap_12
X_07914_ _00383_ _00391_ VGND VGND VPWR VPWR _00392_ sky130_fd_sc_hd__xor2_2
X_08894_ _01357_ _01358_ _01360_ VGND VGND VPWR VPWR _01362_ sky130_fd_sc_hd__a21o_1
XFILLER_69_685 VPWR VGND VPWR VGND sky130_ef_sc_hd__decap_12
XFILLER_29_505 VGND VGND VPWR VPWR sky130_fd_sc_hd__decap_8
XFILLER_110_292 VGND VGND VPWR VPWR sky130_fd_sc_hd__fill_1
XFILLER_68_195 VGND VGND VPWR VPWR sky130_fd_sc_hd__fill_1
X_07845_ net251 _00322_ VGND VGND VPWR VPWR _00323_ sky130_fd_sc_hd__xor2_1
X_07776_ net708 net610 _00253_ _00254_ VGND VGND VPWR VPWR _00255_ sky130_fd_sc_hd__o2bb2a_1
X_09515_ net548 net357 VGND VGND VPWR VPWR _02038_ sky130_fd_sc_hd__nand2_1
XFILLER_17_69 VGND VGND VPWR VPWR sky130_fd_sc_hd__decap_4
X_09446_ _01961_ _01962_ VGND VGND VPWR VPWR _01963_ sky130_fd_sc_hd__xor2_1
XFILLER_24_265 VGND VGND VPWR VPWR sky130_fd_sc_hd__decap_8
XFILLER_40_725 VPWR VGND VPWR VGND sky130_ef_sc_hd__decap_12
XFILLER_138_602 VGND VGND VPWR VPWR sky130_fd_sc_hd__decap_3
X_09377_ _01729_ _01731_ _01728_ VGND VGND VPWR VPWR _01888_ sky130_fd_sc_hd__a21o_1
XFILLER_33_57 VPWR VGND VPWR VGND sky130_ef_sc_hd__decap_12
X_08328_ net598 net603 net704 VGND VGND VPWR VPWR _00802_ sky130_fd_sc_hd__mux2_1
XFILLER_138_657 VGND VGND VPWR VPWR sky130_fd_sc_hd__decap_4
XTAP_TAPCELL_ROW_78_1427 VGND VPWR sky130_fd_sc_hd__tapvpwrvgnd_1
X_08259_ _00725_ _00732_ VGND VGND VPWR VPWR _00734_ sky130_fd_sc_hd__xnor2_1
XFILLER_137_189 VGND VGND VPWR VPWR sky130_fd_sc_hd__decap_8
XFILLER_137_167 VGND VGND VPWR VPWR sky130_fd_sc_hd__fill_1
XPHY_EDGE_ROW_104_Left_243 VGND VGND VPWR VPWR sky130_fd_sc_hd__decap_3
XFILLER_109_3 VPWR VGND VPWR VGND sky130_ef_sc_hd__decap_12
X_11270_ _03919_ _03950_ VGND VGND VPWR VPWR _03951_ sky130_fd_sc_hd__xor2_1
XTAP_TAPCELL_ROW_91_1616 VGND VPWR sky130_fd_sc_hd__tapvpwrvgnd_1
XFILLER_79_405 VPWR VGND VPWR VGND sky130_ef_sc_hd__decap_12
XFILLER_3_169 VGND VGND VPWR VPWR sky130_fd_sc_hd__decap_8
X_10221_ net643 net328 net325 net654 VGND VGND VPWR VPWR _02805_ sky130_fd_sc_hd__a22oi_1
XFILLER_133_373 VGND VGND VPWR VPWR sky130_fd_sc_hd__fill_1
X_10152_ _02730_ _02731_ _02720_ VGND VGND VPWR VPWR _02733_ sky130_fd_sc_hd__o21ai_1
XFILLER_106_598 VGND VGND VPWR VPWR sky130_fd_sc_hd__decap_6
XFILLER_106_587 VGND VGND VPWR VPWR sky130_fd_sc_hd__fill_1
XFILLER_79_449 VPWR VGND VPWR VGND sky130_ef_sc_hd__decap_12
XFILLER_0_821 VGND VGND VPWR VPWR sky130_fd_sc_hd__decap_3
X_10083_ _02647_ _02656_ VGND VGND VPWR VPWR _02658_ sky130_fd_sc_hd__xor2_1
XFILLER_58_65 VGND VGND VPWR VPWR sky130_fd_sc_hd__decap_8
XFILLER_47_313 VGND VGND VPWR VPWR sky130_fd_sc_hd__decap_6
XPHY_EDGE_ROW_113_Left_252 VGND VGND VPWR VPWR sky130_fd_sc_hd__decap_3
XFILLER_102_793 VPWR VGND VPWR VGND sky130_ef_sc_hd__decap_12
XFILLER_101_281 VPWR VGND VPWR VGND sky130_ef_sc_hd__decap_12
XFILLER_74_121 VPWR VGND VPWR VGND sky130_ef_sc_hd__decap_12
XFILLER_114_93 VPWR VGND VPWR VGND sky130_ef_sc_hd__decap_12
XTAP_TAPCELL_ROW_89_1589 VGND VPWR sky130_fd_sc_hd__tapvpwrvgnd_1
XFILLER_62_305 VGND VGND VPWR VPWR sky130_fd_sc_hd__decap_3
XFILLER_90_658 VGND VGND VPWR VPWR sky130_fd_sc_hd__fill_1
XFILLER_74_53 VPWR VGND VPWR VGND sky130_ef_sc_hd__decap_12
X_12724_ _05526_ _05532_ _05533_ VGND VGND VPWR VPWR _05534_ sky130_fd_sc_hd__nand3_1
XFILLER_16_755 VGND VGND VPWR VPWR sky130_fd_sc_hd__fill_1
X_10985_ net457 net449 net273 net271 VGND VGND VPWR VPWR _03639_ sky130_fd_sc_hd__nand4_1
XFILLER_90_41 VPWR VGND VPWR VGND sky130_ef_sc_hd__decap_12
X_12655_ _05456_ _05457_ VGND VGND VPWR VPWR _05458_ sky130_fd_sc_hd__xnor2_1
XFILLER_129_635 VGND VGND VPWR VPWR sky130_fd_sc_hd__fill_1
XFILLER_129_613 VGND VGND VPWR VPWR sky130_fd_sc_hd__decap_3
XPHY_EDGE_ROW_122_Left_261 VGND VGND VPWR VPWR sky130_fd_sc_hd__decap_3
XTAP_TAPCELL_ROW_100_1756 VGND VPWR sky130_fd_sc_hd__tapvpwrvgnd_1
XTAP_TAPCELL_ROW_100_1745 VGND VPWR sky130_fd_sc_hd__tapvpwrvgnd_1
X_12586_ _05223_ _05382_ VGND VGND VPWR VPWR _05383_ sky130_fd_sc_hd__and2_1
XFILLER_90_85 VGND VGND VPWR VPWR sky130_fd_sc_hd__decap_6
X_11606_ _04313_ _04314_ _04312_ VGND VGND VPWR VPWR _04316_ sky130_fd_sc_hd__o21ai_1
XTAP_TAPCELL_ROW_13_488 VGND VPWR sky130_fd_sc_hd__tapvpwrvgnd_1
X_11537_ _03982_ _04241_ VGND VGND VPWR VPWR _04242_ sky130_fd_sc_hd__xor2_1
XTAP_TAPCELL_ROW_133_2233 VGND VPWR sky130_fd_sc_hd__tapvpwrvgnd_1
XTAP_TAPCELL_ROW_133_2222 VGND VPWR sky130_fd_sc_hd__tapvpwrvgnd_1
XFILLER_109_370 VPWR VGND VPWR VGND sky130_ef_sc_hd__decap_12
X_11468_ _03890_ _04044_ _04043_ VGND VGND VPWR VPWR _04167_ sky130_fd_sc_hd__a21oi_1
XFILLER_98_714 VGND VGND VPWR VPWR sky130_fd_sc_hd__fill_1
X_13207_ _06053_ _06058_ VGND VGND VPWR VPWR _06060_ sky130_fd_sc_hd__xnor2_1
X_11399_ _04085_ _04089_ VGND VGND VPWR VPWR _04092_ sky130_fd_sc_hd__xnor2_1
X_10419_ _03017_ _03018_ _03016_ VGND VGND VPWR VPWR _03021_ sky130_fd_sc_hd__a21bo_1
X_13138_ _05983_ _05984_ VGND VGND VPWR VPWR _05986_ sky130_fd_sc_hd__nor2_1
XFILLER_98_769 VPWR VGND VPWR VGND sky130_ef_sc_hd__decap_12
XFILLER_39_803 VGND VGND VPWR VPWR sky130_fd_sc_hd__fill_1
XPHY_EDGE_ROW_131_Left_270 VGND VGND VPWR VPWR sky130_fd_sc_hd__decap_3
X_13069_ _05906_ _05907_ VGND VGND VPWR VPWR _05910_ sky130_fd_sc_hd__xnor2_1
XFILLER_97_279 VGND VGND VPWR VPWR sky130_fd_sc_hd__fill_1
XFILLER_24_3 VPWR VGND VPWR VGND sky130_ef_sc_hd__decap_12
XPHY_EDGE_ROW_119_Right_119 VGND VGND VPWR VPWR sky130_fd_sc_hd__decap_3
XFILLER_93_430 VGND VGND VPWR VPWR sky130_fd_sc_hd__fill_1
XFILLER_65_110 VGND VGND VPWR VPWR sky130_fd_sc_hd__fill_2
X_07630_ _00106_ _00107_ _00108_ VGND VGND VPWR VPWR _00110_ sky130_fd_sc_hd__a21o_1
XTAP_TAPCELL_ROW_49_1006 VGND VPWR sky130_fd_sc_hd__tapvpwrvgnd_1
X_07561_ net502 net119 net678 net513 VGND VGND VPWR VPWR _06790_ sky130_fd_sc_hd__a22o_1
X_09300_ _01634_ _01637_ VGND VGND VPWR VPWR _01805_ sky130_fd_sc_hd__nand2_1
XFILLER_80_157 VGND VGND VPWR VPWR sky130_fd_sc_hd__decap_4
XFILLER_110_29 VPWR VGND VPWR VGND sky130_ef_sc_hd__decap_12
X_07492_ _06575_ _06721_ VGND VGND VPWR VPWR _06722_ sky130_fd_sc_hd__and2_1
X_09231_ _01721_ _01727_ VGND VGND VPWR VPWR _01729_ sky130_fd_sc_hd__nand2b_1
X_09162_ _01652_ _01653_ VGND VGND VPWR VPWR _01654_ sky130_fd_sc_hd__and2b_1
XTAP_TAPCELL_ROW_32_764 VGND VPWR sky130_fd_sc_hd__tapvpwrvgnd_1
XFILLER_119_27 VPWR VGND VPWR VGND sky130_ef_sc_hd__decap_12
X_08113_ _00587_ _00588_ VGND VGND VPWR VPWR _00589_ sky130_fd_sc_hd__and2b_1
XFILLER_119_167 VGND VGND VPWR VPWR sky130_fd_sc_hd__fill_1
X_09093_ net421 net339 _01578_ VGND VGND VPWR VPWR _01579_ sky130_fd_sc_hd__and3_1
X_08044_ _00519_ _00520_ VGND VGND VPWR VPWR _00521_ sky130_fd_sc_hd__and2_1
XFILLER_135_15 VPWR VGND VPWR VGND sky130_ef_sc_hd__decap_12
XFILLER_115_384 VGND VGND VPWR VPWR sky130_fd_sc_hd__fill_2
XTAP_TAPCELL_ROW_73_1357 VGND VPWR sky130_fd_sc_hd__tapvpwrvgnd_1
X_09995_ _02560_ _02561_ VGND VGND VPWR VPWR _02562_ sky130_fd_sc_hd__nor2_1
XFILLER_103_557 VGND VGND VPWR VPWR sky130_fd_sc_hd__decap_3
XFILLER_88_257 VPWR VGND VPWR VGND sky130_ef_sc_hd__decap_12
XFILLER_76_408 VGND VGND VPWR VPWR sky130_fd_sc_hd__fill_1
X_08946_ _01416_ _01417_ VGND VGND VPWR VPWR _01418_ sky130_fd_sc_hd__and2_1
X_08877_ _01295_ _01341_ _01342_ VGND VGND VPWR VPWR _01343_ sky130_fd_sc_hd__nor3_1
XFILLER_57_633 VPWR VGND VPWR VGND sky130_ef_sc_hd__decap_12
XFILLER_45_817 VGND VGND VPWR VPWR sky130_fd_sc_hd__decap_3
X_07828_ _00304_ _00305_ VGND VGND VPWR VPWR _00306_ sky130_fd_sc_hd__and2b_1
XFILLER_56_187 VGND VGND VPWR VPWR sky130_fd_sc_hd__decap_8
XFILLER_44_327 VGND VGND VPWR VPWR sky130_fd_sc_hd__fill_1
X_07759_ _00235_ _00236_ VGND VGND VPWR VPWR _00238_ sky130_fd_sc_hd__xnor2_1
XFILLER_25_541 VPWR VGND VPWR VGND sky130_ef_sc_hd__decap_12
XFILLER_12_202 VGND VGND VPWR VPWR sky130_fd_sc_hd__decap_8
X_10770_ _03234_ _03403_ VGND VGND VPWR VPWR _03404_ sky130_fd_sc_hd__xor2_1
XFILLER_40_500 VGND VGND VPWR VPWR sky130_fd_sc_hd__decap_8
X_09429_ _01941_ _01942_ VGND VGND VPWR VPWR _01945_ sky130_fd_sc_hd__and2b_1
XFILLER_40_533 VGND VGND VPWR VPWR sky130_fd_sc_hd__fill_2
X_12440_ _05086_ _05221_ VGND VGND VPWR VPWR _05223_ sky130_fd_sc_hd__xnor2_1
XFILLER_138_454 VGND VGND VPWR VPWR sky130_fd_sc_hd__decap_4
XFILLER_138_421 VGND VGND VPWR VPWR sky130_fd_sc_hd__fill_2
XFILLER_8_228 VGND VGND VPWR VPWR sky130_fd_sc_hd__fill_1
X_12371_ _05146_ _05147_ VGND VGND VPWR VPWR _05148_ sky130_fd_sc_hd__and2b_1
XTAP_TAPCELL_ROW_10_447 VGND VPWR sky130_fd_sc_hd__tapvpwrvgnd_1
X_11322_ _04006_ _04007_ VGND VGND VPWR VPWR _04008_ sky130_fd_sc_hd__nand2b_1
XFILLER_69_31 VPWR VGND VPWR VGND sky130_ef_sc_hd__decap_12
XFILLER_5_39 VPWR VGND VPWR VGND sky130_ef_sc_hd__decap_12
X_11253_ _03929_ _03930_ VGND VGND VPWR VPWR _03932_ sky130_fd_sc_hd__xor2_1
X_10204_ _02784_ _02788_ VGND VGND VPWR VPWR _02789_ sky130_fd_sc_hd__xnor2_1
XFILLER_122_811 VGND VGND VPWR VPWR sky130_fd_sc_hd__fill_1
XFILLER_79_202 VGND VGND VPWR VPWR sky130_fd_sc_hd__decap_3
XFILLER_4_489 VGND VGND VPWR VPWR sky130_fd_sc_hd__decap_6
XFILLER_133_181 VGND VGND VPWR VPWR sky130_fd_sc_hd__decap_4
XFILLER_106_395 VGND VGND VPWR VPWR sky130_fd_sc_hd__decap_3
XFILLER_69_97 VGND VGND VPWR VPWR sky130_fd_sc_hd__fill_1
X_11184_ _03854_ _03855_ VGND VGND VPWR VPWR _03857_ sky130_fd_sc_hd__xnor2_1
X_10135_ _02711_ _02712_ VGND VGND VPWR VPWR _02714_ sky130_fd_sc_hd__nand2_1
X_10066_ _02637_ _02638_ VGND VGND VPWR VPWR _02639_ sky130_fd_sc_hd__or2_1
XFILLER_125_81 VPWR VGND VPWR VGND sky130_ef_sc_hd__decap_12
XFILLER_63_614 VGND VGND VPWR VPWR sky130_fd_sc_hd__fill_2
XFILLER_35_305 VGND VGND VPWR VPWR sky130_fd_sc_hd__decap_4
XFILLER_63_636 VPWR VGND VPWR VGND sky130_ef_sc_hd__decap_12
XFILLER_48_699 VGND VGND VPWR VPWR sky130_fd_sc_hd__fill_1
XTAP_TAPCELL_ROW_18_558 VGND VPWR sky130_fd_sc_hd__tapvpwrvgnd_1
XFILLER_35_349 VGND VGND VPWR VPWR sky130_fd_sc_hd__decap_8
XFILLER_90_477 VGND VGND VPWR VPWR sky130_fd_sc_hd__fill_2
XFILLER_43_371 VGND VGND VPWR VPWR sky130_fd_sc_hd__decap_8
X_10968_ _03613_ _03618_ VGND VGND VPWR VPWR _03621_ sky130_fd_sc_hd__xor2_1
X_12707_ _05323_ _05514_ VGND VGND VPWR VPWR _05515_ sky130_fd_sc_hd__xnor2_1
X_13687_ clknet_3_3__leaf_clk _00008_ net713 VGND VGND VPWR VPWR net222 sky130_fd_sc_hd__dfrtp_1
XFILLER_43_393 VGND VGND VPWR VPWR sky130_fd_sc_hd__decap_4
X_12638_ _05426_ _05438_ VGND VGND VPWR VPWR _05440_ sky130_fd_sc_hd__nand2_1
X_10899_ _03541_ _03542_ VGND VGND VPWR VPWR _03545_ sky130_fd_sc_hd__and2_1
XFILLER_129_443 VGND VGND VPWR VPWR sky130_fd_sc_hd__decap_4
X_12569_ _05364_ _05362_ VGND VGND VPWR VPWR _05365_ sky130_fd_sc_hd__and2b_1
XTAP_TAPCELL_ROW_113_1936 VGND VPWR sky130_fd_sc_hd__tapvpwrvgnd_1
XFILLER_98_533 VGND VGND VPWR VPWR sky130_fd_sc_hd__decap_8
XFILLER_98_511 VGND VGND VPWR VPWR sky130_fd_sc_hd__decap_8
X_08800_ _01253_ _01265_ VGND VGND VPWR VPWR _01266_ sky130_fd_sc_hd__xnor2_1
XFILLER_112_332 VGND VGND VPWR VPWR sky130_fd_sc_hd__decap_6
Xfanout719 net1 VGND VGND VPWR VPWR net719 sky130_fd_sc_hd__clkbuf_8
Xfanout708 net102 VGND VGND VPWR VPWR net708 sky130_fd_sc_hd__clkbuf_4
X_09780_ net540 net356 net357 net265 VGND VGND VPWR VPWR _02328_ sky130_fd_sc_hd__o2bb2a_1
XFILLER_112_365 VPWR VGND VPWR VGND sky130_ef_sc_hd__decap_12
X_06992_ _03183_ _03226_ VGND VGND VPWR VPWR _03248_ sky130_fd_sc_hd__xnor2_1
XTAP_TAPCELL_ROW_55_1098 VGND VPWR sky130_fd_sc_hd__tapvpwrvgnd_1
XPHY_EDGE_ROW_7_Right_7 VGND VGND VPWR VPWR sky130_fd_sc_hd__decap_3
XFILLER_39_611 VGND VGND VPWR VPWR sky130_fd_sc_hd__decap_4
X_08731_ _01197_ _01191_ _01190_ VGND VGND VPWR VPWR _01198_ sky130_fd_sc_hd__and3_1
XFILLER_79_791 VPWR VGND VPWR VGND sky130_ef_sc_hd__decap_12
XFILLER_38_121 VGND VGND VPWR VPWR sky130_fd_sc_hd__decap_6
X_08662_ _01126_ _01128_ VGND VGND VPWR VPWR _01129_ sky130_fd_sc_hd__xor2_1
XFILLER_27_817 VGND VGND VPWR VPWR sky130_fd_sc_hd__decap_3
X_07613_ _06659_ _00092_ VGND VGND VPWR VPWR _00093_ sky130_fd_sc_hd__nor2_1
XFILLER_53_113 VGND VGND VPWR VPWR sky130_fd_sc_hd__decap_6
XTAP_TAPCELL_ROW_37_834 VGND VPWR sky130_fd_sc_hd__tapvpwrvgnd_1
XFILLER_39_688 VGND VGND VPWR VPWR sky130_fd_sc_hd__fill_2
X_08593_ net596 net586 net364 net363 VGND VGND VPWR VPWR _01061_ sky130_fd_sc_hd__and4_1
XFILLER_121_39 VPWR VGND VPWR VGND sky130_ef_sc_hd__decap_12
XFILLER_93_293 VGND VGND VPWR VPWR sky130_fd_sc_hd__decap_8
XFILLER_81_466 VGND VGND VPWR VPWR sky130_fd_sc_hd__decap_8
XFILLER_53_146 VGND VGND VPWR VPWR sky130_fd_sc_hd__fill_1
X_07544_ _06759_ _06771_ VGND VGND VPWR VPWR _06773_ sky130_fd_sc_hd__xnor2_1
XFILLER_62_680 VGND VGND VPWR VPWR sky130_fd_sc_hd__decap_8
X_07475_ _06704_ _06703_ VGND VGND VPWR VPWR _06705_ sky130_fd_sc_hd__nand2b_1
XFILLER_14_15 VPWR VGND VPWR VGND sky130_ef_sc_hd__decap_12
XFILLER_22_533 VPWR VGND VPWR VGND sky130_ef_sc_hd__decap_12
X_09214_ _01707_ _01708_ VGND VGND VPWR VPWR _01710_ sky130_fd_sc_hd__xor2_1
X_09145_ net633 net38 net371 net639 VGND VGND VPWR VPWR _01635_ sky130_fd_sc_hd__a22o_1
X_09076_ _01258_ _01260_ _01395_ _01394_ _01384_ VGND VGND VPWR VPWR _01560_ sky130_fd_sc_hd__a32o_1
XFILLER_135_468 VPWR VGND VPWR VGND sky130_ef_sc_hd__decap_12
X_08027_ _00232_ _00373_ _00377_ VGND VGND VPWR VPWR _00504_ sky130_fd_sc_hd__a21oi_4
XFILLER_104_811 VGND VGND VPWR VPWR sky130_fd_sc_hd__fill_1
XFILLER_89_511 VGND VGND VPWR VPWR sky130_fd_sc_hd__fill_1
XFILLER_89_500 VGND VGND VPWR VPWR sky130_fd_sc_hd__decap_4
XFILLER_131_641 VGND VGND VPWR VPWR sky130_fd_sc_hd__decap_8
XFILLER_103_321 VPWR VGND VPWR VGND sky130_ef_sc_hd__decap_12
X_09978_ _02537_ _02541_ VGND VGND VPWR VPWR _02544_ sky130_fd_sc_hd__xnor2_1
XFILLER_89_599 VPWR VGND VPWR VGND sky130_ef_sc_hd__decap_12
XFILLER_76_205 VGND VGND VPWR VPWR sky130_fd_sc_hd__fill_1
X_08929_ _01399_ _01396_ VGND VGND VPWR VPWR _01400_ sky130_fd_sc_hd__and2b_1
XFILLER_76_227 VGND VGND VPWR VPWR sky130_fd_sc_hd__fill_1
XFILLER_92_709 VGND VGND VPWR VPWR sky130_fd_sc_hd__fill_1
X_11940_ _04677_ VGND VGND VPWR VPWR _04678_ sky130_fd_sc_hd__inv_2
XFILLER_44_113 VGND VGND VPWR VPWR sky130_fd_sc_hd__fill_2
XFILLER_17_327 VGND VGND VPWR VPWR sky130_fd_sc_hd__decap_8
XFILLER_29_176 VGND VGND VPWR VPWR sky130_fd_sc_hd__decap_8
XTAP_TAPCELL_ROW_86_1548 VGND VPWR sky130_fd_sc_hd__tapvpwrvgnd_1
XFILLER_72_444 VPWR VGND VPWR VGND sky130_ef_sc_hd__decap_12
XFILLER_55_55 VGND VGND VPWR VPWR sky130_fd_sc_hd__fill_1
X_11871_ _04313_ _04501_ _04500_ VGND VGND VPWR VPWR _04606_ sky130_fd_sc_hd__a21boi_1
XFILLER_33_809 VPWR VGND VPWR VGND sky130_ef_sc_hd__decap_12
X_13610_ _06452_ _06453_ _06451_ VGND VGND VPWR VPWR _06500_ sky130_fd_sc_hd__a21oi_1
XFILLER_72_477 VGND VGND VPWR VPWR sky130_fd_sc_hd__decap_6
XFILLER_44_179 VGND VGND VPWR VPWR sky130_fd_sc_hd__decap_3
XTAP_TAPCELL_ROW_15_517 VGND VPWR sky130_fd_sc_hd__tapvpwrvgnd_1
XFILLER_25_360 VGND VGND VPWR VPWR sky130_fd_sc_hd__decap_8
X_10822_ _03457_ _03458_ _03460_ VGND VGND VPWR VPWR _03461_ sky130_fd_sc_hd__a21o_1
X_13541_ _06333_ _06349_ _06348_ VGND VGND VPWR VPWR _06425_ sky130_fd_sc_hd__o21a_1
X_10753_ _03382_ _03383_ VGND VGND VPWR VPWR _03385_ sky130_fd_sc_hd__xnor2_1
XFILLER_25_393 VGND VGND VPWR VPWR sky130_fd_sc_hd__decap_3
XFILLER_111_94 VPWR VGND VPWR VGND sky130_ef_sc_hd__decap_12
XFILLER_71_43 VPWR VGND VPWR VGND sky130_ef_sc_hd__decap_12
XFILLER_13_566 VPWR VGND VPWR VGND sky130_ef_sc_hd__decap_12
X_13472_ _06333_ _06349_ VGND VGND VPWR VPWR _06350_ sky130_fd_sc_hd__xnor2_1
XFILLER_71_87 VGND VGND VPWR VPWR sky130_fd_sc_hd__decap_8
XFILLER_9_559 VGND VGND VPWR VPWR sky130_fd_sc_hd__fill_1
X_10684_ _03305_ _03308_ VGND VGND VPWR VPWR _03310_ sky130_fd_sc_hd__xor2_1
X_12423_ _05202_ _05203_ _05048_ _05050_ VGND VGND VPWR VPWR _05205_ sky130_fd_sc_hd__a211oi_2
X_12354_ net531 net396 _04985_ VGND VGND VPWR VPWR _05129_ sky130_fd_sc_hd__nand3_2
XFILLER_5_710 VPWR VGND VPWR VGND sky130_ef_sc_hd__decap_12
XTAP_TAPCELL_ROW_97_1699 VGND VPWR sky130_fd_sc_hd__tapvpwrvgnd_1
XFILLER_5_765 VPWR VGND VPWR VGND sky130_ef_sc_hd__decap_12
X_11305_ _03835_ _03838_ _03836_ VGND VGND VPWR VPWR _03989_ sky130_fd_sc_hd__a21bo_1
XFILLER_107_671 VGND VGND VPWR VPWR sky130_fd_sc_hd__fill_1
X_12285_ _05053_ VGND VGND VPWR VPWR _05054_ sky130_fd_sc_hd__inv_2
XFILLER_4_253 VPWR VGND VPWR VGND sky130_ef_sc_hd__decap_12
XFILLER_134_490 VGND VGND VPWR VPWR sky130_fd_sc_hd__fill_1
X_11236_ _03898_ _03912_ VGND VGND VPWR VPWR _03913_ sky130_fd_sc_hd__xor2_1
XFILLER_122_674 VGND VGND VPWR VPWR sky130_fd_sc_hd__fill_1
XFILLER_122_663 VGND VGND VPWR VPWR sky130_fd_sc_hd__fill_1
XFILLER_95_503 VGND VGND VPWR VPWR sky130_fd_sc_hd__fill_1
X_11167_ _03672_ _03837_ VGND VGND VPWR VPWR _03838_ sky130_fd_sc_hd__nand2_1
XFILLER_122_696 VGND VGND VPWR VPWR sky130_fd_sc_hd__decap_4
X_10118_ _02595_ _02601_ _02594_ VGND VGND VPWR VPWR _02696_ sky130_fd_sc_hd__a21oi_1
XFILLER_95_547 VGND VGND VPWR VPWR sky130_fd_sc_hd__fill_1
XFILLER_67_238 VPWR VGND VPWR VGND sky130_ef_sc_hd__decap_12
XTAP_TAPCELL_ROW_128_2154 VGND VPWR sky130_fd_sc_hd__tapvpwrvgnd_1
XFILLER_95_569 VGND VGND VPWR VPWR sky130_fd_sc_hd__decap_3
X_11098_ _03611_ _03625_ _03624_ VGND VGND VPWR VPWR _03763_ sky130_fd_sc_hd__a21o_1
X_10049_ _02617_ _02618_ VGND VGND VPWR VPWR _02621_ sky130_fd_sc_hd__xnor2_1
XFILLER_76_783 VGND VGND VPWR VPWR sky130_fd_sc_hd__decap_8
XFILLER_48_496 VGND VGND VPWR VPWR sky130_fd_sc_hd__decap_6
XFILLER_35_113 VGND VGND VPWR VPWR sky130_fd_sc_hd__decap_8
XFILLER_63_433 VGND VGND VPWR VPWR sky130_fd_sc_hd__fill_1
XFILLER_91_797 VPWR VGND VPWR VGND sky130_ef_sc_hd__decap_12
XFILLER_51_617 VPWR VGND VPWR VGND sky130_ef_sc_hd__decap_12
XFILLER_16_360 VGND VGND VPWR VPWR sky130_fd_sc_hd__decap_4
XFILLER_35_157 VGND VGND VPWR VPWR sky130_fd_sc_hd__decap_8
XFILLER_91_3 VPWR VGND VPWR VGND sky130_ef_sc_hd__decap_12
X_07260_ _04838_ _06149_ _06160_ VGND VGND VPWR VPWR _06171_ sky130_fd_sc_hd__and3_1
XFILLER_31_363 VGND VGND VPWR VPWR sky130_fd_sc_hd__fill_1
X_07191_ _05363_ _05385_ _04547_ VGND VGND VPWR VPWR _05417_ sky130_fd_sc_hd__o21a_1
XFILLER_117_468 VPWR VGND VPWR VGND sky130_ef_sc_hd__decap_12
XTAP_TAPCELL_ROW_57_1127 VGND VPWR sky130_fd_sc_hd__tapvpwrvgnd_1
XFILLER_132_416 VGND VGND VPWR VPWR sky130_fd_sc_hd__decap_4
XFILLER_132_405 VGND VGND VPWR VPWR sky130_fd_sc_hd__fill_1
X_09901_ _02355_ _02357_ _02457_ VGND VGND VPWR VPWR _02459_ sky130_fd_sc_hd__or3b_1
Xfanout505 net149 VGND VGND VPWR VPWR net505 sky130_fd_sc_hd__clkbuf_2
X_09832_ _02370_ _02384_ VGND VGND VPWR VPWR _02385_ sky130_fd_sc_hd__xnor2_1
XFILLER_113_663 VGND VGND VPWR VPWR sky130_fd_sc_hd__decap_4
Xfanout516 net518 VGND VGND VPWR VPWR net516 sky130_fd_sc_hd__clkbuf_4
XTAP_TAPCELL_ROW_70_1316 VGND VPWR sky130_fd_sc_hd__tapvpwrvgnd_1
Xfanout527 net528 VGND VGND VPWR VPWR net527 sky130_fd_sc_hd__clkbuf_4
Xfanout538 net543 VGND VGND VPWR VPWR net538 sky130_fd_sc_hd__buf_1
Xfanout549 net551 VGND VGND VPWR VPWR net549 sky130_fd_sc_hd__clkbuf_2
X_09763_ _02308_ _02309_ VGND VGND VPWR VPWR _02310_ sky130_fd_sc_hd__nor2_1
XFILLER_132_27 VGND VGND VPWR VPWR sky130_fd_sc_hd__fill_1
X_08714_ _01171_ _01173_ _01172_ VGND VGND VPWR VPWR _01181_ sky130_fd_sc_hd__a21o_1
X_06975_ _03041_ _03052_ VGND VGND VPWR VPWR _03063_ sky130_fd_sc_hd__xor2_1
X_09694_ _02082_ _02233_ VGND VGND VPWR VPWR _02234_ sky130_fd_sc_hd__xor2_2
XFILLER_67_783 VGND VGND VPWR VPWR sky130_fd_sc_hd__fill_1
XFILLER_39_463 VPWR VGND VPWR VGND sky130_ef_sc_hd__decap_12
X_08645_ _01110_ _01111_ VGND VGND VPWR VPWR _01112_ sky130_fd_sc_hd__nor2_1
XFILLER_66_293 VGND VGND VPWR VPWR sky130_fd_sc_hd__fill_1
XFILLER_15_809 VGND VGND VPWR VPWR sky130_fd_sc_hd__decap_8
XFILLER_27_669 VGND VGND VPWR VPWR sky130_fd_sc_hd__decap_3
X_08576_ net463 net455 net58 net340 VGND VGND VPWR VPWR _01044_ sky130_fd_sc_hd__and4_1
XFILLER_81_263 VGND VGND VPWR VPWR sky130_fd_sc_hd__fill_1
XTAP_TAPCELL_ROW_68_1289 VGND VPWR sky130_fd_sc_hd__tapvpwrvgnd_1
XTAP_TAPCELL_ROW_68_1278 VGND VPWR sky130_fd_sc_hd__tapvpwrvgnd_1
XFILLER_54_477 VGND VGND VPWR VPWR sky130_fd_sc_hd__fill_2
XFILLER_81_285 VGND VGND VPWR VPWR sky130_fd_sc_hd__fill_1
X_07527_ _06754_ _06755_ VGND VGND VPWR VPWR _06756_ sky130_fd_sc_hd__nand2_1
XTAP_TAPCELL_ROW_81_1467 VGND VPWR sky130_fd_sc_hd__tapvpwrvgnd_1
XTAP_TAPCELL_ROW_81_1478 VGND VPWR sky130_fd_sc_hd__tapvpwrvgnd_1
X_07458_ net650 net411 net105 VGND VGND VPWR VPWR _06688_ sky130_fd_sc_hd__and3_1
X_07389_ _06577_ _06618_ VGND VGND VPWR VPWR _06619_ sky130_fd_sc_hd__nand2b_1
XFILLER_41_57 VPWR VGND VPWR VGND sky130_ef_sc_hd__decap_12
X_09128_ _01447_ _01615_ VGND VGND VPWR VPWR _01617_ sky130_fd_sc_hd__xor2_1
XFILLER_6_529 VGND VGND VPWR VPWR sky130_fd_sc_hd__decap_3
XFILLER_108_457 VGND VGND VPWR VPWR sky130_fd_sc_hd__decap_6
XTAP_TAPCELL_ROW_20_586 VGND VPWR sky130_fd_sc_hd__tapvpwrvgnd_1
X_09059_ _01538_ _01539_ VGND VGND VPWR VPWR _01542_ sky130_fd_sc_hd__xnor2_1
XFILLER_135_265 VGND VGND VPWR VPWR sky130_fd_sc_hd__decap_8
XFILLER_123_416 VGND VGND VPWR VPWR sky130_fd_sc_hd__fill_1
XFILLER_123_449 VGND VGND VPWR VPWR sky130_fd_sc_hd__fill_2
XFILLER_89_341 VGND VGND VPWR VPWR sky130_fd_sc_hd__fill_1
X_12070_ _04760_ _04763_ VGND VGND VPWR VPWR _04819_ sky130_fd_sc_hd__nand2b_1
XFILLER_2_757 VPWR VGND VPWR VGND sky130_ef_sc_hd__decap_12
XFILLER_89_374 VGND VGND VPWR VPWR sky130_fd_sc_hd__fill_2
X_11021_ _03676_ _03677_ _03678_ VGND VGND VPWR VPWR _03679_ sky130_fd_sc_hd__nand3_1
XFILLER_77_547 VGND VGND VPWR VPWR sky130_fd_sc_hd__fill_2
XFILLER_2_29 VPWR VGND VPWR VGND sky130_ef_sc_hd__decap_12
XFILLER_106_83 VGND VGND VPWR VPWR sky130_fd_sc_hd__fill_1
X_12972_ _05797_ _05802_ VGND VGND VPWR VPWR _05804_ sky130_fd_sc_hd__xor2_1
XFILLER_66_65 VGND VGND VPWR VPWR sky130_fd_sc_hd__decap_6
XFILLER_18_603 VGND VGND VPWR VPWR sky130_fd_sc_hd__fill_1
XFILLER_18_625 VPWR VGND VPWR VGND sky130_ef_sc_hd__decap_12
XFILLER_85_591 VGND VGND VPWR VPWR sky130_fd_sc_hd__decap_8
X_11923_ _02886_ _03075_ VGND VGND VPWR VPWR _00012_ sky130_fd_sc_hd__xor2_1
XFILLER_73_797 VPWR VGND VPWR VGND sky130_ef_sc_hd__decap_12
XFILLER_73_775 VGND VGND VPWR VPWR sky130_fd_sc_hd__decap_8
X_11854_ net248 _04511_ _04510_ VGND VGND VPWR VPWR _04587_ sky130_fd_sc_hd__o21a_1
XTAP_TAPCELL_ROW_123_2084 VGND VPWR sky130_fd_sc_hd__tapvpwrvgnd_1
XFILLER_82_53 VPWR VGND VPWR VGND sky130_ef_sc_hd__decap_12
X_10805_ _03440_ _03441_ VGND VGND VPWR VPWR _03442_ sky130_fd_sc_hd__or2_1
XFILLER_82_97 VGND VGND VPWR VPWR sky130_fd_sc_hd__decap_8
X_11785_ net248 _04511_ VGND VGND VPWR VPWR _04512_ sky130_fd_sc_hd__xor2_1
X_13524_ _06405_ _06406_ VGND VGND VPWR VPWR _06407_ sky130_fd_sc_hd__or2_1
X_10736_ _03213_ _03365_ VGND VGND VPWR VPWR _03366_ sky130_fd_sc_hd__nor2_1
XFILLER_13_363 VPWR VGND VPWR VGND sky130_ef_sc_hd__decap_12
XFILLER_15_80 VPWR VGND VPWR VGND sky130_ef_sc_hd__decap_12
XFILLER_127_700 VGND VGND VPWR VPWR sky130_fd_sc_hd__fill_1
XTAP_TAPCELL_ROW_99_1739 VGND VPWR sky130_fd_sc_hd__tapvpwrvgnd_1
XTAP_TAPCELL_ROW_99_1728 VGND VPWR sky130_fd_sc_hd__tapvpwrvgnd_1
X_13455_ _06234_ _06241_ _06240_ VGND VGND VPWR VPWR _06331_ sky130_fd_sc_hd__a21bo_1
X_10667_ net450 net277 net275 net458 VGND VGND VPWR VPWR _03291_ sky130_fd_sc_hd__a22oi_2
XFILLER_40_182 VGND VGND VPWR VPWR sky130_fd_sc_hd__fill_1
XFILLER_127_722 VGND VGND VPWR VPWR sky130_fd_sc_hd__decap_6
X_12406_ _05182_ _05183_ _05184_ VGND VGND VPWR VPWR _05186_ sky130_fd_sc_hd__a21o_1
XFILLER_127_755 VPWR VGND VPWR VGND sky130_ef_sc_hd__decap_12
X_13386_ _06076_ _06255_ VGND VGND VPWR VPWR _06256_ sky130_fd_sc_hd__and2_1
X_10598_ _03079_ _03081_ _03078_ VGND VGND VPWR VPWR _03216_ sky130_fd_sc_hd__o21ba_1
XFILLER_99_105 VGND VGND VPWR VPWR sky130_fd_sc_hd__decap_6
X_12337_ _05109_ _05071_ VGND VGND VPWR VPWR _05110_ sky130_fd_sc_hd__and2b_1
XFILLER_114_438 VGND VGND VPWR VPWR sky130_fd_sc_hd__decap_8
X_12268_ _04851_ _04864_ _04863_ VGND VGND VPWR VPWR _05036_ sky130_fd_sc_hd__a21bo_1
X_11219_ _03730_ _03733_ _03727_ VGND VGND VPWR VPWR _03895_ sky130_fd_sc_hd__a21oi_1
X_12199_ _04955_ _04956_ VGND VGND VPWR VPWR _04960_ sky130_fd_sc_hd__xnor2_1
XTAP_TAPCELL_ROW_52_1057 VGND VPWR sky130_fd_sc_hd__tapvpwrvgnd_1
XTAP_TAPCELL_ROW_52_1046 VGND VPWR sky130_fd_sc_hd__tapvpwrvgnd_1
XFILLER_110_699 VGND VGND VPWR VPWR sky130_fd_sc_hd__fill_1
XFILLER_102_19 VGND VGND VPWR VPWR sky130_fd_sc_hd__decap_8
XFILLER_36_433 VGND VGND VPWR VPWR sky130_fd_sc_hd__decap_4
XTAP_TAPCELL_ROW_108_1868 VGND VPWR sky130_fd_sc_hd__tapvpwrvgnd_1
XFILLER_91_561 VGND VGND VPWR VPWR sky130_fd_sc_hd__fill_2
XFILLER_63_241 VGND VGND VPWR VPWR sky130_fd_sc_hd__decap_3
X_08430_ _00813_ _00902_ VGND VGND VPWR VPWR _00903_ sky130_fd_sc_hd__xor2_1
XTAP_TAPCELL_ROW_47_984 VGND VPWR sky130_fd_sc_hd__tapvpwrvgnd_1
XFILLER_36_477 VGND VGND VPWR VPWR sky130_fd_sc_hd__decap_3
XFILLER_91_583 VPWR VGND VPWR VGND sky130_ef_sc_hd__decap_12
XFILLER_51_447 VGND VGND VPWR VPWR sky130_fd_sc_hd__fill_1
X_08361_ net663 _06801_ _06804_ _00764_ VGND VGND VPWR VPWR _00835_ sky130_fd_sc_hd__o22a_1
X_07312_ _06534_ _06541_ _06542_ VGND VGND VPWR VPWR _06543_ sky130_fd_sc_hd__nand3_1
X_08292_ _00763_ _00766_ VGND VGND VPWR VPWR _00767_ sky130_fd_sc_hd__xor2_1
XFILLER_137_519 VGND VGND VPWR VPWR sky130_fd_sc_hd__fill_1
X_07243_ net687 net476 VGND VGND VPWR VPWR _05985_ sky130_fd_sc_hd__nand2_1
X_07174_ _05013_ _05199_ _05220_ VGND VGND VPWR VPWR _05231_ sky130_fd_sc_hd__nor3_1
XFILLER_11_27 VPWR VGND VPWR VGND sky130_ef_sc_hd__decap_12
XFILLER_133_725 VGND VGND VPWR VPWR sky130_fd_sc_hd__decap_3
XFILLER_127_27 VPWR VGND VPWR VGND sky130_ef_sc_hd__decap_12
XFILLER_118_799 VPWR VGND VPWR VGND sky130_ef_sc_hd__decap_12
XFILLER_132_224 VGND VGND VPWR VPWR sky130_fd_sc_hd__fill_2
XFILLER_120_419 VGND VGND VPWR VPWR sky130_fd_sc_hd__fill_1
XFILLER_120_408 VGND VGND VPWR VPWR sky130_fd_sc_hd__fill_1
XFILLER_59_503 VGND VGND VPWR VPWR sky130_fd_sc_hd__fill_1
Xfanout313 net74 VGND VGND VPWR VPWR net313 sky130_fd_sc_hd__buf_2
Xfanout302 net80 VGND VGND VPWR VPWR net302 sky130_fd_sc_hd__clkbuf_2
Xfanout357 net47 VGND VGND VPWR VPWR net357 sky130_fd_sc_hd__buf_2
X_09815_ _02364_ _02365_ VGND VGND VPWR VPWR _02366_ sky130_fd_sc_hd__nand2b_1
Xfanout346 net55 VGND VGND VPWR VPWR net346 sky130_fd_sc_hd__buf_2
XFILLER_113_482 VGND VGND VPWR VPWR sky130_fd_sc_hd__decap_4
Xfanout335 net61 VGND VGND VPWR VPWR net335 sky130_fd_sc_hd__clkbuf_4
XFILLER_86_300 VGND VGND VPWR VPWR sky130_fd_sc_hd__decap_8
XFILLER_59_536 VGND VGND VPWR VPWR sky130_fd_sc_hd__decap_6
Xfanout324 net68 VGND VGND VPWR VPWR net324 sky130_fd_sc_hd__dlymetal6s2s_1
Xfanout368 net40 VGND VGND VPWR VPWR net368 sky130_fd_sc_hd__clkbuf_4
XFILLER_101_666 VGND VGND VPWR VPWR sky130_fd_sc_hd__fill_2
XFILLER_100_132 VGND VGND VPWR VPWR sky130_fd_sc_hd__decap_8
XFILLER_100_121 VGND VGND VPWR VPWR sky130_fd_sc_hd__decap_6
Xfanout379 net33 VGND VGND VPWR VPWR net379 sky130_fd_sc_hd__clkbuf_4
X_09746_ _02284_ _02289_ VGND VGND VPWR VPWR _02291_ sky130_fd_sc_hd__xnor2_1
XFILLER_100_165 VGND VGND VPWR VPWR sky130_fd_sc_hd__decap_6
X_06958_ _02315_ _02793_ VGND VGND VPWR VPWR _02877_ sky130_fd_sc_hd__nor2_1
X_09677_ _02054_ _02064_ _02062_ VGND VGND VPWR VPWR _02215_ sky130_fd_sc_hd__a21oi_1
XFILLER_27_433 VGND VGND VPWR VPWR sky130_fd_sc_hd__decap_6
X_08628_ _01093_ _01094_ VGND VGND VPWR VPWR _01095_ sky130_fd_sc_hd__nor2_1
XTAP_TAPCELL_ROW_83_1507 VGND VPWR sky130_fd_sc_hd__tapvpwrvgnd_1
XFILLER_70_701 VPWR VGND VPWR VGND sky130_ef_sc_hd__decap_12
X_06889_ net687 net519 net686 net526 VGND VGND VPWR VPWR _02129_ sky130_fd_sc_hd__a22o_1
X_08559_ _01024_ _01026_ _01027_ VGND VGND VPWR VPWR _01028_ sky130_fd_sc_hd__or3_1
XTAP_TAPCELL_ROW_25_656 VGND VPWR sky130_fd_sc_hd__tapvpwrvgnd_1
XTAP_TAPCELL_ROW_25_667 VGND VPWR sky130_fd_sc_hd__tapvpwrvgnd_1
X_11570_ _04274_ _04276_ VGND VGND VPWR VPWR _04278_ sky130_fd_sc_hd__xnor2_1
XFILLER_128_519 VPWR VGND VPWR VGND sky130_ef_sc_hd__decap_12
XFILLER_10_333 VGND VGND VPWR VPWR sky130_fd_sc_hd__fill_2
X_10521_ _03107_ _03130_ VGND VGND VPWR VPWR _03132_ sky130_fd_sc_hd__and2b_1
X_13240_ _06093_ _06095_ VGND VGND VPWR VPWR _06097_ sky130_fd_sc_hd__xor2_1
XFILLER_10_377 VPWR VGND VPWR VGND sky130_ef_sc_hd__decap_12
XFILLER_6_359 VGND VGND VPWR VPWR sky130_fd_sc_hd__decap_4
X_10452_ _02938_ _03056_ VGND VGND VPWR VPWR _03057_ sky130_fd_sc_hd__and2_1
XFILLER_124_714 VPWR VGND VPWR VGND sky130_ef_sc_hd__decap_12
XFILLER_108_265 VGND VGND VPWR VPWR sky130_fd_sc_hd__decap_8
X_13171_ _05891_ _06021_ VGND VGND VPWR VPWR _06022_ sky130_fd_sc_hd__xnor2_2
X_10383_ _02977_ _02979_ VGND VGND VPWR VPWR _02981_ sky130_fd_sc_hd__nor2_1
XTAP_TAPCELL_ROW_94_1669 VGND VPWR sky130_fd_sc_hd__tapvpwrvgnd_1
XTAP_TAPCELL_ROW_94_1658 VGND VPWR sky130_fd_sc_hd__tapvpwrvgnd_1
X_12122_ _04865_ _04866_ _04874_ VGND VGND VPWR VPWR _04876_ sky130_fd_sc_hd__nand3_1
X_12053_ _04774_ _04798_ VGND VGND VPWR VPWR _04800_ sky130_fd_sc_hd__xor2_1
XFILLER_78_801 VGND VGND VPWR VPWR sky130_fd_sc_hd__decap_8
XFILLER_77_300 VGND VGND VPWR VPWR sky130_fd_sc_hd__fill_2
XFILLER_2_598 VGND VGND VPWR VPWR sky130_fd_sc_hd__fill_1
XFILLER_2_587 VGND VGND VPWR VPWR sky130_fd_sc_hd__fill_1
X_11004_ _03655_ _03659_ VGND VGND VPWR VPWR _03660_ sky130_fd_sc_hd__and2b_1
XFILLER_89_193 VGND VGND VPWR VPWR sky130_fd_sc_hd__fill_1
XTAP_TAPCELL_ROW_125_2113 VGND VPWR sky130_fd_sc_hd__tapvpwrvgnd_1
XTAP_TAPCELL_ROW_5_370 VGND VPWR sky130_fd_sc_hd__tapvpwrvgnd_1
XFILLER_18_400 VGND VGND VPWR VPWR sky130_fd_sc_hd__fill_1
XFILLER_133_81 VPWR VGND VPWR VGND sky130_ef_sc_hd__decap_12
X_12955_ _05783_ _05784_ VGND VGND VPWR VPWR _05785_ sky130_fd_sc_hd__xnor2_1
XFILLER_46_764 VGND VGND VPWR VPWR sky130_fd_sc_hd__decap_6
XFILLER_18_477 VGND VGND VPWR VPWR sky130_fd_sc_hd__decap_6
X_11906_ net243 _04642_ VGND VGND VPWR VPWR _04643_ sky130_fd_sc_hd__xnor2_1
X_12886_ _05511_ _05543_ _05542_ VGND VGND VPWR VPWR _05710_ sky130_fd_sc_hd__a21bo_1
XFILLER_45_296 VGND VGND VPWR VPWR sky130_fd_sc_hd__fill_2
XTAP_TAPCELL_ROW_44_932 VGND VPWR sky130_fd_sc_hd__tapvpwrvgnd_1
XTAP_TAPCELL_ROW_44_943 VGND VPWR sky130_fd_sc_hd__tapvpwrvgnd_1
X_11837_ _04454_ _04457_ _04566_ VGND VGND VPWR VPWR _04568_ sky130_fd_sc_hd__nor3_1
XTAP_TAPCELL_ROW_103_1787 VGND VPWR sky130_fd_sc_hd__tapvpwrvgnd_1
X_11768_ _04491_ _04492_ VGND VGND VPWR VPWR _04494_ sky130_fd_sc_hd__nor2_1
XTAP_TAPCELL_ROW_103_1798 VGND VPWR sky130_fd_sc_hd__tapvpwrvgnd_1
X_13507_ _06387_ _06359_ VGND VGND VPWR VPWR _06388_ sky130_fd_sc_hd__nand2b_1
XFILLER_41_480 VGND VGND VPWR VPWR sky130_fd_sc_hd__decap_3
X_10719_ _03344_ _03345_ _03190_ _03193_ VGND VGND VPWR VPWR _03349_ sky130_fd_sc_hd__o211ai_1
XFILLER_9_153 VGND VGND VPWR VPWR sky130_fd_sc_hd__decap_8
X_11699_ _04309_ _04418_ VGND VGND VPWR VPWR _04419_ sky130_fd_sc_hd__xnor2_1
Xrebuffer1 _02682_ VGND VGND VPWR VPWR net720 sky130_fd_sc_hd__clkbuf_1
XTAP_TAPCELL_ROW_136_2275 VGND VPWR sky130_fd_sc_hd__tapvpwrvgnd_1
XTAP_TAPCELL_ROW_136_2264 VGND VPWR sky130_fd_sc_hd__tapvpwrvgnd_1
XFILLER_127_541 VGND VGND VPWR VPWR sky130_fd_sc_hd__decap_8
X_13438_ _06304_ _06310_ VGND VGND VPWR VPWR _06313_ sky130_fd_sc_hd__xnor2_1
X_13369_ _06235_ _06237_ VGND VGND VPWR VPWR _06238_ sky130_fd_sc_hd__or2_2
XFILLER_54_3 VPWR VGND VPWR VGND sky130_ef_sc_hd__decap_12
XFILLER_115_769 VPWR VGND VPWR VGND sky130_ef_sc_hd__decap_12
XFILLER_102_419 VGND VGND VPWR VPWR sky130_fd_sc_hd__fill_1
X_07930_ _00242_ _00270_ _00269_ VGND VGND VPWR VPWR _00408_ sky130_fd_sc_hd__a21o_1
XFILLER_130_739 VPWR VGND VPWR VGND sky130_ef_sc_hd__decap_12
XFILLER_69_823 VGND VGND VPWR VPWR sky130_fd_sc_hd__fill_1
X_07861_ net684 net258 _00337_ _00338_ VGND VGND VPWR VPWR _00339_ sky130_fd_sc_hd__o22a_1
XFILLER_110_474 VGND VGND VPWR VPWR sky130_fd_sc_hd__fill_2
X_09600_ net373 net137 VGND VGND VPWR VPWR _02132_ sky130_fd_sc_hd__nand2b_1
XFILLER_68_377 VPWR VGND VPWR VGND sky130_ef_sc_hd__decap_12
X_07792_ _00242_ _00270_ VGND VGND VPWR VPWR _00271_ sky130_fd_sc_hd__xor2_2
X_09531_ _01722_ _01726_ VGND VGND VPWR VPWR _02056_ sky130_fd_sc_hd__nor2_2
XFILLER_49_591 VGND VGND VPWR VPWR sky130_fd_sc_hd__decap_3
X_09462_ _01973_ _01979_ VGND VGND VPWR VPWR _01981_ sky130_fd_sc_hd__xnor2_1
XTAP_TAPCELL_ROW_65_1237 VGND VPWR sky130_fd_sc_hd__tapvpwrvgnd_1
XFILLER_36_296 VGND VGND VPWR VPWR sky130_fd_sc_hd__decap_4
XFILLER_37_797 VPWR VGND VPWR VGND sky130_ef_sc_hd__decap_12
X_09393_ _01887_ _01905_ VGND VGND VPWR VPWR _01906_ sky130_fd_sc_hd__xnor2_1
XTAP_TAPCELL_ROW_65_1248 VGND VPWR sky130_fd_sc_hd__tapvpwrvgnd_1
X_08413_ _00884_ _00885_ VGND VGND VPWR VPWR _00887_ sky130_fd_sc_hd__xnor2_1
X_08344_ _00812_ _00817_ VGND VGND VPWR VPWR _00818_ sky130_fd_sc_hd__xnor2_1
XFILLER_52_789 VPWR VGND VPWR VGND sky130_ef_sc_hd__decap_12
XFILLER_51_266 VPWR VGND VPWR VGND sky130_ef_sc_hd__decap_12
XTAP_TAPCELL_ROW_22_615 VGND VPWR sky130_fd_sc_hd__tapvpwrvgnd_1
XFILLER_51_299 VGND VGND VPWR VPWR sky130_fd_sc_hd__fill_1
XFILLER_22_15 VPWR VGND VPWR VGND sky130_ef_sc_hd__decap_12
XFILLER_138_15 VPWR VGND VPWR VGND sky130_ef_sc_hd__decap_12
X_08275_ _00739_ _00748_ VGND VGND VPWR VPWR _00750_ sky130_fd_sc_hd__xnor2_1
XFILLER_20_686 VGND VGND VPWR VPWR sky130_fd_sc_hd__fill_2
X_07226_ net571 net694 VGND VGND VPWR VPWR _05799_ sky130_fd_sc_hd__nand2_1
XFILLER_118_563 VGND VGND VPWR VPWR sky130_fd_sc_hd__fill_1
XFILLER_106_725 VPWR VGND VPWR VGND sky130_ef_sc_hd__decap_12
X_07157_ net100 net632 net622 net267 VGND VGND VPWR VPWR _05046_ sky130_fd_sc_hd__a22oi_1
XFILLER_133_533 VGND VGND VPWR VPWR sky130_fd_sc_hd__decap_8
XFILLER_133_555 VGND VGND VPWR VPWR sky130_fd_sc_hd__decap_4
XFILLER_106_769 VPWR VGND VPWR VGND sky130_ef_sc_hd__decap_12
XTAP_TAPCELL_ROW_76_1399 VGND VPWR sky130_fd_sc_hd__tapvpwrvgnd_1
X_07088_ _04275_ _04286_ VGND VGND VPWR VPWR _04297_ sky130_fd_sc_hd__nor2_1
XFILLER_120_216 VPWR VGND VPWR VGND sky130_ef_sc_hd__decap_12
XFILLER_78_119 VGND VGND VPWR VPWR sky130_fd_sc_hd__fill_2
XFILLER_59_300 VGND VGND VPWR VPWR sky130_fd_sc_hd__fill_1
XFILLER_86_141 VGND VGND VPWR VPWR sky130_fd_sc_hd__decap_6
XFILLER_87_697 VPWR VGND VPWR VGND sky130_ef_sc_hd__decap_12
XFILLER_86_152 VPWR VGND VPWR VGND sky130_ef_sc_hd__decap_12
XFILLER_19_219 VGND VGND VPWR VPWR sky130_fd_sc_hd__decap_4
X_09729_ net629 net620 net367 VGND VGND VPWR VPWR _02273_ sky130_fd_sc_hd__and3_1
XFILLER_103_51 VGND VGND VPWR VPWR sky130_fd_sc_hd__decap_4
X_12740_ _05548_ _05549_ _05370_ _05372_ VGND VGND VPWR VPWR _05551_ sky130_fd_sc_hd__o211a_1
XTAP_TAPCELL_ROW_120_2043 VGND VPWR sky130_fd_sc_hd__tapvpwrvgnd_1
XTAP_TAPCELL_ROW_120_2032 VGND VPWR sky130_fd_sc_hd__tapvpwrvgnd_1
X_12671_ net522 net394 VGND VGND VPWR VPWR _05476_ sky130_fd_sc_hd__nand2_4
XFILLER_63_55 VGND VGND VPWR VPWR sky130_fd_sc_hd__fill_1
XFILLER_43_778 VGND VGND VPWR VPWR sky130_fd_sc_hd__decap_6
XFILLER_42_233 VGND VGND VPWR VPWR sky130_fd_sc_hd__decap_4
XFILLER_63_99 VGND VGND VPWR VPWR sky130_fd_sc_hd__fill_1
X_11622_ _04191_ _04194_ _04332_ VGND VGND VPWR VPWR _04334_ sky130_fd_sc_hd__and3_1
XFILLER_10_141 VGND VGND VPWR VPWR sky130_fd_sc_hd__decap_4
X_11553_ _04126_ _04137_ _04125_ VGND VGND VPWR VPWR _04259_ sky130_fd_sc_hd__a21oi_1
XFILLER_128_349 VGND VGND VPWR VPWR sky130_fd_sc_hd__fill_1
XFILLER_109_530 VGND VGND VPWR VPWR sky130_fd_sc_hd__decap_8
X_11484_ _04032_ _04040_ _04183_ VGND VGND VPWR VPWR _04184_ sky130_fd_sc_hd__a21o_1
X_10504_ _03110_ _03111_ _03109_ VGND VGND VPWR VPWR _03113_ sky130_fd_sc_hd__o21ai_1
X_13223_ net478 net396 net395 net487 VGND VGND VPWR VPWR _06078_ sky130_fd_sc_hd__a22o_1
X_10435_ _02960_ _03035_ _03036_ VGND VGND VPWR VPWR _03038_ sky130_fd_sc_hd__or3_2
XFILLER_124_522 VGND VGND VPWR VPWR sky130_fd_sc_hd__fill_2
X_13154_ _05993_ _06002_ VGND VGND VPWR VPWR _06003_ sky130_fd_sc_hd__xor2_2
XFILLER_12_92 VGND VGND VPWR VPWR sky130_fd_sc_hd__decap_4
XFILLER_88_41 VPWR VGND VPWR VGND sky130_ef_sc_hd__decap_12
X_12105_ net656 net647 net369 net353 VGND VGND VPWR VPWR _04857_ sky130_fd_sc_hd__nand4_1
X_10366_ net443 net281 VGND VGND VPWR VPWR _02962_ sky130_fd_sc_hd__nand2_1
XTAP_TAPCELL_ROW_131_2194 VGND VPWR sky130_fd_sc_hd__tapvpwrvgnd_1
X_13085_ _05923_ _05924_ VGND VGND VPWR VPWR _05927_ sky130_fd_sc_hd__xor2_1
XFILLER_88_85 VGND VGND VPWR VPWR sky130_fd_sc_hd__decap_6
XFILLER_2_362 VGND VGND VPWR VPWR sky130_fd_sc_hd__fill_2
X_10297_ _02833_ _02885_ VGND VGND VPWR VPWR _00002_ sky130_fd_sc_hd__xnor2_1
X_12036_ net572 net696 VGND VGND VPWR VPWR _04781_ sky130_fd_sc_hd__nand2_1
XFILLER_78_653 VGND VGND VPWR VPWR sky130_fd_sc_hd__fill_1
XFILLER_46_550 VGND VGND VPWR VPWR sky130_fd_sc_hd__decap_6
XFILLER_19_764 VPWR VGND VPWR VGND sky130_ef_sc_hd__decap_12
XTAP_TAPCELL_ROW_105_1827 VGND VPWR sky130_fd_sc_hd__tapvpwrvgnd_1
XTAP_TAPCELL_ROW_105_1816 VGND VPWR sky130_fd_sc_hd__tapvpwrvgnd_1
X_12938_ _05760_ _05765_ VGND VGND VPWR VPWR _05767_ sky130_fd_sc_hd__and2_1
XFILLER_19_797 VPWR VGND VPWR VGND sky130_ef_sc_hd__decap_12
XTAP_TAPCELL_ROW_138_2315 VGND VPWR sky130_fd_sc_hd__tapvpwrvgnd_1
XTAP_TAPCELL_ROW_138_2304 VGND VPWR sky130_fd_sc_hd__tapvpwrvgnd_1
X_12869_ net613 net338 _05689_ _05691_ VGND VGND VPWR VPWR _05692_ sky130_fd_sc_hd__o2bb2a_1
XFILLER_61_597 VGND VGND VPWR VPWR sky130_fd_sc_hd__decap_8
XFILLER_21_406 VPWR VGND VPWR VGND sky130_ef_sc_hd__decap_12
XFILLER_119_316 VGND VGND VPWR VPWR sky130_fd_sc_hd__fill_2
XFILLER_119_305 VGND VGND VPWR VPWR sky130_fd_sc_hd__fill_1
XTAP_TAPCELL_ROW_60_1167 VGND VPWR sky130_fd_sc_hd__tapvpwrvgnd_1
XFILLER_135_809 VPWR VGND VPWR VGND sky130_ef_sc_hd__decap_12
X_08060_ _00513_ _00535_ VGND VGND VPWR VPWR _00537_ sky130_fd_sc_hd__xnor2_2
X_07011_ net268 net638 VGND VGND VPWR VPWR _03456_ sky130_fd_sc_hd__and2_1
XFILLER_115_522 VGND VGND VPWR VPWR sky130_fd_sc_hd__fill_1
XFILLER_108_29 VPWR VGND VPWR VGND sky130_ef_sc_hd__decap_12
XTAP_TAPCELL_ROW_116_1978 VGND VPWR sky130_fd_sc_hd__tapvpwrvgnd_1
X_08962_ _01407_ _01435_ VGND VGND VPWR VPWR _01436_ sky130_fd_sc_hd__and2b_1
XFILLER_102_205 VPWR VGND VPWR VGND sky130_ef_sc_hd__decap_12
X_08893_ _01357_ _01358_ _01360_ VGND VGND VPWR VPWR _01361_ sky130_fd_sc_hd__nand3_1
XFILLER_102_249 VGND VGND VPWR VPWR sky130_fd_sc_hd__decap_3
XFILLER_69_653 VPWR VGND VPWR VGND sky130_ef_sc_hd__decap_12
X_07913_ _00384_ _00389_ VGND VGND VPWR VPWR _00391_ sky130_fd_sc_hd__xnor2_1
XFILLER_57_804 VPWR VGND VPWR VGND sky130_ef_sc_hd__decap_12
XFILLER_111_783 VGND VGND VPWR VPWR sky130_fd_sc_hd__fill_1
XFILLER_110_260 VGND VGND VPWR VPWR sky130_fd_sc_hd__fill_2
XFILLER_84_623 VGND VGND VPWR VPWR sky130_fd_sc_hd__fill_1
XFILLER_84_601 VGND VGND VPWR VPWR sky130_fd_sc_hd__decap_8
XFILLER_69_697 VPWR VGND VPWR VGND sky130_ef_sc_hd__decap_12
XFILLER_68_141 VGND VGND VPWR VPWR sky130_fd_sc_hd__decap_8
X_07844_ net252 _00320_ VGND VGND VPWR VPWR _00322_ sky130_fd_sc_hd__xor2_1
XFILLER_84_645 VGND VGND VPWR VPWR sky130_fd_sc_hd__decap_4
XFILLER_56_336 VGND VGND VPWR VPWR sky130_fd_sc_hd__decap_4
XFILLER_83_144 VPWR VGND VPWR VGND sky130_ef_sc_hd__decap_12
X_07775_ net619 net706 net705 net628 VGND VGND VPWR VPWR _00254_ sky130_fd_sc_hd__a22oi_1
XFILLER_17_15 VPWR VGND VPWR VGND sky130_ef_sc_hd__decap_12
XFILLER_25_701 VPWR VGND VPWR VGND sky130_ef_sc_hd__decap_12
X_09514_ _02035_ _02036_ VGND VGND VPWR VPWR _02037_ sky130_fd_sc_hd__nand2b_1
X_09445_ net445 net330 VGND VGND VPWR VPWR _01962_ sky130_fd_sc_hd__nand2_1
XFILLER_52_531 VGND VGND VPWR VPWR sky130_fd_sc_hd__fill_1
XFILLER_12_406 VGND VGND VPWR VPWR sky130_fd_sc_hd__decap_8
XFILLER_12_428 VPWR VGND VPWR VGND sky130_ef_sc_hd__decap_12
XFILLER_40_737 VGND VGND VPWR VPWR sky130_fd_sc_hd__fill_1
X_09376_ _01700_ _01886_ VGND VGND VPWR VPWR _01887_ sky130_fd_sc_hd__xnor2_1
XFILLER_24_299 VGND VGND VPWR VPWR sky130_fd_sc_hd__decap_8
XFILLER_40_748 VGND VGND VPWR VPWR sky130_fd_sc_hd__decap_8
XFILLER_138_636 VGND VGND VPWR VPWR sky130_fd_sc_hd__decap_4
XFILLER_137_113 VPWR VGND VPWR VGND sky130_ef_sc_hd__decap_12
X_08327_ _06658_ _00729_ _00728_ VGND VGND VPWR VPWR _00801_ sky130_fd_sc_hd__a21oi_1
XFILLER_33_69 VPWR VGND VPWR VGND sky130_ef_sc_hd__decap_12
XTAP_TAPCELL_ROW_78_1428 VGND VPWR sky130_fd_sc_hd__tapvpwrvgnd_1
X_08258_ _00725_ _00732_ VGND VGND VPWR VPWR _00733_ sky130_fd_sc_hd__nand2_1
XFILLER_125_319 VPWR VGND VPWR VGND sky130_ef_sc_hd__decap_12
XFILLER_125_308 VGND VGND VPWR VPWR sky130_fd_sc_hd__fill_1
X_07209_ _05591_ _05602_ VGND VGND VPWR VPWR _05613_ sky130_fd_sc_hd__nor2_1
XFILLER_106_533 VPWR VGND VPWR VGND sky130_ef_sc_hd__decap_12
X_08189_ _00469_ _00544_ _00543_ VGND VGND VPWR VPWR _00665_ sky130_fd_sc_hd__a21oi_2
XFILLER_3_126 VGND VGND VPWR VPWR sky130_fd_sc_hd__fill_1
X_10220_ _02803_ _02804_ VGND VGND VPWR VPWR _00000_ sky130_fd_sc_hd__and2_1
XTAP_TAPCELL_ROW_91_1617 VGND VPWR sky130_fd_sc_hd__tapvpwrvgnd_1
X_10151_ _02720_ _02730_ _02731_ VGND VGND VPWR VPWR _02732_ sky130_fd_sc_hd__or3_1
XFILLER_121_503 VGND VGND VPWR VPWR sky130_fd_sc_hd__fill_1
XFILLER_79_417 VPWR VGND VPWR VGND sky130_ef_sc_hd__decap_12
X_10082_ _02656_ _02647_ VGND VGND VPWR VPWR _02657_ sky130_fd_sc_hd__nand2b_1
XFILLER_102_750 VGND VGND VPWR VPWR sky130_fd_sc_hd__decap_6
XFILLER_87_461 VGND VGND VPWR VPWR sky130_fd_sc_hd__decap_6
XFILLER_75_612 VGND VGND VPWR VPWR sky130_fd_sc_hd__decap_4
XFILLER_101_293 VGND VGND VPWR VPWR sky130_fd_sc_hd__decap_6
XFILLER_101_260 VPWR VGND VPWR VGND sky130_ef_sc_hd__decap_12
XFILLER_114_83 VGND VGND VPWR VPWR sky130_fd_sc_hd__fill_1
XFILLER_74_133 VGND VGND VPWR VPWR sky130_fd_sc_hd__decap_6
XFILLER_74_188 VGND VGND VPWR VPWR sky130_fd_sc_hd__decap_8
XFILLER_74_177 VGND VGND VPWR VPWR sky130_fd_sc_hd__decap_4
XFILLER_74_65 VGND VGND VPWR VPWR sky130_fd_sc_hd__fill_1
X_10984_ net457 net449 net271 VGND VGND VPWR VPWR _03638_ sky130_fd_sc_hd__and3_1
X_12723_ _05530_ _05531_ _00108_ VGND VGND VPWR VPWR _05533_ sky130_fd_sc_hd__a21o_1
XFILLER_55_391 VGND VGND VPWR VPWR sky130_fd_sc_hd__fill_1
XFILLER_70_350 VGND VGND VPWR VPWR sky130_fd_sc_hd__fill_1
XFILLER_90_53 VPWR VGND VPWR VGND sky130_ef_sc_hd__decap_12
X_12654_ net259 net406 VGND VGND VPWR VPWR _05457_ sky130_fd_sc_hd__nor2_1
XFILLER_30_214 VPWR VGND VPWR VGND sky130_ef_sc_hd__decap_12
XFILLER_129_603 VGND VGND VPWR VPWR sky130_fd_sc_hd__decap_3
XTAP_TAPCELL_ROW_100_1746 VGND VPWR sky130_fd_sc_hd__tapvpwrvgnd_1
XFILLER_90_97 VPWR VGND VPWR VGND sky130_ef_sc_hd__decap_12
X_12585_ _05379_ _05380_ VGND VGND VPWR VPWR _05382_ sky130_fd_sc_hd__xnor2_1
X_11605_ _04312_ _04313_ _04314_ VGND VGND VPWR VPWR _04315_ sky130_fd_sc_hd__or3_1
XTAP_TAPCELL_ROW_13_489 VGND VPWR sky130_fd_sc_hd__tapvpwrvgnd_1
X_11536_ net609 _04119_ _04240_ VGND VGND VPWR VPWR _04241_ sky130_fd_sc_hd__a21o_1
XTAP_TAPCELL_ROW_133_2234 VGND VPWR sky130_fd_sc_hd__tapvpwrvgnd_1
XTAP_TAPCELL_ROW_133_2223 VGND VPWR sky130_fd_sc_hd__tapvpwrvgnd_1
XFILLER_109_393 VGND VGND VPWR VPWR sky130_fd_sc_hd__decap_6
XFILLER_109_382 VGND VGND VPWR VPWR sky130_fd_sc_hd__decap_6
X_13206_ _06053_ _06058_ VGND VGND VPWR VPWR _06059_ sky130_fd_sc_hd__nand2_1
X_11467_ _04164_ _04165_ VGND VGND VPWR VPWR _00014_ sky130_fd_sc_hd__xnor2_1
X_11398_ _04085_ _04089_ VGND VGND VPWR VPWR _04091_ sky130_fd_sc_hd__and2b_1
X_10418_ _03016_ _03017_ _03018_ VGND VGND VPWR VPWR _03020_ sky130_fd_sc_hd__nand3_1
XFILLER_124_363 VGND VGND VPWR VPWR sky130_fd_sc_hd__fill_1
XFILLER_98_737 VPWR VGND VPWR VGND sky130_ef_sc_hd__decap_12
X_13137_ net629 net620 net284 VGND VGND VPWR VPWR _05984_ sky130_fd_sc_hd__o21ai_1
X_10349_ net503 net83 net295 net511 VGND VGND VPWR VPWR _02944_ sky130_fd_sc_hd__a22o_1
XFILLER_100_709 VGND VGND VPWR VPWR sky130_fd_sc_hd__fill_2
X_13068_ _05907_ _05906_ VGND VGND VPWR VPWR _05909_ sky130_fd_sc_hd__and2b_1
X_12019_ net400 _04727_ net529 net19 VGND VGND VPWR VPWR _04763_ sky130_fd_sc_hd__or4bb_1
XFILLER_66_601 VGND VGND VPWR VPWR sky130_fd_sc_hd__decap_8
XFILLER_78_494 VGND VGND VPWR VPWR sky130_fd_sc_hd__decap_8
XFILLER_78_483 VGND VGND VPWR VPWR sky130_fd_sc_hd__fill_1
XFILLER_17_3 VPWR VGND VPWR VGND sky130_ef_sc_hd__decap_12
XFILLER_66_656 VPWR VGND VPWR VGND sky130_ef_sc_hd__decap_12
XTAP_TAPCELL_ROW_49_1007 VGND VPWR sky130_fd_sc_hd__tapvpwrvgnd_1
X_07560_ net510 net502 net119 net678 VGND VGND VPWR VPWR _06789_ sky130_fd_sc_hd__and4_1
X_09230_ _01727_ _01721_ VGND VGND VPWR VPWR _01728_ sky130_fd_sc_hd__and2b_1
XFILLER_61_361 VGND VGND VPWR VPWR sky130_fd_sc_hd__decap_8
X_07491_ _06718_ _06719_ VGND VGND VPWR VPWR _06721_ sky130_fd_sc_hd__xnor2_1
XFILLER_34_586 VGND VGND VPWR VPWR sky130_fd_sc_hd__fill_2
XFILLER_21_225 VGND VGND VPWR VPWR sky130_fd_sc_hd__decap_3
XFILLER_34_597 VGND VGND VPWR VPWR sky130_fd_sc_hd__decap_3
X_09161_ _01473_ _01482_ _01481_ VGND VGND VPWR VPWR _01653_ sky130_fd_sc_hd__a21bo_1
XTAP_TAPCELL_ROW_32_765 VGND VPWR sky130_fd_sc_hd__tapvpwrvgnd_1
XFILLER_119_124 VGND VGND VPWR VPWR sky130_fd_sc_hd__fill_1
X_09092_ net341 net413 VGND VGND VPWR VPWR _01578_ sky130_fd_sc_hd__and2b_1
X_08112_ _00451_ _00459_ _00458_ VGND VGND VPWR VPWR _00588_ sky130_fd_sc_hd__a21bo_1
XFILLER_30_781 VPWR VGND VPWR VGND sky130_ef_sc_hd__decap_12
XFILLER_135_617 VPWR VGND VPWR VGND sky130_ef_sc_hd__decap_12
XFILLER_135_606 VGND VGND VPWR VPWR sky130_fd_sc_hd__fill_1
XFILLER_119_39 VPWR VGND VPWR VGND sky130_ef_sc_hd__decap_12
X_08043_ _00260_ _00398_ _00258_ VGND VGND VPWR VPWR _00520_ sky130_fd_sc_hd__a21o_1
XFILLER_115_341 VGND VGND VPWR VPWR sky130_fd_sc_hd__fill_1
XFILLER_135_27 VPWR VGND VPWR VGND sky130_ef_sc_hd__decap_12
X_09994_ _02359_ _02430_ _02429_ VGND VGND VPWR VPWR _02561_ sky130_fd_sc_hd__a21boi_1
XTAP_TAPCELL_ROW_73_1358 VGND VPWR sky130_fd_sc_hd__tapvpwrvgnd_1
X_08945_ _01414_ _01415_ _01412_ VGND VGND VPWR VPWR _01417_ sky130_fd_sc_hd__a21bo_1
XFILLER_88_269 VGND VGND VPWR VPWR sky130_fd_sc_hd__fill_1
XFILLER_69_461 VPWR VGND VPWR VGND sky130_ef_sc_hd__decap_12
X_08876_ _01339_ _01340_ _01199_ _01202_ VGND VGND VPWR VPWR _01342_ sky130_fd_sc_hd__o211a_1
XFILLER_96_291 VGND VGND VPWR VPWR sky130_fd_sc_hd__decap_3
XFILLER_96_280 VGND VGND VPWR VPWR sky130_fd_sc_hd__decap_6
XFILLER_57_645 VPWR VGND VPWR VGND sky130_ef_sc_hd__decap_12
XFILLER_72_604 VGND VGND VPWR VPWR sky130_fd_sc_hd__decap_3
X_07827_ net693 net545 _00154_ _00152_ VGND VGND VPWR VPWR _00305_ sky130_fd_sc_hd__a31o_1
XFILLER_84_475 VGND VGND VPWR VPWR sky130_fd_sc_hd__fill_1
X_07758_ _00235_ _00236_ VGND VGND VPWR VPWR _00237_ sky130_fd_sc_hd__nand2_1
XFILLER_71_136 VGND VGND VPWR VPWR sky130_fd_sc_hd__decap_8
XFILLER_25_520 VGND VGND VPWR VPWR sky130_fd_sc_hd__fill_2
XFILLER_71_169 VGND VGND VPWR VPWR sky130_fd_sc_hd__decap_8
XFILLER_25_553 VGND VGND VPWR VPWR sky130_fd_sc_hd__decap_6
X_07689_ _06741_ _00166_ VGND VGND VPWR VPWR _00168_ sky130_fd_sc_hd__xor2_1
X_09428_ _01942_ _01941_ VGND VGND VPWR VPWR _01944_ sky130_fd_sc_hd__nand2b_1
XFILLER_9_708 VGND VGND VPWR VPWR sky130_fd_sc_hd__fill_1
XFILLER_12_225 VGND VGND VPWR VPWR sky130_fd_sc_hd__fill_1
X_09359_ _01744_ _01779_ _01778_ VGND VGND VPWR VPWR _01869_ sky130_fd_sc_hd__a21o_1
XFILLER_100_41 VPWR VGND VPWR VGND sky130_ef_sc_hd__decap_12
XFILLER_40_556 VGND VGND VPWR VPWR sky130_fd_sc_hd__decap_4
XFILLER_138_433 VGND VGND VPWR VPWR sky130_fd_sc_hd__decap_4
XFILLER_100_85 VPWR VGND VPWR VGND sky130_ef_sc_hd__decap_12
X_12370_ net430 net391 net389 net439 VGND VGND VPWR VPWR _05147_ sky130_fd_sc_hd__a22o_1
XFILLER_40_589 VPWR VGND VPWR VGND sky130_ef_sc_hd__decap_12
XFILLER_121_3 VPWR VGND VPWR VGND sky130_ef_sc_hd__decap_12
XFILLER_60_89 VPWR VGND VPWR VGND sky130_ef_sc_hd__decap_12
XTAP_TAPCELL_ROW_10_437 VGND VPWR sky130_fd_sc_hd__tapvpwrvgnd_1
X_11321_ _03761_ _03857_ _03856_ VGND VGND VPWR VPWR _04007_ sky130_fd_sc_hd__a21bo_1
XTAP_TAPCELL_ROW_10_448 VGND VPWR sky130_fd_sc_hd__tapvpwrvgnd_1
XFILLER_125_105 VGND VGND VPWR VPWR sky130_fd_sc_hd__decap_6
XFILLER_106_341 VPWR VGND VPWR VGND sky130_ef_sc_hd__decap_12
X_11252_ _03929_ _03930_ VGND VGND VPWR VPWR _03931_ sky130_fd_sc_hd__nor2_1
X_10203_ _02785_ _02787_ VGND VGND VPWR VPWR _02788_ sky130_fd_sc_hd__xnor2_1
XFILLER_69_43 VPWR VGND VPWR VGND sky130_ef_sc_hd__decap_12
X_11183_ _03855_ _03854_ VGND VGND VPWR VPWR _03856_ sky130_fd_sc_hd__nand2b_1
X_10134_ _02711_ _02712_ VGND VGND VPWR VPWR _02713_ sky130_fd_sc_hd__nor2_1
XFILLER_79_247 VPWR VGND VPWR VGND sky130_ef_sc_hd__decap_12
XFILLER_79_225 VGND VGND VPWR VPWR sky130_fd_sc_hd__decap_8
XFILLER_95_729 VGND VGND VPWR VPWR sky130_fd_sc_hd__decap_8
XFILLER_0_663 VGND VGND VPWR VPWR sky130_fd_sc_hd__fill_1
X_10065_ _02463_ _02636_ VGND VGND VPWR VPWR _02638_ sky130_fd_sc_hd__and2_1
XFILLER_125_93 VPWR VGND VPWR VGND sky130_ef_sc_hd__decap_12
XFILLER_121_399 VGND VGND VPWR VPWR sky130_fd_sc_hd__fill_1
XFILLER_75_431 VGND VGND VPWR VPWR sky130_fd_sc_hd__decap_4
XFILLER_48_645 VPWR VGND VPWR VGND sky130_ef_sc_hd__decap_12
XFILLER_47_111 VGND VGND VPWR VPWR sky130_fd_sc_hd__fill_1
XFILLER_75_442 VGND VGND VPWR VPWR sky130_fd_sc_hd__decap_6
XFILLER_63_648 VGND VGND VPWR VPWR sky130_fd_sc_hd__decap_6
XTAP_TAPCELL_ROW_18_559 VGND VPWR sky130_fd_sc_hd__tapvpwrvgnd_1
XFILLER_62_169 VGND VGND VPWR VPWR sky130_fd_sc_hd__decap_6
XFILLER_50_309 VPWR VGND VPWR VGND sky130_ef_sc_hd__decap_12
XFILLER_43_361 VGND VGND VPWR VPWR sky130_fd_sc_hd__decap_3
X_10967_ _03613_ _03618_ VGND VGND VPWR VPWR _03619_ sky130_fd_sc_hd__and2_1
X_12706_ net386 net600 VGND VGND VPWR VPWR _05514_ sky130_fd_sc_hd__nand2b_1
X_13686_ clknet_3_3__leaf_clk _00007_ net713 VGND VGND VPWR VPWR net221 sky130_fd_sc_hd__dfrtp_1
X_10898_ _03541_ _03542_ VGND VGND VPWR VPWR _03544_ sky130_fd_sc_hd__nor2_1
X_12637_ _05436_ _05437_ VGND VGND VPWR VPWR _05438_ sky130_fd_sc_hd__xnor2_1
X_12568_ _05172_ _05192_ _05191_ VGND VGND VPWR VPWR _05364_ sky130_fd_sc_hd__a21boi_1
X_12499_ _05284_ net254 VGND VGND VPWR VPWR _05288_ sky130_fd_sc_hd__xnor2_1
XFILLER_7_273 VGND VGND VPWR VPWR sky130_fd_sc_hd__decap_6
X_11519_ net256 net274 _03427_ VGND VGND VPWR VPWR _04223_ sky130_fd_sc_hd__o21a_1
XFILLER_125_650 VGND VGND VPWR VPWR sky130_fd_sc_hd__decap_4
XTAP_TAPCELL_ROW_113_1937 VGND VPWR sky130_fd_sc_hd__tapvpwrvgnd_1
Xfanout709 net101 VGND VGND VPWR VPWR net709 sky130_fd_sc_hd__clkbuf_4
XFILLER_112_377 VPWR VGND VPWR VGND sky130_ef_sc_hd__decap_12
XFILLER_98_589 VPWR VGND VPWR VGND sky130_ef_sc_hd__decap_12
XFILLER_86_729 VGND VGND VPWR VPWR sky130_fd_sc_hd__fill_1
X_06991_ _03226_ _03183_ VGND VGND VPWR VPWR _03237_ sky130_fd_sc_hd__and2b_1
XTAP_TAPCELL_ROW_55_1099 VGND VPWR sky130_fd_sc_hd__tapvpwrvgnd_1
X_08730_ _01194_ _01195_ _01193_ VGND VGND VPWR VPWR _01197_ sky130_fd_sc_hd__a21bo_1
XFILLER_100_528 VGND VGND VPWR VPWR sky130_fd_sc_hd__decap_4
XFILLER_78_280 VGND VGND VPWR VPWR sky130_fd_sc_hd__decap_8
X_08661_ net350 _01078_ _01127_ VGND VGND VPWR VPWR _01128_ sky130_fd_sc_hd__a21bo_1
XFILLER_66_486 VGND VGND VPWR VPWR sky130_fd_sc_hd__fill_1
X_07612_ _06664_ _00091_ VGND VGND VPWR VPWR _00092_ sky130_fd_sc_hd__xnor2_1
X_08592_ _01019_ _01058_ VGND VGND VPWR VPWR _01060_ sky130_fd_sc_hd__xnor2_1
XFILLER_19_391 VGND VGND VPWR VPWR sky130_fd_sc_hd__fill_1
XTAP_TAPCELL_ROW_37_835 VGND VPWR sky130_fd_sc_hd__tapvpwrvgnd_1
Xclkbuf_3_5__f_clk clknet_0_clk VGND VGND VPWR VPWR clknet_3_5__leaf_clk sky130_fd_sc_hd__clkbuf_16
XFILLER_81_478 VGND VGND VPWR VPWR sky130_fd_sc_hd__decap_3
X_07543_ _06759_ _06771_ VGND VGND VPWR VPWR _06772_ sky130_fd_sc_hd__nand2_1
XFILLER_34_361 VGND VGND VPWR VPWR sky130_fd_sc_hd__decap_3
X_07474_ _06529_ _06547_ _06546_ VGND VGND VPWR VPWR _06704_ sky130_fd_sc_hd__a21boi_1
XFILLER_14_27 VGND VGND VPWR VPWR sky130_fd_sc_hd__fill_1
XFILLER_34_394 VGND VGND VPWR VPWR sky130_fd_sc_hd__fill_1
X_09213_ _01707_ _01708_ VGND VGND VPWR VPWR _01709_ sky130_fd_sc_hd__nand2b_1
X_09144_ net639 net633 net38 net371 VGND VGND VPWR VPWR _01634_ sky130_fd_sc_hd__nand4_1
XFILLER_22_589 VGND VGND VPWR VPWR sky130_fd_sc_hd__fill_1
X_09075_ _01393_ _01558_ VGND VGND VPWR VPWR _01559_ sky130_fd_sc_hd__xor2_1
XFILLER_107_105 VGND VGND VPWR VPWR sky130_fd_sc_hd__decap_6
XFILLER_30_15 VPWR VGND VPWR VGND sky130_ef_sc_hd__decap_12
X_08026_ _00383_ _00391_ _00390_ VGND VGND VPWR VPWR _00503_ sky130_fd_sc_hd__a21o_1
XFILLER_115_182 VPWR VGND VPWR VGND sky130_ef_sc_hd__decap_12
XFILLER_103_333 VGND VGND VPWR VPWR sky130_fd_sc_hd__decap_3
XFILLER_1_427 VGND VGND VPWR VPWR sky130_fd_sc_hd__decap_8
XFILLER_131_686 VPWR VGND VPWR VGND sky130_ef_sc_hd__decap_12
X_09977_ _02537_ _02541_ VGND VGND VPWR VPWR _02542_ sky130_fd_sc_hd__nand2b_1
XFILLER_39_57 VPWR VGND VPWR VGND sky130_ef_sc_hd__decap_12
X_08928_ _01130_ _01262_ _01397_ VGND VGND VPWR VPWR _01399_ sky130_fd_sc_hd__a21oi_1
XFILLER_29_122 VPWR VGND VPWR VGND sky130_ef_sc_hd__decap_12
X_08859_ _01166_ _01168_ _01167_ VGND VGND VPWR VPWR _01325_ sky130_fd_sc_hd__a21bo_1
XFILLER_72_412 VGND VGND VPWR VPWR sky130_fd_sc_hd__decap_8
XFILLER_57_464 VGND VGND VPWR VPWR sky130_fd_sc_hd__fill_1
XFILLER_45_615 VGND VGND VPWR VPWR sky130_fd_sc_hd__fill_1
XTAP_TAPCELL_ROW_86_1549 VGND VPWR sky130_fd_sc_hd__tapvpwrvgnd_1
XFILLER_72_456 VGND VGND VPWR VPWR sky130_fd_sc_hd__decap_6
X_11870_ _04601_ _04603_ VGND VGND VPWR VPWR _04605_ sky130_fd_sc_hd__xor2_1
X_10821_ net457 net273 _03455_ VGND VGND VPWR VPWR _03460_ sky130_fd_sc_hd__and3_1
XFILLER_32_309 VGND VGND VPWR VPWR sky130_fd_sc_hd__decap_8
X_13540_ _06420_ _06422_ VGND VGND VPWR VPWR _06424_ sky130_fd_sc_hd__xnor2_1
X_10752_ _03383_ _03382_ VGND VGND VPWR VPWR _03384_ sky130_fd_sc_hd__nand2b_1
XTAP_TAPCELL_ROW_15_518 VGND VPWR sky130_fd_sc_hd__tapvpwrvgnd_1
X_13471_ _06346_ _06347_ VGND VGND VPWR VPWR _06349_ sky130_fd_sc_hd__xnor2_1
XFILLER_71_55 VGND VGND VPWR VPWR sky130_fd_sc_hd__fill_1
XFILLER_9_505 VPWR VGND VPWR VGND sky130_ef_sc_hd__decap_12
X_12422_ _05048_ _05050_ _05202_ _05203_ VGND VGND VPWR VPWR _05204_ sky130_fd_sc_hd__o211a_1
XFILLER_13_578 VPWR VGND VPWR VGND sky130_ef_sc_hd__decap_12
X_10683_ _03305_ _03308_ VGND VGND VPWR VPWR _03309_ sky130_fd_sc_hd__nand2_1
X_12353_ net531 net396 _04985_ VGND VGND VPWR VPWR _05128_ sky130_fd_sc_hd__a21o_1
XFILLER_5_722 VGND VGND VPWR VPWR sky130_fd_sc_hd__decap_6
XFILLER_126_469 VGND VGND VPWR VPWR sky130_fd_sc_hd__decap_6
XFILLER_114_609 VGND VGND VPWR VPWR sky130_fd_sc_hd__fill_2
X_12284_ _04900_ _04902_ _05051_ _05052_ VGND VGND VPWR VPWR _05053_ sky130_fd_sc_hd__o211a_4
XFILLER_4_210 VGND VGND VPWR VPWR sky130_fd_sc_hd__fill_1
X_11304_ _03982_ _03987_ VGND VGND VPWR VPWR _03988_ sky130_fd_sc_hd__xor2_1
XFILLER_5_777 VGND VGND VPWR VPWR sky130_fd_sc_hd__decap_6
XFILLER_4_265 VPWR VGND VPWR VGND sky130_ef_sc_hd__decap_12
XFILLER_4_243 VGND VGND VPWR VPWR sky130_fd_sc_hd__fill_1
X_11235_ _03909_ _03910_ VGND VGND VPWR VPWR _03912_ sky130_fd_sc_hd__xnor2_1
XFILLER_122_631 VGND VGND VPWR VPWR sky130_fd_sc_hd__fill_1
XFILLER_96_41 VPWR VGND VPWR VGND sky130_ef_sc_hd__decap_12
X_11166_ net315 _00259_ _00261_ VGND VGND VPWR VPWR _03837_ sky130_fd_sc_hd__nand3_1
XFILLER_121_174 VPWR VGND VPWR VGND sky130_ef_sc_hd__decap_12
X_10117_ _02687_ _02693_ VGND VGND VPWR VPWR _02694_ sky130_fd_sc_hd__xnor2_1
XFILLER_96_85 VPWR VGND VPWR VGND sky130_ef_sc_hd__decap_12
X_11097_ _03719_ _03759_ VGND VGND VPWR VPWR _03761_ sky130_fd_sc_hd__xnor2_1
XTAP_TAPCELL_ROW_128_2155 VGND VPWR sky130_fd_sc_hd__tapvpwrvgnd_1
X_10048_ _02617_ _02618_ VGND VGND VPWR VPWR _02620_ sky130_fd_sc_hd__nand2b_1
XFILLER_95_559 VGND VGND VPWR VPWR sky130_fd_sc_hd__fill_1
XFILLER_76_740 VGND VGND VPWR VPWR sky130_fd_sc_hd__fill_1
XFILLER_91_732 VPWR VGND VPWR VGND sky130_ef_sc_hd__decap_12
XFILLER_90_253 VGND VGND VPWR VPWR sky130_fd_sc_hd__decap_3
XFILLER_35_169 VPWR VGND VPWR VGND sky130_ef_sc_hd__decap_12
X_11999_ _04739_ _04741_ VGND VGND VPWR VPWR _04742_ sky130_fd_sc_hd__nor2_1
XFILLER_50_139 VGND VGND VPWR VPWR sky130_fd_sc_hd__fill_1
XFILLER_50_117 VGND VGND VPWR VPWR sky130_fd_sc_hd__decap_3
XFILLER_16_372 VGND VGND VPWR VPWR sky130_fd_sc_hd__fill_1
XFILLER_84_3 VPWR VGND VPWR VGND sky130_ef_sc_hd__decap_12
X_13669_ clknet_3_1__leaf_clk _00001_ net712 VGND VGND VPWR VPWR net204 sky130_fd_sc_hd__dfrtp_1
X_07190_ _04547_ _05363_ _05385_ VGND VGND VPWR VPWR _05406_ sky130_fd_sc_hd__or3_4
XFILLER_117_436 VPWR VGND VPWR VGND sky130_ef_sc_hd__decap_12
XTAP_TAPCELL_ROW_57_1128 VGND VPWR sky130_fd_sc_hd__tapvpwrvgnd_1
X_09900_ _02355_ _02357_ _02457_ VGND VGND VPWR VPWR _02458_ sky130_fd_sc_hd__o21ba_1
XFILLER_6_83 VGND VGND VPWR VPWR sky130_fd_sc_hd__fill_1
XFILLER_116_29 VPWR VGND VPWR VGND sky130_ef_sc_hd__decap_12
Xfanout506 net509 VGND VGND VPWR VPWR net506 sky130_fd_sc_hd__clkbuf_4
Xfanout517 net518 VGND VGND VPWR VPWR net517 sky130_fd_sc_hd__clkbuf_2
X_09831_ _02379_ _02381_ VGND VGND VPWR VPWR _02384_ sky130_fd_sc_hd__xor2_1
Xfanout539 net542 VGND VGND VPWR VPWR net539 sky130_fd_sc_hd__buf_2
XFILLER_86_504 VPWR VGND VPWR VGND sky130_ef_sc_hd__decap_12
XTAP_TAPCELL_ROW_70_1317 VGND VPWR sky130_fd_sc_hd__tapvpwrvgnd_1
XFILLER_59_729 VPWR VGND VPWR VGND sky130_ef_sc_hd__decap_12
XFILLER_59_707 VPWR VGND VPWR VGND sky130_ef_sc_hd__decap_12
Xfanout528 net146 VGND VGND VPWR VPWR net528 sky130_fd_sc_hd__buf_4
X_09762_ _02073_ _02163_ _02161_ VGND VGND VPWR VPWR _02309_ sky130_fd_sc_hd__a21oi_2
XFILLER_112_174 VGND VGND VPWR VPWR sky130_fd_sc_hd__fill_1
X_06974_ _01703_ _02140_ _02488_ VGND VGND VPWR VPWR _03052_ sky130_fd_sc_hd__o21bai_1
X_08713_ net639 net378 _01033_ _01032_ VGND VGND VPWR VPWR _01180_ sky130_fd_sc_hd__a31o_1
XFILLER_39_431 VGND VGND VPWR VPWR sky130_fd_sc_hd__fill_2
X_09693_ net496 net343 VGND VGND VPWR VPWR _02233_ sky130_fd_sc_hd__nand2_1
XFILLER_94_581 VGND VGND VPWR VPWR sky130_fd_sc_hd__decap_6
XFILLER_66_261 VGND VGND VPWR VPWR sky130_fd_sc_hd__fill_2
XFILLER_39_475 VGND VGND VPWR VPWR sky130_fd_sc_hd__decap_4
X_08644_ _01107_ _01109_ VGND VGND VPWR VPWR _01111_ sky130_fd_sc_hd__nor2_1
X_08575_ net455 net341 net339 net463 VGND VGND VPWR VPWR _01043_ sky130_fd_sc_hd__a22oi_1
XFILLER_82_765 VGND VGND VPWR VPWR sky130_fd_sc_hd__fill_1
XTAP_TAPCELL_ROW_68_1279 VGND VPWR sky130_fd_sc_hd__tapvpwrvgnd_1
XFILLER_25_15 VPWR VGND VPWR VGND sky130_ef_sc_hd__decap_12
X_07526_ _06594_ _06596_ _06753_ VGND VGND VPWR VPWR _06755_ sky130_fd_sc_hd__nand3_1
XTAP_TAPCELL_ROW_81_1468 VGND VPWR sky130_fd_sc_hd__tapvpwrvgnd_1
XTAP_TAPCELL_ROW_81_1479 VGND VPWR sky130_fd_sc_hd__tapvpwrvgnd_1
X_07457_ net650 net704 net411 VGND VGND VPWR VPWR _06687_ sky130_fd_sc_hd__a21oi_1
XFILLER_50_695 VGND VGND VPWR VPWR sky130_fd_sc_hd__decap_4
X_07388_ _06601_ _06617_ VGND VGND VPWR VPWR _06618_ sky130_fd_sc_hd__xnor2_1
X_09127_ _01611_ _01612_ _01614_ VGND VGND VPWR VPWR _01615_ sky130_fd_sc_hd__a21o_1
XFILLER_41_69 VPWR VGND VPWR VGND sky130_ef_sc_hd__decap_12
X_09058_ _01539_ _01538_ VGND VGND VPWR VPWR _01541_ sky130_fd_sc_hd__nand2b_1
XFILLER_135_233 VPWR VGND VPWR VGND sky130_ef_sc_hd__decap_12
XTAP_TAPCELL_ROW_20_587 VGND VPWR sky130_fd_sc_hd__tapvpwrvgnd_1
XFILLER_123_406 VGND VGND VPWR VPWR sky130_fd_sc_hd__fill_1
X_08009_ net669 _06801_ _06803_ _00353_ VGND VGND VPWR VPWR _00486_ sky130_fd_sc_hd__a2bb2o_1
XFILLER_104_620 VGND VGND VPWR VPWR sky130_fd_sc_hd__decap_3
XFILLER_89_320 VPWR VGND VPWR VGND sky130_ef_sc_hd__decap_12
XFILLER_2_769 VPWR VGND VPWR VGND sky130_ef_sc_hd__decap_12
X_11020_ _03493_ _03496_ _03495_ VGND VGND VPWR VPWR _03678_ sky130_fd_sc_hd__a21o_1
XFILLER_77_515 VGND VGND VPWR VPWR sky130_fd_sc_hd__decap_8
XFILLER_92_507 VGND VGND VPWR VPWR sky130_fd_sc_hd__decap_8
XFILLER_77_559 VGND VGND VPWR VPWR sky130_fd_sc_hd__fill_1
X_12971_ _05797_ _05802_ VGND VGND VPWR VPWR _05803_ sky130_fd_sc_hd__and2_1
XFILLER_45_401 VGND VGND VPWR VPWR sky130_fd_sc_hd__fill_1
XFILLER_73_732 VPWR VGND VPWR VGND sky130_ef_sc_hd__decap_12
XFILLER_66_99 VGND VGND VPWR VPWR sky130_fd_sc_hd__decap_4
X_11922_ _04621_ _04660_ VGND VGND VPWR VPWR _00019_ sky130_fd_sc_hd__xnor2_1
XFILLER_18_637 VGND VGND VPWR VPWR sky130_fd_sc_hd__decap_6
XFILLER_122_83 VGND VGND VPWR VPWR sky130_fd_sc_hd__fill_1
XFILLER_72_253 VGND VGND VPWR VPWR sky130_fd_sc_hd__decap_4
X_11853_ _04581_ _04584_ VGND VGND VPWR VPWR _04586_ sky130_fd_sc_hd__xnor2_2
XFILLER_17_158 VGND VGND VPWR VPWR sky130_fd_sc_hd__decap_3
XFILLER_17_169 VGND VGND VPWR VPWR sky130_fd_sc_hd__fill_2
XTAP_TAPCELL_ROW_123_2085 VGND VPWR sky130_fd_sc_hd__tapvpwrvgnd_1
XFILLER_82_65 VPWR VGND VPWR VGND sky130_ef_sc_hd__decap_12
XFILLER_72_297 VGND VGND VPWR VPWR sky130_fd_sc_hd__decap_8
XFILLER_72_275 VGND VGND VPWR VPWR sky130_fd_sc_hd__decap_8
XTAP_TAPCELL_ROW_0_290 VGND VPWR sky130_fd_sc_hd__tapvpwrvgnd_1
XFILLER_14_821 VGND VGND VPWR VPWR sky130_fd_sc_hd__decap_3
X_10804_ _03438_ _03439_ _03435_ VGND VGND VPWR VPWR _03441_ sky130_fd_sc_hd__a21oi_1
XTAP_TAPCELL_ROW_28_698 VGND VPWR sky130_fd_sc_hd__tapvpwrvgnd_1
XFILLER_33_629 VPWR VGND VPWR VGND sky130_ef_sc_hd__decap_12
X_11784_ _04509_ _04510_ VGND VGND VPWR VPWR _04511_ sky130_fd_sc_hd__nand2_1
XFILLER_13_331 VGND VGND VPWR VPWR sky130_fd_sc_hd__fill_1
XFILLER_32_139 VGND VGND VPWR VPWR sky130_fd_sc_hd__fill_1
X_13523_ _06403_ _06404_ VGND VGND VPWR VPWR _06406_ sky130_fd_sc_hd__and2_1
XFILLER_41_673 VPWR VGND VPWR VGND sky130_ef_sc_hd__decap_12
X_10735_ net537 net310 VGND VGND VPWR VPWR _03365_ sky130_fd_sc_hd__nand2_1
XFILLER_13_375 VGND VGND VPWR VPWR sky130_fd_sc_hd__fill_2
XFILLER_15_92 VPWR VGND VPWR VGND sky130_ef_sc_hd__decap_12
XTAP_TAPCELL_ROW_99_1729 VGND VPWR sky130_fd_sc_hd__tapvpwrvgnd_1
X_13454_ _06259_ _06272_ _06271_ VGND VGND VPWR VPWR _06330_ sky130_fd_sc_hd__a21o_1
X_10666_ net457 net450 net277 net275 VGND VGND VPWR VPWR _03290_ sky130_fd_sc_hd__and4_1
X_13385_ _06253_ _06254_ VGND VGND VPWR VPWR _06255_ sky130_fd_sc_hd__xnor2_1
X_12405_ _05182_ _05183_ _05184_ VGND VGND VPWR VPWR _05185_ sky130_fd_sc_hd__nand3_1
XFILLER_127_767 VPWR VGND VPWR VGND sky130_ef_sc_hd__decap_12
X_10597_ _03212_ _03213_ VGND VGND VPWR VPWR _03214_ sky130_fd_sc_hd__xnor2_1
XFILLER_114_406 VGND VGND VPWR VPWR sky130_fd_sc_hd__decap_8
X_12336_ _05072_ _05108_ VGND VGND VPWR VPWR _05109_ sky130_fd_sc_hd__xnor2_1
XFILLER_114_428 VGND VGND VPWR VPWR sky130_fd_sc_hd__decap_3
X_12267_ _05032_ _05031_ _05023_ VGND VGND VPWR VPWR _05034_ sky130_fd_sc_hd__a21o_1
XFILLER_96_813 VGND VGND VPWR VPWR sky130_fd_sc_hd__decap_4
X_12198_ _04955_ _04957_ VGND VGND VPWR VPWR _04959_ sky130_fd_sc_hd__nand2_1
X_11218_ _03889_ _03892_ VGND VGND VPWR VPWR _03894_ sky130_fd_sc_hd__xnor2_1
XTAP_TAPCELL_ROW_52_1058 VGND VPWR sky130_fd_sc_hd__tapvpwrvgnd_1
XTAP_TAPCELL_ROW_52_1047 VGND VPWR sky130_fd_sc_hd__tapvpwrvgnd_1
X_11149_ _03801_ _03818_ VGND VGND VPWR VPWR _03819_ sky130_fd_sc_hd__xor2_1
XFILLER_83_518 VGND VGND VPWR VPWR sky130_fd_sc_hd__fill_1
XFILLER_64_710 VGND VGND VPWR VPWR sky130_fd_sc_hd__fill_2
XTAP_TAPCELL_ROW_108_1858 VGND VPWR sky130_fd_sc_hd__tapvpwrvgnd_1
XTAP_TAPCELL_ROW_108_1869 VGND VPWR sky130_fd_sc_hd__tapvpwrvgnd_1
XTAP_TAPCELL_ROW_47_974 VGND VPWR sky130_fd_sc_hd__tapvpwrvgnd_1
XFILLER_91_595 VGND VGND VPWR VPWR sky130_fd_sc_hd__decap_4
X_08360_ _00826_ _00832_ VGND VGND VPWR VPWR _00834_ sky130_fd_sc_hd__xnor2_1
XFILLER_51_437 VGND VGND VPWR VPWR sky130_fd_sc_hd__fill_1
XTAP_TAPCELL_ROW_47_985 VGND VPWR sky130_fd_sc_hd__tapvpwrvgnd_1
XFILLER_17_692 VGND VGND VPWR VPWR sky130_fd_sc_hd__decap_8
X_07311_ _06538_ _06539_ _06540_ VGND VGND VPWR VPWR _06542_ sky130_fd_sc_hd__a21o_1
X_08291_ _06803_ _00765_ VGND VGND VPWR VPWR _00766_ sky130_fd_sc_hd__xnor2_1
XFILLER_20_813 VGND VGND VPWR VPWR sky130_fd_sc_hd__decap_8
X_07242_ _04718_ _04729_ _04761_ VGND VGND VPWR VPWR _05974_ sky130_fd_sc_hd__a21oi_1
XFILLER_118_701 VGND VGND VPWR VPWR sky130_fd_sc_hd__fill_2
X_07173_ _05166_ _05177_ _05188_ VGND VGND VPWR VPWR _05220_ sky130_fd_sc_hd__a21oi_1
XFILLER_11_39 VPWR VGND VPWR VGND sky130_ef_sc_hd__decap_12
XFILLER_127_39 VPWR VGND VPWR VGND sky130_ef_sc_hd__decap_12
XFILLER_117_277 VGND VGND VPWR VPWR sky130_fd_sc_hd__decap_3
XFILLER_105_406 VGND VGND VPWR VPWR sky130_fd_sc_hd__decap_3
XFILLER_105_439 VGND VGND VPWR VPWR sky130_fd_sc_hd__decap_8
XFILLER_99_673 VPWR VGND VPWR VGND sky130_ef_sc_hd__decap_12
Xfanout303 net8 VGND VGND VPWR VPWR net303 sky130_fd_sc_hd__clkbuf_4
Xfanout314 net73 VGND VGND VPWR VPWR net314 sky130_fd_sc_hd__buf_2
X_09814_ net479 net344 net342 net488 VGND VGND VPWR VPWR _02365_ sky130_fd_sc_hd__a22o_1
Xfanout347 net54 VGND VGND VPWR VPWR net347 sky130_fd_sc_hd__buf_2
Xfanout336 net60 VGND VGND VPWR VPWR net336 sky130_fd_sc_hd__clkbuf_4
Xfanout325 net67 VGND VGND VPWR VPWR net325 sky130_fd_sc_hd__clkbuf_4
Xfanout358 net47 VGND VGND VPWR VPWR net358 sky130_fd_sc_hd__dlymetal6s2s_1
Xfanout369 net4 VGND VGND VPWR VPWR net369 sky130_fd_sc_hd__clkbuf_4
X_09745_ _02284_ _02289_ VGND VGND VPWR VPWR _02290_ sky130_fd_sc_hd__and2b_1
XFILLER_100_177 VGND VGND VPWR VPWR sky130_fd_sc_hd__fill_2
XFILLER_55_710 VGND VGND VPWR VPWR sky130_fd_sc_hd__fill_1
X_06957_ _02565_ _02844_ VGND VGND VPWR VPWR _02866_ sky130_fd_sc_hd__xnor2_1
X_09676_ _02206_ _02213_ VGND VGND VPWR VPWR _02214_ sky130_fd_sc_hd__xnor2_1
X_06888_ _02085_ _02096_ VGND VGND VPWR VPWR _02118_ sky130_fd_sc_hd__xor2_1
X_08627_ net566 net557 net42 net365 VGND VGND VPWR VPWR _01094_ sky130_fd_sc_hd__and4_1
XTAP_TAPCELL_ROW_83_1508 VGND VPWR sky130_fd_sc_hd__tapvpwrvgnd_1
XFILLER_70_713 VPWR VGND VPWR VGND sky130_ef_sc_hd__decap_12
XFILLER_54_253 VGND VGND VPWR VPWR sky130_fd_sc_hd__decap_8
X_08558_ net596 net586 net366 net364 VGND VGND VPWR VPWR _01027_ sky130_fd_sc_hd__and4_1
XFILLER_70_757 VPWR VGND VPWR VGND sky130_ef_sc_hd__decap_12
XFILLER_42_459 VGND VGND VPWR VPWR sky130_fd_sc_hd__fill_1
XFILLER_14_139 VGND VGND VPWR VPWR sky130_fd_sc_hd__fill_1
XTAP_TAPCELL_ROW_25_657 VGND VPWR sky130_fd_sc_hd__tapvpwrvgnd_1
XFILLER_10_301 VGND VGND VPWR VPWR sky130_fd_sc_hd__decap_6
XFILLER_23_673 VGND VGND VPWR VPWR sky130_fd_sc_hd__fill_2
XTAP_TAPCELL_ROW_25_668 VGND VPWR sky130_fd_sc_hd__tapvpwrvgnd_1
X_08489_ _00959_ _00960_ VGND VGND VPWR VPWR _00962_ sky130_fd_sc_hd__nand2b_1
X_07509_ _06736_ _06737_ VGND VGND VPWR VPWR _06738_ sky130_fd_sc_hd__nor2_1
X_10520_ _03130_ _03107_ VGND VGND VPWR VPWR _03131_ sky130_fd_sc_hd__and2b_1
X_10451_ net562 net74 _02937_ VGND VGND VPWR VPWR _03056_ sky130_fd_sc_hd__a21o_1
XFILLER_10_389 VGND VGND VPWR VPWR sky130_fd_sc_hd__fill_2
XFILLER_124_726 VGND VGND VPWR VPWR sky130_fd_sc_hd__decap_6
X_13170_ _06017_ _06019_ VGND VGND VPWR VPWR _06021_ sky130_fd_sc_hd__xor2_2
X_10382_ _02977_ _02979_ VGND VGND VPWR VPWR _02980_ sky130_fd_sc_hd__and2_1
XFILLER_123_225 VGND VGND VPWR VPWR sky130_fd_sc_hd__fill_1
XTAP_TAPCELL_ROW_94_1659 VGND VPWR sky130_fd_sc_hd__tapvpwrvgnd_1
X_12121_ _04865_ _04866_ _04874_ VGND VGND VPWR VPWR _04875_ sky130_fd_sc_hd__and3_1
X_12052_ _04771_ _04773_ _04798_ VGND VGND VPWR VPWR _04799_ sky130_fd_sc_hd__or3_1
XFILLER_78_813 VGND VGND VPWR VPWR sky130_fd_sc_hd__decap_4
XFILLER_132_781 VPWR VGND VPWR VGND sky130_ef_sc_hd__decap_12
XFILLER_104_483 VGND VGND VPWR VPWR sky130_fd_sc_hd__fill_1
XFILLER_104_461 VGND VGND VPWR VPWR sky130_fd_sc_hd__decap_3
X_11003_ _03457_ _03657_ VGND VGND VPWR VPWR _03659_ sky130_fd_sc_hd__xnor2_1
XFILLER_131_291 VPWR VGND VPWR VGND sky130_ef_sc_hd__decap_12
XFILLER_77_334 VGND VGND VPWR VPWR sky130_fd_sc_hd__fill_2
XTAP_TAPCELL_ROW_125_2114 VGND VPWR sky130_fd_sc_hd__tapvpwrvgnd_1
XFILLER_58_570 VPWR VGND VPWR VGND sky130_ef_sc_hd__decap_12
XTAP_TAPCELL_ROW_5_371 VGND VPWR sky130_fd_sc_hd__tapvpwrvgnd_1
XFILLER_133_93 VPWR VGND VPWR VGND sky130_ef_sc_hd__decap_12
X_12954_ net259 net400 VGND VGND VPWR VPWR _05784_ sky130_fd_sc_hd__nor2_1
XFILLER_18_412 VGND VGND VPWR VPWR sky130_fd_sc_hd__fill_1
X_11905_ _04640_ _04641_ VGND VGND VPWR VPWR _04642_ sky130_fd_sc_hd__xnor2_1
XFILLER_93_97 VGND VGND VPWR VPWR sky130_fd_sc_hd__decap_6
X_12885_ _05677_ _05708_ VGND VGND VPWR VPWR _05709_ sky130_fd_sc_hd__xnor2_1
XFILLER_60_201 VGND VGND VPWR VPWR sky130_fd_sc_hd__fill_1
XTAP_TAPCELL_ROW_44_933 VGND VPWR sky130_fd_sc_hd__tapvpwrvgnd_1
XFILLER_18_489 VGND VGND VPWR VPWR sky130_fd_sc_hd__fill_2
XTAP_TAPCELL_ROW_44_944 VGND VPWR sky130_fd_sc_hd__tapvpwrvgnd_1
XFILLER_14_640 VGND VGND VPWR VPWR sky130_fd_sc_hd__decap_4
X_11836_ _04454_ _04457_ _04566_ VGND VGND VPWR VPWR _04567_ sky130_fd_sc_hd__o21a_1
XFILLER_26_91 VGND VGND VPWR VPWR sky130_fd_sc_hd__fill_1
XTAP_TAPCELL_ROW_103_1788 VGND VPWR sky130_fd_sc_hd__tapvpwrvgnd_1
X_11767_ _04379_ _04409_ _04378_ VGND VGND VPWR VPWR _04492_ sky130_fd_sc_hd__a21oi_1
XTAP_TAPCELL_ROW_103_1799 VGND VPWR sky130_fd_sc_hd__tapvpwrvgnd_1
X_13506_ _06360_ _06385_ VGND VGND VPWR VPWR _06387_ sky130_fd_sc_hd__xnor2_1
XFILLER_9_110 VGND VGND VPWR VPWR sky130_fd_sc_hd__fill_2
XFILLER_13_172 VGND VGND VPWR VPWR sky130_fd_sc_hd__decap_8
X_10718_ _03346_ VGND VGND VPWR VPWR _03348_ sky130_fd_sc_hd__inv_2
X_11698_ _04414_ _04415_ VGND VGND VPWR VPWR _04418_ sky130_fd_sc_hd__xor2_1
XTAP_TAPCELL_ROW_136_2276 VGND VPWR sky130_fd_sc_hd__tapvpwrvgnd_1
XTAP_TAPCELL_ROW_136_2265 VGND VPWR sky130_fd_sc_hd__tapvpwrvgnd_1
Xrebuffer2 _01329_ VGND VGND VPWR VPWR net721 sky130_fd_sc_hd__dlymetal6s2s_1
X_13437_ _06304_ _06310_ VGND VGND VPWR VPWR _06311_ sky130_fd_sc_hd__and2b_1
X_10649_ _02951_ _03123_ _03122_ VGND VGND VPWR VPWR _03272_ sky130_fd_sc_hd__a21o_1
X_13368_ net418 _06131_ VGND VGND VPWR VPWR _06237_ sky130_fd_sc_hd__and2_1
XFILLER_127_597 VPWR VGND VPWR VGND sky130_ef_sc_hd__decap_12
X_12319_ net583 net422 VGND VGND VPWR VPWR _05091_ sky130_fd_sc_hd__nand2_1
XFILLER_114_247 VGND VGND VPWR VPWR sky130_fd_sc_hd__decap_4
X_13299_ _05735_ _06025_ _06024_ VGND VGND VPWR VPWR _06162_ sky130_fd_sc_hd__a21oi_2
XFILLER_87_109 VGND VGND VPWR VPWR sky130_fd_sc_hd__decap_3
XFILLER_47_3 VPWR VGND VPWR VGND sky130_ef_sc_hd__decap_12
XFILLER_68_301 VGND VGND VPWR VPWR sky130_fd_sc_hd__decap_6
X_07860_ net681 net484 net475 net682 VGND VGND VPWR VPWR _00338_ sky130_fd_sc_hd__a22oi_1
XFILLER_3_51 VGND VGND VPWR VPWR sky130_fd_sc_hd__decap_4
XFILLER_110_453 VGND VGND VPWR VPWR sky130_fd_sc_hd__decap_6
XFILLER_83_315 VGND VGND VPWR VPWR sky130_fd_sc_hd__decap_4
XFILLER_68_389 VPWR VGND VPWR VGND sky130_ef_sc_hd__decap_12
X_07791_ _00267_ _00268_ VGND VGND VPWR VPWR _00270_ sky130_fd_sc_hd__xnor2_2
XFILLER_28_209 VPWR VGND VPWR VGND sky130_ef_sc_hd__decap_12
X_09530_ _01918_ _01929_ _01928_ VGND VGND VPWR VPWR _02055_ sky130_fd_sc_hd__a21o_1
XFILLER_37_721 VGND VGND VPWR VPWR sky130_fd_sc_hd__decap_6
X_09461_ _01973_ _01979_ VGND VGND VPWR VPWR _01980_ sky130_fd_sc_hd__and2b_1
XFILLER_36_253 VGND VGND VPWR VPWR sky130_fd_sc_hd__decap_6
XTAP_TAPCELL_ROW_65_1238 VGND VPWR sky130_fd_sc_hd__tapvpwrvgnd_1
X_09392_ _01901_ _01902_ VGND VGND VPWR VPWR _01905_ sky130_fd_sc_hd__xor2_1
XFILLER_52_757 VPWR VGND VPWR VGND sky130_ef_sc_hd__decap_12
X_08412_ _00884_ _00885_ VGND VGND VPWR VPWR _00886_ sky130_fd_sc_hd__nand2b_1
X_08343_ _00813_ _00816_ VGND VGND VPWR VPWR _00817_ sky130_fd_sc_hd__xor2_1
XFILLER_51_278 VGND VGND VPWR VPWR sky130_fd_sc_hd__fill_2
XTAP_TAPCELL_ROW_22_616 VGND VPWR sky130_fd_sc_hd__tapvpwrvgnd_1
X_08274_ _00739_ _00748_ VGND VGND VPWR VPWR _00749_ sky130_fd_sc_hd__nand2_1
XFILLER_20_621 VPWR VGND VPWR VGND sky130_ef_sc_hd__decap_12
XFILLER_22_27 VGND VGND VPWR VPWR sky130_fd_sc_hd__fill_1
X_07225_ _05766_ _05777_ VGND VGND VPWR VPWR _05788_ sky130_fd_sc_hd__and2b_1
XFILLER_138_27 VGND VGND VPWR VPWR sky130_fd_sc_hd__fill_1
XFILLER_20_698 VGND VGND VPWR VPWR sky130_fd_sc_hd__fill_2
X_07156_ net267 net100 net632 net622 VGND VGND VPWR VPWR _05035_ sky130_fd_sc_hd__and4_1
XFILLER_118_586 VGND VGND VPWR VPWR sky130_fd_sc_hd__fill_2
XFILLER_106_737 VPWR VGND VPWR VGND sky130_ef_sc_hd__decap_12
XFILLER_105_225 VPWR VGND VPWR VGND sky130_ef_sc_hd__decap_12
XFILLER_105_203 VGND VGND VPWR VPWR sky130_fd_sc_hd__decap_8
X_07087_ net700 net561 net553 net701 VGND VGND VPWR VPWR _04286_ sky130_fd_sc_hd__a22oi_1
XFILLER_105_247 VGND VGND VPWR VPWR sky130_fd_sc_hd__fill_2
XFILLER_120_228 VGND VGND VPWR VPWR sky130_fd_sc_hd__decap_4
X_09728_ _02258_ _02270_ VGND VGND VPWR VPWR _02272_ sky130_fd_sc_hd__xnor2_2
XFILLER_86_197 VPWR VGND VPWR VGND sky130_ef_sc_hd__decap_12
XFILLER_86_186 VGND VGND VPWR VPWR sky130_fd_sc_hd__fill_1
XFILLER_74_348 VPWR VGND VPWR VGND sky130_ef_sc_hd__decap_12
XFILLER_47_57 VPWR VGND VPWR VGND sky130_ef_sc_hd__decap_12
X_07989_ _00435_ _00465_ VGND VGND VPWR VPWR _00466_ sky130_fd_sc_hd__and2b_1
XTAP_TAPCELL_ROW_2_330 VGND VPWR sky130_fd_sc_hd__tapvpwrvgnd_1
XPHY_EDGE_ROW_29_Right_29 VGND VGND VPWR VPWR sky130_fd_sc_hd__decap_3
XFILLER_90_819 VGND VGND VPWR VPWR sky130_fd_sc_hd__fill_1
XFILLER_43_702 VGND VGND VPWR VPWR sky130_fd_sc_hd__decap_8
X_09659_ _02195_ VGND VGND VPWR VPWR _02196_ sky130_fd_sc_hd__inv_2
XTAP_TAPCELL_ROW_120_2044 VGND VPWR sky130_fd_sc_hd__tapvpwrvgnd_1
XTAP_TAPCELL_ROW_120_2033 VGND VPWR sky130_fd_sc_hd__tapvpwrvgnd_1
X_12670_ net254 _05473_ VGND VGND VPWR VPWR _05475_ sky130_fd_sc_hd__xnor2_1
X_11621_ _04191_ _04194_ _04332_ VGND VGND VPWR VPWR _04333_ sky130_fd_sc_hd__a21oi_1
XFILLER_8_29 VPWR VGND VPWR VGND sky130_ef_sc_hd__decap_12
XFILLER_128_306 VGND VGND VPWR VPWR sky130_fd_sc_hd__fill_2
XFILLER_7_614 VGND VGND VPWR VPWR sky130_fd_sc_hd__fill_2
X_11552_ _04246_ _04257_ VGND VGND VPWR VPWR _04258_ sky130_fd_sc_hd__xnor2_1
XPHY_EDGE_ROW_38_Right_38 VGND VGND VPWR VPWR sky130_fd_sc_hd__decap_3
X_11483_ _04175_ _04182_ VGND VGND VPWR VPWR _04183_ sky130_fd_sc_hd__xor2_1
XFILLER_10_186 VGND VGND VPWR VPWR sky130_fd_sc_hd__decap_8
XFILLER_11_687 VGND VGND VPWR VPWR sky130_fd_sc_hd__fill_2
X_10503_ _03109_ _03110_ _03111_ VGND VGND VPWR VPWR _03112_ sky130_fd_sc_hd__or3_1
X_13222_ net487 net478 net396 net395 VGND VGND VPWR VPWR _06077_ sky130_fd_sc_hd__and4_1
XFILLER_10_197 VGND VGND VPWR VPWR sky130_fd_sc_hd__decap_4
X_10434_ _02960_ _03035_ _03036_ VGND VGND VPWR VPWR _03037_ sky130_fd_sc_hd__nor3_1
X_13153_ _05994_ _06000_ VGND VGND VPWR VPWR _06002_ sky130_fd_sc_hd__xor2_2
X_10365_ net435 net90 VGND VGND VPWR VPWR _02961_ sky130_fd_sc_hd__nand2_1
XFILLER_88_53 VPWR VGND VPWR VGND sky130_ef_sc_hd__decap_12
X_12104_ _04853_ _04854_ _04852_ VGND VGND VPWR VPWR _04856_ sky130_fd_sc_hd__a21o_1
XTAP_TAPCELL_ROW_131_2195 VGND VPWR sky130_fd_sc_hd__tapvpwrvgnd_1
XFILLER_124_589 VPWR VGND VPWR VGND sky130_ef_sc_hd__decap_12
XFILLER_111_206 VPWR VGND VPWR VGND sky130_ef_sc_hd__decap_12
XFILLER_97_429 VPWR VGND VPWR VGND sky130_ef_sc_hd__decap_12
X_13084_ _05923_ _05924_ VGND VGND VPWR VPWR _05926_ sky130_fd_sc_hd__and2_1
XFILLER_69_109 VGND VGND VPWR VPWR sky130_fd_sc_hd__decap_3
X_10296_ _02835_ _02885_ VGND VGND VPWR VPWR _02886_ sky130_fd_sc_hd__nand2_1
X_12035_ net594 net584 net679 net659 VGND VGND VPWR VPWR _04780_ sky130_fd_sc_hd__and4_1
XFILLER_77_131 VGND VGND VPWR VPWR sky130_fd_sc_hd__fill_1
XFILLER_120_773 VPWR VGND VPWR VGND sky130_ef_sc_hd__decap_12
XFILLER_93_602 VGND VGND VPWR VPWR sky130_fd_sc_hd__fill_2
XPHY_EDGE_ROW_47_Right_47 VGND VGND VPWR VPWR sky130_fd_sc_hd__decap_3
XFILLER_65_337 VGND VGND VPWR VPWR sky130_fd_sc_hd__decap_6
XFILLER_80_307 VGND VGND VPWR VPWR sky130_fd_sc_hd__fill_1
XFILLER_19_776 VGND VGND VPWR VPWR sky130_fd_sc_hd__decap_8
XTAP_TAPCELL_ROW_105_1828 VGND VPWR sky130_fd_sc_hd__tapvpwrvgnd_1
XTAP_TAPCELL_ROW_105_1817 VGND VPWR sky130_fd_sc_hd__tapvpwrvgnd_1
XFILLER_92_178 VGND VGND VPWR VPWR sky130_fd_sc_hd__fill_1
X_12937_ _05761_ _05764_ VGND VGND VPWR VPWR _05765_ sky130_fd_sc_hd__xor2_1
X_12868_ net621 net320 net303 net630 VGND VGND VPWR VPWR _05691_ sky130_fd_sc_hd__a22oi_1
XFILLER_61_543 VGND VGND VPWR VPWR sky130_fd_sc_hd__decap_8
XFILLER_61_532 VGND VGND VPWR VPWR sky130_fd_sc_hd__fill_1
XFILLER_18_297 VGND VGND VPWR VPWR sky130_fd_sc_hd__fill_1
XFILLER_34_757 VPWR VGND VPWR VGND sky130_ef_sc_hd__decap_12
XTAP_TAPCELL_ROW_138_2305 VGND VPWR sky130_fd_sc_hd__tapvpwrvgnd_1
XFILLER_21_418 VGND VGND VPWR VPWR sky130_fd_sc_hd__decap_3
X_11819_ _04347_ _04548_ _04546_ VGND VGND VPWR VPWR _04549_ sky130_fd_sc_hd__o21a_1
XFILLER_33_267 VGND VGND VPWR VPWR sky130_fd_sc_hd__fill_1
XTAP_TAPCELL_ROW_138_2316 VGND VPWR sky130_fd_sc_hd__tapvpwrvgnd_1
X_12799_ _05596_ _05614_ VGND VGND VPWR VPWR _05615_ sky130_fd_sc_hd__xnor2_1
XPHY_EDGE_ROW_56_Right_56 VGND VGND VPWR VPWR sky130_fd_sc_hd__decap_3
XTAP_TAPCELL_ROW_60_1168 VGND VPWR sky130_fd_sc_hd__tapvpwrvgnd_1
XFILLER_134_309 VGND VGND VPWR VPWR sky130_fd_sc_hd__decap_8
X_07010_ net655 net649 net100 net709 VGND VGND VPWR VPWR _03445_ sky130_fd_sc_hd__nand4_1
XTAP_TAPCELL_ROW_116_1979 VGND VPWR sky130_fd_sc_hd__tapvpwrvgnd_1
XFILLER_115_545 VGND VGND VPWR VPWR sky130_fd_sc_hd__fill_2
X_08961_ _01309_ _01433_ VGND VGND VPWR VPWR _01435_ sky130_fd_sc_hd__xnor2_1
XFILLER_103_729 VPWR VGND VPWR VGND sky130_ef_sc_hd__decap_12
XFILLER_102_217 VPWR VGND VPWR VGND sky130_ef_sc_hd__decap_12
XPHY_EDGE_ROW_65_Right_65 VGND VGND VPWR VPWR sky130_fd_sc_hd__decap_3
X_08892_ _01234_ _01237_ _01233_ VGND VGND VPWR VPWR _01360_ sky130_fd_sc_hd__a21bo_1
XFILLER_124_29 VPWR VGND VPWR VGND sky130_ef_sc_hd__decap_12
XFILLER_68_120 VPWR VGND VPWR VGND sky130_ef_sc_hd__decap_12
X_07912_ _00384_ _00389_ VGND VGND VPWR VPWR _00390_ sky130_fd_sc_hd__and2b_1
XFILLER_69_665 VGND VGND VPWR VPWR sky130_fd_sc_hd__decap_6
XFILLER_57_816 VGND VGND VPWR VPWR sky130_fd_sc_hd__decap_4
X_07843_ _00320_ _00174_ VGND VGND VPWR VPWR _00321_ sky130_fd_sc_hd__nand2b_1
XFILLER_96_484 VPWR VGND VPWR VGND sky130_ef_sc_hd__decap_12
XFILLER_68_197 VPWR VGND VPWR VGND sky130_ef_sc_hd__decap_12
XFILLER_83_156 VPWR VGND VPWR VGND sky130_ef_sc_hd__decap_12
X_07774_ net628 net619 net706 net705 VGND VGND VPWR VPWR _00253_ sky130_fd_sc_hd__and4_1
XFILLER_17_27 VPWR VGND VPWR VGND sky130_ef_sc_hd__decap_12
X_09513_ net558 net355 net49 net567 VGND VGND VPWR VPWR _02036_ sky130_fd_sc_hd__a22o_1
XFILLER_71_329 VGND VGND VPWR VPWR sky130_fd_sc_hd__decap_6
XFILLER_25_713 VPWR VGND VPWR VGND sky130_ef_sc_hd__decap_12
X_09444_ _01789_ _01959_ VGND VGND VPWR VPWR _01961_ sky130_fd_sc_hd__nand2_1
XFILLER_24_245 VGND VGND VPWR VPWR sky130_fd_sc_hd__fill_1
XFILLER_25_746 VPWR VGND VPWR VGND sky130_ef_sc_hd__decap_12
XPHY_EDGE_ROW_74_Right_74 VGND VGND VPWR VPWR sky130_fd_sc_hd__decap_3
XFILLER_52_587 VGND VGND VPWR VPWR sky130_fd_sc_hd__fill_1
XFILLER_33_15 VPWR VGND VPWR VGND sky130_ef_sc_hd__decap_12
X_09375_ _01883_ _01884_ VGND VGND VPWR VPWR _01886_ sky130_fd_sc_hd__xor2_1
XFILLER_138_615 VGND VGND VPWR VPWR sky130_fd_sc_hd__fill_1
X_08326_ _00797_ _00798_ VGND VGND VPWR VPWR _00800_ sky130_fd_sc_hd__xnor2_1
XFILLER_137_125 VPWR VGND VPWR VGND sky130_ef_sc_hd__decap_12
X_08257_ _00726_ _00730_ VGND VGND VPWR VPWR _00732_ sky130_fd_sc_hd__xnor2_1
XFILLER_137_169 VGND VGND VPWR VPWR sky130_fd_sc_hd__decap_8
XTAP_TAPCELL_ROW_78_1429 VGND VPWR sky130_fd_sc_hd__tapvpwrvgnd_1
X_08188_ _00595_ _00663_ VGND VGND VPWR VPWR _00664_ sky130_fd_sc_hd__xnor2_2
XFILLER_4_606 VPWR VGND VPWR VGND sky130_ef_sc_hd__decap_12
X_07208_ net698 net561 net553 net699 VGND VGND VPWR VPWR _05602_ sky130_fd_sc_hd__a22oi_1
XFILLER_134_821 VGND VGND VPWR VPWR sky130_fd_sc_hd__decap_3
XFILLER_118_361 VGND VGND VPWR VPWR sky130_fd_sc_hd__decap_3
XFILLER_106_512 VGND VGND VPWR VPWR sky130_fd_sc_hd__decap_4
X_07139_ _04827_ _04838_ VGND VGND VPWR VPWR _04849_ sky130_fd_sc_hd__or2_1
XFILLER_3_105 VGND VGND VPWR VPWR sky130_fd_sc_hd__decap_6
XFILLER_106_545 VGND VGND VPWR VPWR sky130_fd_sc_hd__decap_6
XTAP_TAPCELL_ROW_91_1618 VGND VPWR sky130_fd_sc_hd__tapvpwrvgnd_1
XPHY_EDGE_ROW_83_Right_83 VGND VGND VPWR VPWR sky130_fd_sc_hd__decap_3
XPHY_EDGE_ROW_18_Left_157 VGND VGND VPWR VPWR sky130_fd_sc_hd__decap_3
X_10150_ _02654_ _02657_ _02729_ VGND VGND VPWR VPWR _02731_ sky130_fd_sc_hd__and3_1
XFILLER_79_429 VPWR VGND VPWR VGND sky130_ef_sc_hd__decap_12
XTAP_TAPCELL_ROW_7_400 VGND VPWR sky130_fd_sc_hd__tapvpwrvgnd_1
X_10081_ _02654_ _02655_ VGND VGND VPWR VPWR _02656_ sky130_fd_sc_hd__nand2_1
XFILLER_48_805 VGND VGND VPWR VPWR sky130_fd_sc_hd__decap_6
XFILLER_101_272 VGND VGND VPWR VPWR sky130_fd_sc_hd__fill_2
XFILLER_47_337 VPWR VGND VPWR VGND sky130_ef_sc_hd__decap_12
XFILLER_63_808 VPWR VGND VPWR VGND sky130_ef_sc_hd__decap_12
XFILLER_15_201 VGND VGND VPWR VPWR sky130_fd_sc_hd__fill_2
X_10983_ _03635_ _03636_ VGND VGND VPWR VPWR _03637_ sky130_fd_sc_hd__xnor2_1
XPHY_EDGE_ROW_92_Right_92 VGND VGND VPWR VPWR sky130_fd_sc_hd__decap_3
X_12722_ _00108_ _05530_ _05531_ VGND VGND VPWR VPWR _05532_ sky130_fd_sc_hd__nand3_1
XFILLER_43_543 VPWR VGND VPWR VGND sky130_ef_sc_hd__decap_12
XFILLER_15_212 VGND VGND VPWR VPWR sky130_fd_sc_hd__fill_1
XFILLER_15_223 VGND VGND VPWR VPWR sky130_fd_sc_hd__fill_1
XPHY_EDGE_ROW_27_Left_166 VGND VGND VPWR VPWR sky130_fd_sc_hd__decap_3
XFILLER_28_595 VGND VGND VPWR VPWR sky130_fd_sc_hd__fill_1
XPHY_EDGE_ROW_133_Right_133 VGND VGND VPWR VPWR sky130_fd_sc_hd__decap_3
XFILLER_15_267 VPWR VGND VPWR VGND sky130_ef_sc_hd__decap_12
XFILLER_30_204 VGND VGND VPWR VPWR sky130_fd_sc_hd__decap_4
XFILLER_31_727 VGND VGND VPWR VPWR sky130_fd_sc_hd__fill_1
XFILLER_130_83 VGND VGND VPWR VPWR sky130_fd_sc_hd__fill_1
X_12653_ _05454_ _05455_ VGND VGND VPWR VPWR _05456_ sky130_fd_sc_hd__and2b_1
XFILLER_70_395 VGND VGND VPWR VPWR sky130_fd_sc_hd__fill_1
XFILLER_30_226 VPWR VGND VPWR VGND sky130_ef_sc_hd__decap_12
XTAP_TAPCELL_ROW_100_1747 VGND VPWR sky130_fd_sc_hd__tapvpwrvgnd_1
XFILLER_90_65 VPWR VGND VPWR VGND sky130_ef_sc_hd__decap_12
X_12584_ _05380_ _05379_ VGND VGND VPWR VPWR _05381_ sky130_fd_sc_hd__and2b_1
X_11604_ net535 net299 net301 net263 VGND VGND VPWR VPWR _04314_ sky130_fd_sc_hd__o2bb2a_1
X_11535_ net609 net314 _04119_ VGND VGND VPWR VPWR _04240_ sky130_fd_sc_hd__a21oi_1
XTAP_TAPCELL_ROW_133_2224 VGND VPWR sky130_fd_sc_hd__tapvpwrvgnd_1
XFILLER_128_147 VGND VGND VPWR VPWR sky130_fd_sc_hd__decap_4
XFILLER_109_350 VGND VGND VPWR VPWR sky130_fd_sc_hd__fill_1
XFILLER_99_30 VPWR VGND VPWR VGND sky130_ef_sc_hd__decap_12
X_13205_ net246 _06056_ VGND VGND VPWR VPWR _06058_ sky130_fd_sc_hd__xnor2_1
X_11466_ _04019_ _04021_ _04018_ VGND VGND VPWR VPWR _04165_ sky130_fd_sc_hd__o21ba_1
XPHY_EDGE_ROW_36_Left_175 VGND VGND VPWR VPWR sky130_fd_sc_hd__decap_3
X_11397_ _03617_ _04088_ VGND VGND VPWR VPWR _04089_ sky130_fd_sc_hd__xnor2_1
X_10417_ _03007_ _03015_ _02842_ VGND VGND VPWR VPWR _03018_ sky130_fd_sc_hd__a21o_1
XFILLER_98_749 VGND VGND VPWR VPWR sky130_fd_sc_hd__decap_6
X_13136_ net629 net620 net284 VGND VGND VPWR VPWR _05983_ sky130_fd_sc_hd__and3_1
X_10348_ net494 net82 VGND VGND VPWR VPWR _02943_ sky130_fd_sc_hd__nand2_1
X_13067_ _05749_ _05750_ _05751_ _05748_ _05747_ VGND VGND VPWR VPWR _05907_ sky130_fd_sc_hd__o32a_1
X_10279_ _02820_ _02867_ VGND VGND VPWR VPWR _02868_ sky130_fd_sc_hd__and2_1
X_12018_ _04727_ _04758_ _04760_ VGND VGND VPWR VPWR _04762_ sky130_fd_sc_hd__a21o_1
XFILLER_38_304 VGND VGND VPWR VPWR sky130_fd_sc_hd__decap_4
XFILLER_93_465 VPWR VGND VPWR VGND sky130_ef_sc_hd__decap_12
XFILLER_93_443 VGND VGND VPWR VPWR sky130_fd_sc_hd__decap_4
XFILLER_66_668 VPWR VGND VPWR VGND sky130_ef_sc_hd__decap_12
XTAP_TAPCELL_ROW_49_1008 VGND VPWR sky130_fd_sc_hd__tapvpwrvgnd_1
XFILLER_80_104 VGND VGND VPWR VPWR sky130_fd_sc_hd__fill_1
XFILLER_65_167 VGND VGND VPWR VPWR sky130_fd_sc_hd__fill_1
XPHY_EDGE_ROW_45_Left_184 VGND VGND VPWR VPWR sky130_fd_sc_hd__decap_3
XFILLER_0_41 VPWR VGND VPWR VGND sky130_ef_sc_hd__decap_12
XFILLER_80_137 VGND VGND VPWR VPWR sky130_fd_sc_hd__decap_3
X_07490_ _06719_ _06718_ VGND VGND VPWR VPWR _06720_ sky130_fd_sc_hd__and2b_1
XFILLER_0_85 VGND VGND VPWR VPWR sky130_fd_sc_hd__fill_2
XPHY_EDGE_ROW_100_Right_100 VGND VGND VPWR VPWR sky130_fd_sc_hd__decap_3
X_09160_ _01647_ _01651_ VGND VGND VPWR VPWR _01652_ sky130_fd_sc_hd__xnor2_1
XTAP_TAPCELL_ROW_32_766 VGND VPWR sky130_fd_sc_hd__tapvpwrvgnd_1
X_09091_ net420 net339 VGND VGND VPWR VPWR _01577_ sky130_fd_sc_hd__nand2_1
X_08111_ _00577_ _00585_ VGND VGND VPWR VPWR _00587_ sky130_fd_sc_hd__xor2_1
XFILLER_30_793 VPWR VGND VPWR VGND sky130_ef_sc_hd__decap_12
XFILLER_119_169 VPWR VGND VPWR VGND sky130_ef_sc_hd__decap_12
X_08042_ _00393_ _00518_ VGND VGND VPWR VPWR _00519_ sky130_fd_sc_hd__xor2_1
XPHY_EDGE_ROW_54_Left_193 VGND VGND VPWR VPWR sky130_fd_sc_hd__decap_3
XFILLER_135_629 VGND VGND VPWR VPWR sky130_fd_sc_hd__decap_3
XFILLER_128_681 VPWR VGND VPWR VGND sky130_ef_sc_hd__decap_12
XFILLER_134_139 VGND VGND VPWR VPWR sky130_fd_sc_hd__fill_1
XFILLER_115_320 VGND VGND VPWR VPWR sky130_fd_sc_hd__decap_6
X_09993_ _02491_ _02559_ VGND VGND VPWR VPWR _02560_ sky130_fd_sc_hd__xnor2_1
XFILLER_115_364 VGND VGND VPWR VPWR sky130_fd_sc_hd__fill_1
XFILLER_88_215 VGND VGND VPWR VPWR sky130_fd_sc_hd__decap_4
XFILLER_135_39 VPWR VGND VPWR VGND sky130_ef_sc_hd__decap_12
X_08944_ _01412_ _01414_ _01415_ VGND VGND VPWR VPWR _01416_ sky130_fd_sc_hd__nand3b_1
XTAP_TAPCELL_ROW_73_1359 VGND VPWR sky130_fd_sc_hd__tapvpwrvgnd_1
X_08875_ _01199_ _01202_ _01339_ _01340_ VGND VGND VPWR VPWR _01341_ sky130_fd_sc_hd__a211oi_4
XFILLER_84_421 VPWR VGND VPWR VGND sky130_ef_sc_hd__decap_12
XFILLER_69_473 VGND VGND VPWR VPWR sky130_fd_sc_hd__decap_3
XFILLER_28_15 VPWR VGND VPWR VGND sky130_ef_sc_hd__decap_12
XFILLER_29_315 VGND VGND VPWR VPWR sky130_fd_sc_hd__decap_6
XFILLER_29_337 VPWR VGND VPWR VGND sky130_ef_sc_hd__decap_12
XFILLER_57_657 VGND VGND VPWR VPWR sky130_fd_sc_hd__decap_8
XFILLER_56_123 VGND VGND VPWR VPWR sky130_fd_sc_hd__fill_1
X_07826_ _00302_ _00303_ VGND VGND VPWR VPWR _00304_ sky130_fd_sc_hd__xnor2_1
XFILLER_71_104 VGND VGND VPWR VPWR sky130_fd_sc_hd__decap_8
X_07757_ _00076_ _00079_ VGND VGND VPWR VPWR _00236_ sky130_fd_sc_hd__nand2_1
XTAP_TAPCELL_ROW_88_1580 VGND VPWR sky130_fd_sc_hd__tapvpwrvgnd_1
X_07688_ _00166_ VGND VGND VPWR VPWR _00167_ sky130_fd_sc_hd__inv_2
X_09427_ _01763_ _01772_ _01771_ VGND VGND VPWR VPWR _01942_ sky130_fd_sc_hd__a21oi_1
X_09358_ _01718_ _01739_ _01738_ VGND VGND VPWR VPWR _01868_ sky130_fd_sc_hd__a21bo_1
XFILLER_100_53 VPWR VGND VPWR VGND sky130_ef_sc_hd__decap_12
XFILLER_100_97 VPWR VGND VPWR VGND sky130_ef_sc_hd__decap_12
X_08309_ _00595_ _00663_ _00662_ VGND VGND VPWR VPWR _00784_ sky130_fd_sc_hd__a21oi_1
XFILLER_126_607 VGND VGND VPWR VPWR sky130_fd_sc_hd__fill_1
X_09289_ net445 net331 _01790_ _01792_ VGND VGND VPWR VPWR _01793_ sky130_fd_sc_hd__a22o_1
XTAP_TAPCELL_ROW_10_438 VGND VPWR sky130_fd_sc_hd__tapvpwrvgnd_1
X_11320_ _03918_ _04005_ VGND VGND VPWR VPWR _04006_ sky130_fd_sc_hd__xnor2_1
XTAP_TAPCELL_ROW_10_449 VGND VPWR sky130_fd_sc_hd__tapvpwrvgnd_1
XFILLER_20_281 VGND VGND VPWR VPWR sky130_fd_sc_hd__fill_1
XFILLER_107_821 VGND VGND VPWR VPWR sky130_fd_sc_hd__decap_3
XFILLER_118_191 VGND VGND VPWR VPWR sky130_fd_sc_hd__decap_4
XFILLER_109_51 VGND VGND VPWR VPWR sky130_fd_sc_hd__decap_4
XFILLER_4_436 VGND VGND VPWR VPWR sky130_fd_sc_hd__decap_3
X_11251_ _03772_ _03776_ VGND VGND VPWR VPWR _03930_ sky130_fd_sc_hd__and2_1
X_10202_ _02719_ _02786_ VGND VGND VPWR VPWR _02787_ sky130_fd_sc_hd__xnor2_1
XFILLER_133_150 VGND VGND VPWR VPWR sky130_fd_sc_hd__decap_6
XFILLER_122_813 VGND VGND VPWR VPWR sky130_fd_sc_hd__decap_8
XFILLER_106_353 VGND VGND VPWR VPWR sky130_fd_sc_hd__decap_8
XFILLER_69_55 VGND VGND VPWR VPWR sky130_fd_sc_hd__fill_1
X_11182_ _03629_ _03689_ _03688_ VGND VGND VPWR VPWR _03855_ sky130_fd_sc_hd__o21ba_1
X_10133_ _02605_ _02628_ _02604_ VGND VGND VPWR VPWR _02712_ sky130_fd_sc_hd__o21a_1
XFILLER_121_334 VGND VGND VPWR VPWR sky130_fd_sc_hd__fill_2
XFILLER_79_259 VGND VGND VPWR VPWR sky130_fd_sc_hd__decap_4
X_10064_ _02463_ _02636_ VGND VGND VPWR VPWR _02637_ sky130_fd_sc_hd__nor2_1
XFILLER_102_581 VGND VGND VPWR VPWR sky130_fd_sc_hd__decap_6
XFILLER_88_782 VPWR VGND VPWR VGND sky130_ef_sc_hd__decap_12
XFILLER_87_281 VGND VGND VPWR VPWR sky130_fd_sc_hd__decap_3
XFILLER_48_657 VGND VGND VPWR VPWR sky130_fd_sc_hd__fill_2
XFILLER_47_134 VPWR VGND VPWR VGND sky130_ef_sc_hd__decap_12
XFILLER_75_465 VGND VGND VPWR VPWR sky130_fd_sc_hd__fill_1
XFILLER_16_576 VGND VGND VPWR VPWR sky130_fd_sc_hd__fill_1
X_10966_ _03616_ _03617_ VGND VGND VPWR VPWR _03618_ sky130_fd_sc_hd__xnor2_1
XFILLER_31_502 VGND VGND VPWR VPWR sky130_fd_sc_hd__fill_2
X_12705_ _05349_ _05351_ VGND VGND VPWR VPWR _05513_ sky130_fd_sc_hd__nor2_1
X_13685_ clknet_3_3__leaf_clk _00006_ net713 VGND VGND VPWR VPWR net213 sky130_fd_sc_hd__dfrtp_1
X_10897_ _03367_ _03370_ _03366_ VGND VGND VPWR VPWR _03542_ sky130_fd_sc_hd__a21oi_1
XFILLER_31_535 VGND VGND VPWR VPWR sky130_fd_sc_hd__fill_1
XFILLER_129_401 VGND VGND VPWR VPWR sky130_fd_sc_hd__decap_3
X_12636_ net480 net406 _05257_ _05256_ VGND VGND VPWR VPWR _05437_ sky130_fd_sc_hd__a31o_1
XFILLER_86_7 VPWR VGND VPWR VGND sky130_ef_sc_hd__decap_12
X_12567_ _05347_ _05360_ VGND VGND VPWR VPWR _05362_ sky130_fd_sc_hd__xor2_1
XFILLER_11_281 VGND VGND VPWR VPWR sky130_fd_sc_hd__decap_4
X_12498_ net531 net394 VGND VGND VPWR VPWR _05287_ sky130_fd_sc_hd__nand2_1
X_11518_ _04107_ _04109_ _04106_ VGND VGND VPWR VPWR _04222_ sky130_fd_sc_hd__o21ba_1
X_11449_ _04102_ _04146_ VGND VGND VPWR VPWR _04147_ sky130_fd_sc_hd__xnor2_1
XFILLER_125_662 VGND VGND VPWR VPWR sky130_fd_sc_hd__decap_8
XTAP_TAPCELL_ROW_113_1938 VGND VPWR sky130_fd_sc_hd__tapvpwrvgnd_1
X_13119_ _05935_ _05964_ VGND VGND VPWR VPWR _05965_ sky130_fd_sc_hd__and2b_1
X_06990_ _03194_ _03215_ VGND VGND VPWR VPWR _03226_ sky130_fd_sc_hd__nor2_1
XFILLER_39_602 VGND VGND VPWR VPWR sky130_fd_sc_hd__decap_6
XFILLER_112_389 VPWR VGND VPWR VGND sky130_ef_sc_hd__decap_12
XFILLER_79_782 VGND VGND VPWR VPWR sky130_fd_sc_hd__fill_2
XFILLER_66_421 VGND VGND VPWR VPWR sky130_fd_sc_hd__fill_1
X_08660_ net508 net51 net349 net517 VGND VGND VPWR VPWR _01127_ sky130_fd_sc_hd__a22o_1
XFILLER_94_763 VPWR VGND VPWR VGND sky130_ef_sc_hd__decap_12
XFILLER_66_454 VGND VGND VPWR VPWR sky130_fd_sc_hd__fill_1
XFILLER_38_134 VGND VGND VPWR VPWR sky130_fd_sc_hd__decap_6
XFILLER_39_657 VPWR VGND VPWR VGND sky130_ef_sc_hd__decap_12
X_07611_ net267 net599 VGND VGND VPWR VPWR _00091_ sky130_fd_sc_hd__nand2b_1
XFILLER_26_307 VGND VGND VPWR VPWR sky130_fd_sc_hd__fill_1
XFILLER_38_156 VGND VGND VPWR VPWR sky130_fd_sc_hd__fill_2
X_08591_ _01019_ _01058_ VGND VGND VPWR VPWR _01059_ sky130_fd_sc_hd__and2_1
XFILLER_81_457 VGND VGND VPWR VPWR sky130_fd_sc_hd__fill_2
XFILLER_81_446 VGND VGND VPWR VPWR sky130_fd_sc_hd__fill_2
XFILLER_81_435 VGND VGND VPWR VPWR sky130_fd_sc_hd__decap_4
XTAP_TAPCELL_ROW_37_836 VGND VPWR sky130_fd_sc_hd__tapvpwrvgnd_1
X_07542_ _06769_ _06770_ VGND VGND VPWR VPWR _06771_ sky130_fd_sc_hd__xnor2_1
X_07473_ _06686_ _06701_ VGND VGND VPWR VPWR _06703_ sky130_fd_sc_hd__xor2_1
X_09212_ net585 net355 _01537_ _01536_ VGND VGND VPWR VPWR _01708_ sky130_fd_sc_hd__a31o_1
XFILLER_61_181 VPWR VGND VPWR VGND sky130_ef_sc_hd__decap_12
XFILLER_22_557 VPWR VGND VPWR VGND sky130_ef_sc_hd__decap_12
X_09143_ net616 net375 _01471_ _01470_ VGND VGND VPWR VPWR _01633_ sky130_fd_sc_hd__a31o_1
XPHY_EDGE_ROW_62_Left_201 VGND VGND VPWR VPWR sky130_fd_sc_hd__decap_3
X_09074_ _01548_ _01556_ VGND VGND VPWR VPWR _01558_ sky130_fd_sc_hd__xnor2_1
XFILLER_30_27 VGND VGND VPWR VPWR sky130_fd_sc_hd__fill_1
X_08025_ _00371_ _00378_ _00377_ VGND VGND VPWR VPWR _00502_ sky130_fd_sc_hd__a21o_1
XFILLER_104_813 VGND VGND VPWR VPWR sky130_fd_sc_hd__decap_8
XFILLER_115_194 VPWR VGND VPWR VGND sky130_ef_sc_hd__decap_12
X_09976_ _01768_ _02539_ VGND VGND VPWR VPWR _02541_ sky130_fd_sc_hd__xnor2_1
XPHY_EDGE_ROW_71_Left_210 VGND VGND VPWR VPWR sky130_fd_sc_hd__decap_3
XFILLER_131_698 VPWR VGND VPWR VGND sky130_ef_sc_hd__decap_12
X_08927_ _01130_ _01262_ _01106_ VGND VGND VPWR VPWR _01397_ sky130_fd_sc_hd__o21a_1
XFILLER_39_69 VPWR VGND VPWR VGND sky130_ef_sc_hd__decap_12
XFILLER_130_197 VGND VGND VPWR VPWR sky130_fd_sc_hd__decap_4
X_08858_ _01321_ _01322_ _01320_ VGND VGND VPWR VPWR _01324_ sky130_fd_sc_hd__o21ai_1
XFILLER_69_281 VGND VGND VPWR VPWR sky130_fd_sc_hd__decap_4
X_07809_ _00144_ _00287_ VGND VGND VPWR VPWR _00288_ sky130_fd_sc_hd__nand2_1
XFILLER_29_156 VGND VGND VPWR VPWR sky130_fd_sc_hd__decap_6
X_08789_ net585 net359 net357 net595 VGND VGND VPWR VPWR _01255_ sky130_fd_sc_hd__a22o_1
XTAP_TAPCELL_ROW_86_1539 VGND VPWR sky130_fd_sc_hd__tapvpwrvgnd_1
XFILLER_84_295 VGND VGND VPWR VPWR sky130_fd_sc_hd__fill_2
XFILLER_55_57 VPWR VGND VPWR VGND sky130_ef_sc_hd__decap_12
XFILLER_111_30 VPWR VGND VPWR VGND sky130_ef_sc_hd__decap_12
XFILLER_60_608 VGND VGND VPWR VPWR sky130_fd_sc_hd__decap_8
XFILLER_44_159 VPWR VGND VPWR VGND sky130_ef_sc_hd__decap_12
X_10820_ _03457_ _03458_ VGND VGND VPWR VPWR _03459_ sky130_fd_sc_hd__nand2_1
XFILLER_53_671 VGND VGND VPWR VPWR sky130_fd_sc_hd__fill_1
X_10751_ _03211_ _03213_ _03210_ VGND VGND VPWR VPWR _03383_ sky130_fd_sc_hd__o21ba_1
XTAP_TAPCELL_ROW_15_519 VGND VPWR sky130_fd_sc_hd__tapvpwrvgnd_1
X_13470_ _06346_ _06347_ VGND VGND VPWR VPWR _06348_ sky130_fd_sc_hd__or2_1
XFILLER_9_517 VGND VGND VPWR VPWR sky130_fd_sc_hd__decap_8
X_12421_ _05200_ _05201_ _05142_ VGND VGND VPWR VPWR _05203_ sky130_fd_sc_hd__a21o_1
X_10682_ _03306_ _03307_ VGND VGND VPWR VPWR _03308_ sky130_fd_sc_hd__nor2_1
XFILLER_40_365 VGND VGND VPWR VPWR sky130_fd_sc_hd__decap_3
XFILLER_138_253 VPWR VGND VPWR VGND sky130_ef_sc_hd__decap_12
X_12352_ _05116_ _05126_ VGND VGND VPWR VPWR _05127_ sky130_fd_sc_hd__xor2_1
X_12283_ _05048_ _05049_ _04997_ VGND VGND VPWR VPWR _05052_ sky130_fd_sc_hd__o21ai_1
X_11303_ _03985_ _03986_ VGND VGND VPWR VPWR _03987_ sky130_fd_sc_hd__xnor2_1
XFILLER_107_662 VGND VGND VPWR VPWR sky130_fd_sc_hd__fill_1
X_11234_ _03909_ _03910_ VGND VGND VPWR VPWR _03911_ sky130_fd_sc_hd__or2_1
XFILLER_122_643 VGND VGND VPWR VPWR sky130_fd_sc_hd__fill_1
XFILLER_4_288 VPWR VGND VPWR VGND sky130_ef_sc_hd__decap_12
XFILLER_4_277 VGND VGND VPWR VPWR sky130_fd_sc_hd__decap_3
XFILLER_110_805 VGND VGND VPWR VPWR sky130_fd_sc_hd__decap_6
XFILLER_96_53 VPWR VGND VPWR VGND sky130_ef_sc_hd__decap_12
XFILLER_95_505 VGND VGND VPWR VPWR sky130_fd_sc_hd__fill_1
X_11165_ net636 _03669_ VGND VGND VPWR VPWR _03836_ sky130_fd_sc_hd__nand2_2
XFILLER_121_186 VGND VGND VPWR VPWR sky130_fd_sc_hd__decap_8
X_10116_ _02691_ _02692_ VGND VGND VPWR VPWR _02693_ sky130_fd_sc_hd__nor2_1
X_11096_ _03759_ _03719_ VGND VGND VPWR VPWR _03760_ sky130_fd_sc_hd__nand2b_1
XTAP_TAPCELL_ROW_128_2156 VGND VPWR sky130_fd_sc_hd__tapvpwrvgnd_1
X_10047_ _02536_ _02544_ _02542_ VGND VGND VPWR VPWR _02618_ sky130_fd_sc_hd__a21bo_1
XFILLER_96_97 VGND VGND VPWR VPWR sky130_fd_sc_hd__fill_2
XFILLER_91_711 VPWR VGND VPWR VGND sky130_ef_sc_hd__decap_12
XFILLER_75_240 VGND VGND VPWR VPWR sky130_fd_sc_hd__fill_1
XFILLER_36_627 VGND VGND VPWR VPWR sky130_fd_sc_hd__decap_8
XFILLER_91_744 VPWR VGND VPWR VGND sky130_ef_sc_hd__decap_12
XFILLER_75_284 VGND VGND VPWR VPWR sky130_fd_sc_hd__decap_8
X_11998_ net572 net711 _04737_ _04738_ VGND VGND VPWR VPWR _04741_ sky130_fd_sc_hd__a22oi_1
XFILLER_44_693 VGND VGND VPWR VPWR sky130_fd_sc_hd__decap_6
X_10949_ _03597_ _03599_ VGND VGND VPWR VPWR _03600_ sky130_fd_sc_hd__xnor2_1
XFILLER_32_811 VGND VGND VPWR VPWR sky130_fd_sc_hd__fill_1
X_13668_ clknet_3_1__leaf_clk _00000_ net712 VGND VGND VPWR VPWR net196 sky130_fd_sc_hd__dfrtp_1
XFILLER_129_253 VGND VGND VPWR VPWR sky130_fd_sc_hd__fill_1
XFILLER_129_220 VGND VGND VPWR VPWR sky130_fd_sc_hd__decap_4
X_12619_ _05405_ _05408_ _05416_ VGND VGND VPWR VPWR _05419_ sky130_fd_sc_hd__o21ai_1
X_13599_ _05826_ _06238_ VGND VGND VPWR VPWR _06488_ sky130_fd_sc_hd__nor2_1
XFILLER_129_275 VGND VGND VPWR VPWR sky130_fd_sc_hd__decap_4
XTAP_TAPCELL_ROW_57_1129 VGND VPWR sky130_fd_sc_hd__tapvpwrvgnd_1
XFILLER_125_492 VPWR VGND VPWR VGND sky130_ef_sc_hd__decap_12
X_09830_ _02379_ _02381_ VGND VGND VPWR VPWR _02383_ sky130_fd_sc_hd__and2_1
XFILLER_98_365 VPWR VGND VPWR VGND sky130_ef_sc_hd__decap_12
Xfanout507 net509 VGND VGND VPWR VPWR net507 sky130_fd_sc_hd__clkbuf_4
Xfanout529 net146 VGND VGND VPWR VPWR net529 sky130_fd_sc_hd__clkbuf_4
XTAP_TAPCELL_ROW_70_1318 VGND VPWR sky130_fd_sc_hd__tapvpwrvgnd_1
XTAP_TAPCELL_ROW_70_1307 VGND VPWR sky130_fd_sc_hd__tapvpwrvgnd_1
XFILLER_59_719 VGND VGND VPWR VPWR sky130_fd_sc_hd__decap_8
Xfanout518 net148 VGND VGND VPWR VPWR net518 sky130_fd_sc_hd__clkbuf_4
X_09761_ _02223_ _02306_ VGND VGND VPWR VPWR _02308_ sky130_fd_sc_hd__xnor2_2
XFILLER_86_516 VPWR VGND VPWR VGND sky130_ef_sc_hd__decap_12
X_06973_ _02477_ _03008_ _03030_ net682 VGND VGND VPWR VPWR _03041_ sky130_fd_sc_hd__a22o_1
XFILLER_39_410 VGND VGND VPWR VPWR sky130_fd_sc_hd__fill_2
X_08712_ _01176_ _01177_ _01165_ VGND VGND VPWR VPWR _01179_ sky130_fd_sc_hd__a21o_1
XFILLER_67_741 VPWR VGND VPWR VGND sky130_ef_sc_hd__decap_12
XFILLER_132_29 VPWR VGND VPWR VGND sky130_ef_sc_hd__decap_12
X_09692_ net496 net344 _02082_ _01919_ VGND VGND VPWR VPWR _02232_ sky130_fd_sc_hd__a31oi_4
XFILLER_67_785 VPWR VGND VPWR VGND sky130_ef_sc_hd__decap_12
XFILLER_66_251 VGND VGND VPWR VPWR sky130_fd_sc_hd__fill_1
X_08643_ _01107_ _01109_ VGND VGND VPWR VPWR _01110_ sky130_fd_sc_hd__and2_1
XFILLER_82_755 VGND VGND VPWR VPWR sky130_fd_sc_hd__fill_1
XFILLER_82_722 VPWR VGND VPWR VGND sky130_ef_sc_hd__decap_12
XFILLER_54_446 VGND VGND VPWR VPWR sky130_fd_sc_hd__decap_8
XFILLER_54_413 VGND VGND VPWR VPWR sky130_fd_sc_hd__decap_6
X_08574_ _01009_ _01040_ VGND VGND VPWR VPWR _01042_ sky130_fd_sc_hd__xor2_1
XFILLER_25_27 VPWR VGND VPWR VGND sky130_ef_sc_hd__decap_12
XFILLER_35_671 VGND VGND VPWR VPWR sky130_fd_sc_hd__fill_1
X_07525_ _06594_ _06596_ _06753_ VGND VGND VPWR VPWR _06754_ sky130_fd_sc_hd__a21o_1
XTAP_TAPCELL_ROW_81_1469 VGND VPWR sky130_fd_sc_hd__tapvpwrvgnd_1
X_07456_ _06526_ _06685_ VGND VGND VPWR VPWR _06686_ sky130_fd_sc_hd__xnor2_1
XFILLER_10_516 VPWR VGND VPWR VGND sky130_ef_sc_hd__decap_12
XFILLER_22_365 VGND VGND VPWR VPWR sky130_fd_sc_hd__decap_3
X_07387_ _06613_ _06614_ VGND VGND VPWR VPWR _06617_ sky130_fd_sc_hd__xor2_1
XFILLER_41_15 VPWR VGND VPWR VGND sky130_ef_sc_hd__decap_12
X_09126_ net461 net64 _01610_ VGND VGND VPWR VPWR _01614_ sky130_fd_sc_hd__and3_1
X_09057_ _01370_ _01372_ _01369_ VGND VGND VPWR VPWR _01539_ sky130_fd_sc_hd__o21ba_1
XFILLER_136_757 VPWR VGND VPWR VGND sky130_ef_sc_hd__decap_12
XFILLER_135_245 VGND VGND VPWR VPWR sky130_fd_sc_hd__decap_4
XFILLER_135_223 VGND VGND VPWR VPWR sky130_fd_sc_hd__fill_1
XTAP_TAPCELL_ROW_20_588 VGND VPWR sky130_fd_sc_hd__tapvpwrvgnd_1
XTAP_TAPCELL_ROW_96_1690 VGND VPWR sky130_fd_sc_hd__tapvpwrvgnd_1
X_08008_ _00477_ _00483_ VGND VGND VPWR VPWR _00485_ sky130_fd_sc_hd__xnor2_1
XFILLER_89_332 VGND VGND VPWR VPWR sky130_fd_sc_hd__decap_4
XFILLER_89_310 VGND VGND VPWR VPWR sky130_fd_sc_hd__decap_3
XFILLER_89_354 VPWR VGND VPWR VGND sky130_ef_sc_hd__decap_12
X_09959_ _02519_ _02520_ VGND VGND VPWR VPWR _02523_ sky130_fd_sc_hd__nor2_1
XFILLER_106_41 VPWR VGND VPWR VGND sky130_ef_sc_hd__decap_12
XFILLER_106_85 VGND VGND VPWR VPWR sky130_fd_sc_hd__decap_3
X_12970_ _05476_ _05801_ VGND VGND VPWR VPWR _05802_ sky130_fd_sc_hd__xnor2_1
XFILLER_57_251 VPWR VGND VPWR VGND sky130_ef_sc_hd__decap_12
XFILLER_73_744 VGND VGND VPWR VPWR sky130_fd_sc_hd__decap_6
XFILLER_72_210 VPWR VGND VPWR VGND sky130_ef_sc_hd__decap_12
X_11921_ _04622_ _04659_ VGND VGND VPWR VPWR _04660_ sky130_fd_sc_hd__xnor2_1
X_11852_ _04581_ _04584_ VGND VGND VPWR VPWR _04585_ sky130_fd_sc_hd__and2b_1
XTAP_TAPCELL_ROW_123_2086 VGND VPWR sky130_fd_sc_hd__tapvpwrvgnd_1
XTAP_TAPCELL_ROW_0_280 VGND VPWR sky130_fd_sc_hd__tapvpwrvgnd_1
XFILLER_14_811 VGND VGND VPWR VPWR sky130_fd_sc_hd__fill_1
X_10803_ _03435_ _03438_ _03439_ VGND VGND VPWR VPWR _03440_ sky130_fd_sc_hd__and3_1
XTAP_TAPCELL_ROW_28_699 VGND VPWR sky130_fd_sc_hd__tapvpwrvgnd_1
X_13522_ _06403_ _06404_ VGND VGND VPWR VPWR _06405_ sky130_fd_sc_hd__nor2_1
XFILLER_82_77 VGND VGND VPWR VPWR sky130_fd_sc_hd__decap_6
XTAP_TAPCELL_ROW_0_291 VGND VPWR sky130_fd_sc_hd__tapvpwrvgnd_1
X_11783_ net249 _04508_ VGND VGND VPWR VPWR _04510_ sky130_fd_sc_hd__nand2_1
XFILLER_41_685 VGND VGND VPWR VPWR sky130_fd_sc_hd__decap_6
X_10734_ _03276_ _03278_ VGND VGND VPWR VPWR _03364_ sky130_fd_sc_hd__nor2_1
X_13453_ _06326_ _06327_ VGND VGND VPWR VPWR _06329_ sky130_fd_sc_hd__xnor2_1
XFILLER_9_347 VGND VGND VPWR VPWR sky130_fd_sc_hd__decap_6
XFILLER_13_387 VGND VGND VPWR VPWR sky130_fd_sc_hd__decap_4
X_10665_ net449 net274 VGND VGND VPWR VPWR _03289_ sky130_fd_sc_hd__nand2_1
XFILLER_40_195 VGND VGND VPWR VPWR sky130_fd_sc_hd__fill_1
XFILLER_126_201 VGND VGND VPWR VPWR sky130_fd_sc_hd__fill_1
X_13384_ net259 net396 VGND VGND VPWR VPWR _06254_ sky130_fd_sc_hd__nor2_1
X_12404_ _05025_ _05027_ _05026_ VGND VGND VPWR VPWR _05184_ sky130_fd_sc_hd__o21bai_1
XFILLER_126_234 VGND VGND VPWR VPWR sky130_fd_sc_hd__fill_1
X_12335_ _05088_ _05107_ VGND VGND VPWR VPWR _05108_ sky130_fd_sc_hd__xor2_1
X_10596_ net546 net311 VGND VGND VPWR VPWR _03213_ sky130_fd_sc_hd__nand2_1
XFILLER_127_779 VGND VGND VPWR VPWR sky130_fd_sc_hd__decap_4
XFILLER_126_267 VGND VGND VPWR VPWR sky130_fd_sc_hd__decap_8
XFILLER_126_289 VPWR VGND VPWR VGND sky130_ef_sc_hd__decap_12
X_12266_ _05023_ _05031_ _05032_ VGND VGND VPWR VPWR _05033_ sky130_fd_sc_hd__nand3_1
X_12197_ _04775_ _04777_ VGND VGND VPWR VPWR _04957_ sky130_fd_sc_hd__or2_1
X_11217_ _03890_ _03891_ VGND VGND VPWR VPWR _03892_ sky130_fd_sc_hd__nor2_1
XFILLER_95_302 VGND VGND VPWR VPWR sky130_fd_sc_hd__fill_1
XFILLER_68_516 VPWR VGND VPWR VGND sky130_ef_sc_hd__decap_12
XTAP_TAPCELL_ROW_52_1048 VGND VPWR sky130_fd_sc_hd__tapvpwrvgnd_1
X_11148_ _03802_ _03815_ VGND VGND VPWR VPWR _03818_ sky130_fd_sc_hd__xor2_1
XFILLER_95_335 VGND VGND VPWR VPWR sky130_fd_sc_hd__fill_1
XTAP_TAPCELL_ROW_52_1059 VGND VPWR sky130_fd_sc_hd__tapvpwrvgnd_1
XFILLER_49_785 VPWR VGND VPWR VGND sky130_ef_sc_hd__decap_12
X_11079_ net302 _03573_ _03570_ VGND VGND VPWR VPWR _03742_ sky130_fd_sc_hd__a21oi_1
XFILLER_63_210 VGND VGND VPWR VPWR sky130_fd_sc_hd__decap_6
XTAP_TAPCELL_ROW_108_1859 VGND VPWR sky130_fd_sc_hd__tapvpwrvgnd_1
XFILLER_91_541 VGND VGND VPWR VPWR sky130_fd_sc_hd__decap_6
XTAP_TAPCELL_ROW_47_975 VGND VPWR sky130_fd_sc_hd__tapvpwrvgnd_1
XTAP_TAPCELL_ROW_47_986 VGND VPWR sky130_fd_sc_hd__tapvpwrvgnd_1
XFILLER_17_671 VGND VGND VPWR VPWR sky130_fd_sc_hd__fill_1
XFILLER_23_129 VGND VGND VPWR VPWR sky130_fd_sc_hd__decap_3
X_07310_ _06538_ _06539_ _06540_ VGND VGND VPWR VPWR _06541_ sky130_fd_sc_hd__nand3_1
XFILLER_44_490 VGND VGND VPWR VPWR sky130_fd_sc_hd__decap_6
XFILLER_16_181 VPWR VGND VPWR VGND sky130_ef_sc_hd__decap_12
X_08290_ net663 _06801_ _00764_ VGND VGND VPWR VPWR _00765_ sky130_fd_sc_hd__o21ba_1
X_07241_ _05559_ _05941_ VGND VGND VPWR VPWR _05963_ sky130_fd_sc_hd__xor2_1
X_07172_ _05199_ VGND VGND VPWR VPWR _05210_ sky130_fd_sc_hd__inv_2
XFILLER_8_380 VPWR VGND VPWR VGND sky130_ef_sc_hd__decap_12
XFILLER_105_418 VGND VGND VPWR VPWR sky130_fd_sc_hd__fill_2
XFILLER_132_204 VPWR VGND VPWR VGND sky130_ef_sc_hd__decap_12
XFILLER_99_641 VPWR VGND VPWR VGND sky130_ef_sc_hd__decap_12
Xfanout304 net79 VGND VGND VPWR VPWR net304 sky130_fd_sc_hd__buf_2
X_09813_ net488 net479 net344 net342 VGND VGND VPWR VPWR _02364_ sky130_fd_sc_hd__and4_1
Xfanout348 net53 VGND VGND VPWR VPWR net348 sky130_fd_sc_hd__buf_2
Xfanout337 net60 VGND VGND VPWR VPWR net337 sky130_fd_sc_hd__dlymetal6s2s_1
XFILLER_99_685 VPWR VGND VPWR VGND sky130_ef_sc_hd__decap_12
Xfanout326 net67 VGND VGND VPWR VPWR net326 sky130_fd_sc_hd__dlymetal6s2s_1
Xfanout315 net73 VGND VGND VPWR VPWR net315 sky130_fd_sc_hd__dlymetal6s2s_1
Xfanout359 net360 VGND VGND VPWR VPWR net359 sky130_fd_sc_hd__buf_2
X_09744_ _01610_ _02287_ VGND VGND VPWR VPWR _02289_ sky130_fd_sc_hd__xnor2_1
XFILLER_67_571 VGND VGND VPWR VPWR sky130_fd_sc_hd__decap_6
X_06956_ _02565_ _02844_ VGND VGND VPWR VPWR _02855_ sky130_fd_sc_hd__and2b_1
X_09675_ _02207_ _02211_ VGND VGND VPWR VPWR _02213_ sky130_fd_sc_hd__xor2_1
XFILLER_67_582 VGND VGND VPWR VPWR sky130_fd_sc_hd__decap_4
X_06887_ _02085_ _02096_ VGND VGND VPWR VPWR _02107_ sky130_fd_sc_hd__nor2_1
XFILLER_36_15 VPWR VGND VPWR VGND sky130_ef_sc_hd__decap_12
X_08626_ _01092_ VGND VGND VPWR VPWR _01093_ sky130_fd_sc_hd__inv_2
XTAP_TAPCELL_ROW_83_1509 VGND VPWR sky130_fd_sc_hd__tapvpwrvgnd_1
XFILLER_54_243 VGND VGND VPWR VPWR sky130_fd_sc_hd__decap_8
XFILLER_70_725 VPWR VGND VPWR VGND sky130_ef_sc_hd__decap_12
X_08557_ _01025_ VGND VGND VPWR VPWR _01026_ sky130_fd_sc_hd__inv_2
XFILLER_70_769 VPWR VGND VPWR VGND sky130_ef_sc_hd__decap_12
XTAP_TAPCELL_ROW_25_658 VGND VPWR sky130_fd_sc_hd__tapvpwrvgnd_1
X_08488_ _00959_ _00960_ VGND VGND VPWR VPWR _00961_ sky130_fd_sc_hd__and2b_1
X_07508_ _06579_ _06581_ _06578_ VGND VGND VPWR VPWR _06737_ sky130_fd_sc_hd__a21oi_1
X_07439_ net269 net261 _06665_ _06667_ VGND VGND VPWR VPWR _06669_ sky130_fd_sc_hd__or4b_1
XFILLER_22_184 VPWR VGND VPWR VGND sky130_ef_sc_hd__decap_12
XFILLER_6_306 VGND VGND VPWR VPWR sky130_fd_sc_hd__fill_2
X_10450_ _02856_ _02865_ _03047_ _03054_ VGND VGND VPWR VPWR _03055_ sky130_fd_sc_hd__a211o_1
X_09109_ _01592_ _01593_ _01589_ VGND VGND VPWR VPWR _01596_ sky130_fd_sc_hd__a21oi_1
X_10381_ _02851_ _02978_ VGND VGND VPWR VPWR _02979_ sky130_fd_sc_hd__and2_1
XFILLER_136_587 VGND VGND VPWR VPWR sky130_fd_sc_hd__fill_1
XFILLER_108_278 VPWR VGND VPWR VGND sky130_ef_sc_hd__decap_12
X_12120_ _04870_ _04872_ _04869_ VGND VGND VPWR VPWR _04874_ sky130_fd_sc_hd__o21bai_1
XFILLER_2_523 VGND VGND VPWR VPWR sky130_fd_sc_hd__decap_8
XFILLER_117_51 VGND VGND VPWR VPWR sky130_fd_sc_hd__decap_4
X_12051_ _04792_ _04796_ VGND VGND VPWR VPWR _04798_ sky130_fd_sc_hd__xnor2_1
XFILLER_7_3 VPWR VGND VPWR VGND sky130_ef_sc_hd__decap_12
XFILLER_2_545 VPWR VGND VPWR VGND sky130_ef_sc_hd__decap_12
XFILLER_132_793 VPWR VGND VPWR VGND sky130_ef_sc_hd__decap_12
XFILLER_77_55 VGND VGND VPWR VPWR sky130_fd_sc_hd__fill_1
X_11002_ _03455_ _03657_ VGND VGND VPWR VPWR _03658_ sky130_fd_sc_hd__nand2_1
XFILLER_131_281 VGND VGND VPWR VPWR sky130_fd_sc_hd__decap_6
XTAP_TAPCELL_ROW_125_2115 VGND VPWR sky130_fd_sc_hd__tapvpwrvgnd_1
XFILLER_92_305 VGND VGND VPWR VPWR sky130_fd_sc_hd__decap_3
XFILLER_77_368 VGND VGND VPWR VPWR sky130_fd_sc_hd__fill_2
XFILLER_65_519 VGND VGND VPWR VPWR sky130_fd_sc_hd__decap_8
XTAP_TAPCELL_ROW_5_372 VGND VPWR sky130_fd_sc_hd__tapvpwrvgnd_1
XFILLER_92_349 VPWR VGND VPWR VGND sky130_ef_sc_hd__decap_12
X_12953_ _05781_ _05782_ VGND VGND VPWR VPWR _05783_ sky130_fd_sc_hd__nand2b_1
X_11904_ _04347_ _04442_ _04548_ VGND VGND VPWR VPWR _04641_ sky130_fd_sc_hd__o21ai_1
X_12884_ _05705_ _05706_ VGND VGND VPWR VPWR _05708_ sky130_fd_sc_hd__xor2_1
XFILLER_73_596 VGND VGND VPWR VPWR sky130_fd_sc_hd__fill_2
XFILLER_33_405 VPWR VGND VPWR VGND sky130_ef_sc_hd__decap_12
XTAP_TAPCELL_ROW_44_934 VGND VPWR sky130_fd_sc_hd__tapvpwrvgnd_1
X_11835_ _04467_ _04565_ VGND VGND VPWR VPWR _04566_ sky130_fd_sc_hd__xnor2_1
XFILLER_33_438 VGND VGND VPWR VPWR sky130_fd_sc_hd__decap_3
X_11766_ _04464_ _04490_ VGND VGND VPWR VPWR _04491_ sky130_fd_sc_hd__xnor2_1
XFILLER_13_140 VGND VGND VPWR VPWR sky130_fd_sc_hd__decap_4
XTAP_TAPCELL_ROW_103_1789 VGND VPWR sky130_fd_sc_hd__tapvpwrvgnd_1
X_13505_ _06360_ _06385_ VGND VGND VPWR VPWR _06386_ sky130_fd_sc_hd__or2_1
X_10717_ _03193_ _03190_ _03344_ _03345_ VGND VGND VPWR VPWR _03346_ sky130_fd_sc_hd__a211o_4
X_13436_ _06220_ _06309_ _06306_ VGND VGND VPWR VPWR _06310_ sky130_fd_sc_hd__mux2_1
X_11697_ _04414_ _04415_ VGND VGND VPWR VPWR _04416_ sky130_fd_sc_hd__nor2_1
XTAP_TAPCELL_ROW_136_2277 VGND VPWR sky130_fd_sc_hd__tapvpwrvgnd_1
XTAP_TAPCELL_ROW_136_2266 VGND VPWR sky130_fd_sc_hd__tapvpwrvgnd_1
Xrebuffer3 _01345_ VGND VGND VPWR VPWR net722 sky130_fd_sc_hd__dlymetal6s2s_1
X_10648_ _03268_ _03269_ VGND VGND VPWR VPWR _03271_ sky130_fd_sc_hd__nor2_1
X_13367_ net418 net379 _06131_ VGND VGND VPWR VPWR _06235_ sky130_fd_sc_hd__a21oi_1
XFILLER_61_6 VPWR VGND VPWR VGND sky130_ef_sc_hd__decap_12
X_10579_ _03048_ _03051_ net234 _03195_ VGND VGND VPWR VPWR _03196_ sky130_fd_sc_hd__a211o_1
X_13298_ _05889_ _06158_ VGND VGND VPWR VPWR _06161_ sky130_fd_sc_hd__xnor2_2
X_12318_ net489 net407 _04981_ _04979_ VGND VGND VPWR VPWR _05090_ sky130_fd_sc_hd__a31o_1
XFILLER_5_350 VGND VGND VPWR VPWR sky130_fd_sc_hd__decap_4
XFILLER_130_708 VGND VGND VPWR VPWR sky130_fd_sc_hd__decap_8
X_12249_ _05012_ _05014_ VGND VGND VPWR VPWR _05015_ sky130_fd_sc_hd__nand2_1
XFILLER_95_110 VGND VGND VPWR VPWR sky130_fd_sc_hd__fill_2
X_07790_ _00267_ _00268_ VGND VGND VPWR VPWR _00269_ sky130_fd_sc_hd__and2b_1
X_09460_ _01610_ _01977_ VGND VGND VPWR VPWR _01979_ sky130_fd_sc_hd__xnor2_1
XFILLER_76_390 VGND VGND VPWR VPWR sky130_fd_sc_hd__decap_3
X_08411_ _00689_ _00786_ _00785_ VGND VGND VPWR VPWR _00885_ sky130_fd_sc_hd__a21o_1
X_09391_ _01901_ _01902_ VGND VGND VPWR VPWR _01904_ sky130_fd_sc_hd__nor2_1
XFILLER_91_393 VGND VGND VPWR VPWR sky130_fd_sc_hd__decap_6
XTAP_TAPCELL_ROW_65_1239 VGND VPWR sky130_fd_sc_hd__tapvpwrvgnd_1
XFILLER_52_769 VGND VGND VPWR VPWR sky130_fd_sc_hd__fill_1
XFILLER_24_449 VGND VGND VPWR VPWR sky130_fd_sc_hd__fill_1
X_08342_ _00814_ _00815_ VGND VGND VPWR VPWR _00816_ sky130_fd_sc_hd__nand2_1
XTAP_TAPCELL_ROW_22_617 VGND VPWR sky130_fd_sc_hd__tapvpwrvgnd_1
XFILLER_60_791 VGND VGND VPWR VPWR sky130_fd_sc_hd__fill_1
X_08273_ _00740_ _00746_ VGND VGND VPWR VPWR _00748_ sky130_fd_sc_hd__xnor2_1
XFILLER_20_633 VGND VGND VPWR VPWR sky130_fd_sc_hd__decap_8
X_07224_ net582 net691 net690 net592 VGND VGND VPWR VPWR _05777_ sky130_fd_sc_hd__a22o_1
XFILLER_118_521 VGND VGND VPWR VPWR sky130_fd_sc_hd__fill_1
X_07155_ net269 net611 VGND VGND VPWR VPWR _05024_ sky130_fd_sc_hd__nand2_1
XFILLER_106_749 VGND VGND VPWR VPWR sky130_fd_sc_hd__decap_6
X_07086_ net701 net700 net561 net553 VGND VGND VPWR VPWR _04275_ sky130_fd_sc_hd__and4_1
XFILLER_105_237 VGND VGND VPWR VPWR sky130_fd_sc_hd__decap_4
XFILLER_114_793 VPWR VGND VPWR VGND sky130_ef_sc_hd__decap_12
XFILLER_113_281 VGND VGND VPWR VPWR sky130_fd_sc_hd__decap_6
XFILLER_59_335 VGND VGND VPWR VPWR sky130_fd_sc_hd__fill_1
X_07988_ _00450_ _00464_ VGND VGND VPWR VPWR _00465_ sky130_fd_sc_hd__xnor2_1
XPHY_EDGE_ROW_114_Right_114 VGND VGND VPWR VPWR sky130_fd_sc_hd__decap_3
X_09727_ _02259_ _02268_ VGND VGND VPWR VPWR _02270_ sky130_fd_sc_hd__xnor2_1
XFILLER_74_338 VGND VGND VPWR VPWR sky130_fd_sc_hd__decap_4
XFILLER_47_69 VPWR VGND VPWR VGND sky130_ef_sc_hd__decap_12
XTAP_TAPCELL_ROW_2_331 VGND VPWR sky130_fd_sc_hd__tapvpwrvgnd_1
X_06939_ _02652_ _02663_ VGND VGND VPWR VPWR _02674_ sky130_fd_sc_hd__nor2_1
XFILLER_27_221 VGND VGND VPWR VPWR sky130_fd_sc_hd__decap_3
X_09658_ net360 net357 net540 net534 VGND VGND VPWR VPWR _02195_ sky130_fd_sc_hd__and4b_1
XTAP_TAPCELL_ROW_120_2045 VGND VPWR sky130_fd_sc_hd__tapvpwrvgnd_1
XTAP_TAPCELL_ROW_120_2034 VGND VPWR sky130_fd_sc_hd__tapvpwrvgnd_1
X_08609_ _01075_ _01076_ VGND VGND VPWR VPWR _00011_ sky130_fd_sc_hd__nor2_1
X_09589_ _01789_ _01959_ _02117_ VGND VGND VPWR VPWR _02120_ sky130_fd_sc_hd__a21oi_1
XFILLER_70_555 VGND VGND VPWR VPWR sky130_fd_sc_hd__fill_1
XFILLER_63_57 VGND VGND VPWR VPWR sky130_fd_sc_hd__decap_6
XFILLER_42_246 VGND VGND VPWR VPWR sky130_fd_sc_hd__decap_6
XFILLER_42_279 VPWR VGND VPWR VGND sky130_ef_sc_hd__decap_12
XFILLER_42_257 VGND VGND VPWR VPWR sky130_fd_sc_hd__fill_1
X_11620_ _04330_ _04331_ VGND VGND VPWR VPWR _04332_ sky130_fd_sc_hd__or2_1
XFILLER_30_419 VGND VGND VPWR VPWR sky130_fd_sc_hd__fill_1
X_11551_ _04247_ _04255_ VGND VGND VPWR VPWR _04257_ sky130_fd_sc_hd__xnor2_1
XFILLER_10_121 VGND VGND VPWR VPWR sky130_fd_sc_hd__decap_6
X_10502_ net503 net296 net294 net511 VGND VGND VPWR VPWR _03111_ sky130_fd_sc_hd__a22oi_2
XFILLER_6_125 VGND VGND VPWR VPWR sky130_fd_sc_hd__fill_1
XFILLER_6_103 VGND VGND VPWR VPWR sky130_fd_sc_hd__fill_1
X_11482_ _04179_ _04181_ VGND VGND VPWR VPWR _04182_ sky130_fd_sc_hd__nand2_1
XFILLER_136_351 VGND VGND VPWR VPWR sky130_fd_sc_hd__decap_4
X_13221_ net495 _00342_ _05946_ net395 VGND VGND VPWR VPWR _06076_ sky130_fd_sc_hd__o211ai_4
XFILLER_6_147 VGND VGND VPWR VPWR sky130_fd_sc_hd__fill_2
X_10433_ _03025_ _03027_ _03029_ _03034_ VGND VGND VPWR VPWR _03036_ sky130_fd_sc_hd__o211a_1
XFILLER_124_502 VPWR VGND VPWR VGND sky130_ef_sc_hd__decap_12
X_13152_ _05994_ _06000_ VGND VGND VPWR VPWR _06001_ sky130_fd_sc_hd__nand2_1
XFILLER_3_821 VGND VGND VPWR VPWR sky130_fd_sc_hd__decap_3
XFILLER_12_83 VGND VGND VPWR VPWR sky130_fd_sc_hd__fill_1
X_10364_ _02958_ _02959_ VGND VGND VPWR VPWR _02960_ sky130_fd_sc_hd__or2_1
XFILLER_128_83 VGND VGND VPWR VPWR sky130_fd_sc_hd__fill_1
XFILLER_97_408 VGND VGND VPWR VPWR sky130_fd_sc_hd__decap_8
X_12103_ _04852_ _04853_ _04854_ VGND VGND VPWR VPWR _04855_ sky130_fd_sc_hd__nand3_1
XTAP_TAPCELL_ROW_131_2196 VGND VPWR sky130_fd_sc_hd__tapvpwrvgnd_1
XFILLER_111_218 VGND VGND VPWR VPWR sky130_fd_sc_hd__decap_6
X_13083_ _05923_ _05924_ VGND VGND VPWR VPWR _05925_ sky130_fd_sc_hd__or2_1
XFILLER_88_65 VPWR VGND VPWR VGND sky130_ef_sc_hd__decap_12
XFILLER_2_342 VGND VGND VPWR VPWR sky130_fd_sc_hd__fill_1
X_10295_ _02883_ _02884_ VGND VGND VPWR VPWR _02885_ sky130_fd_sc_hd__and2b_1
XFILLER_104_270 VGND VGND VPWR VPWR sky130_fd_sc_hd__fill_1
X_12034_ _04777_ _04778_ VGND VGND VPWR VPWR _04779_ sky130_fd_sc_hd__nor2_1
XFILLER_77_165 VGND VGND VPWR VPWR sky130_fd_sc_hd__decap_3
XFILLER_77_143 VGND VGND VPWR VPWR sky130_fd_sc_hd__fill_1
XFILLER_120_785 VPWR VGND VPWR VGND sky130_ef_sc_hd__decap_12
XFILLER_92_124 VGND VGND VPWR VPWR sky130_fd_sc_hd__decap_8
Xfanout690 net112 VGND VGND VPWR VPWR net690 sky130_fd_sc_hd__clkbuf_2
XFILLER_46_541 VGND VGND VPWR VPWR sky130_fd_sc_hd__fill_2
XTAP_TAPCELL_ROW_105_1818 VGND VPWR sky130_fd_sc_hd__tapvpwrvgnd_1
X_12936_ _05603_ _05762_ VGND VGND VPWR VPWR _05764_ sky130_fd_sc_hd__xor2_1
XFILLER_73_371 VPWR VGND VPWR VGND sky130_ef_sc_hd__decap_12
XFILLER_18_265 VPWR VGND VPWR VGND sky130_ef_sc_hd__decap_12
X_12867_ net630 net621 net320 net303 VGND VGND VPWR VPWR _05689_ sky130_fd_sc_hd__and4_1
XFILLER_34_736 VPWR VGND VPWR VGND sky130_ef_sc_hd__decap_12
XFILLER_34_769 VPWR VGND VPWR VGND sky130_ef_sc_hd__decap_12
XTAP_TAPCELL_ROW_138_2306 VGND VPWR sky130_fd_sc_hd__tapvpwrvgnd_1
XFILLER_61_566 VPWR VGND VPWR VGND sky130_ef_sc_hd__decap_12
X_11818_ _04345_ _04442_ VGND VGND VPWR VPWR _04548_ sky130_fd_sc_hd__nand2_1
XFILLER_33_246 VPWR VGND VPWR VGND sky130_ef_sc_hd__decap_12
XFILLER_33_279 VGND VGND VPWR VPWR sky130_fd_sc_hd__fill_1
XTAP_TAPCELL_ROW_138_2317 VGND VPWR sky130_fd_sc_hd__tapvpwrvgnd_1
X_12798_ _05609_ _05610_ VGND VGND VPWR VPWR _05614_ sky130_fd_sc_hd__xor2_1
X_11749_ net521 net286 _04472_ VGND VGND VPWR VPWR _04473_ sky130_fd_sc_hd__and3_1
XTAP_TAPCELL_ROW_60_1169 VGND VPWR sky130_fd_sc_hd__tapvpwrvgnd_1
X_13419_ _06031_ _06292_ VGND VGND VPWR VPWR _06293_ sky130_fd_sc_hd__xnor2_1
XFILLER_5_191 VGND VGND VPWR VPWR sky130_fd_sc_hd__decap_8
X_08960_ _01309_ _01433_ VGND VGND VPWR VPWR _01434_ sky130_fd_sc_hd__and2b_1
XTAP_TAPCELL_ROW_75_1390 VGND VPWR sky130_fd_sc_hd__tapvpwrvgnd_1
X_08891_ _01357_ _01358_ VGND VGND VPWR VPWR _01359_ sky130_fd_sc_hd__nand2_1
XFILLER_111_741 VPWR VGND VPWR VGND sky130_ef_sc_hd__decap_12
XFILLER_102_229 VPWR VGND VPWR VGND sky130_ef_sc_hd__decap_12
X_07911_ _06658_ _00388_ VGND VGND VPWR VPWR _00389_ sky130_fd_sc_hd__xnor2_1
XFILLER_110_251 VGND VGND VPWR VPWR sky130_fd_sc_hd__fill_1
XFILLER_68_132 VGND VGND VPWR VPWR sky130_fd_sc_hd__decap_8
X_07842_ _00193_ _00195_ _00192_ VGND VGND VPWR VPWR _00320_ sky130_fd_sc_hd__a21oi_1
XFILLER_111_785 VPWR VGND VPWR VGND sky130_ef_sc_hd__decap_12
XFILLER_96_496 VGND VGND VPWR VPWR sky130_fd_sc_hd__decap_4
X_09512_ net567 net558 net355 net49 VGND VGND VPWR VPWR _02035_ sky130_fd_sc_hd__and4_1
X_07773_ _00243_ _00251_ VGND VGND VPWR VPWR _00252_ sky130_fd_sc_hd__xnor2_2
XFILLER_17_39 VPWR VGND VPWR VGND sky130_ef_sc_hd__decap_12
XFILLER_25_725 VGND VGND VPWR VPWR sky130_fd_sc_hd__decap_3
X_09443_ net465 net456 net65 VGND VGND VPWR VPWR _01960_ sky130_fd_sc_hd__o21ai_1
XFILLER_25_758 VPWR VGND VPWR VGND sky130_ef_sc_hd__decap_12
X_09374_ _01883_ _01884_ VGND VGND VPWR VPWR _01885_ sky130_fd_sc_hd__nand2b_1
XFILLER_12_419 VGND VGND VPWR VPWR sky130_fd_sc_hd__fill_1
XFILLER_33_27 VPWR VGND VPWR VGND sky130_ef_sc_hd__decap_12
X_08325_ _00797_ _00798_ VGND VGND VPWR VPWR _00799_ sky130_fd_sc_hd__nor2_1
XFILLER_137_137 VPWR VGND VPWR VGND sky130_ef_sc_hd__decap_12
X_08256_ _00726_ _00730_ VGND VGND VPWR VPWR _00731_ sky130_fd_sc_hd__nand2b_1
X_08187_ _00660_ _00661_ VGND VGND VPWR VPWR _00663_ sky130_fd_sc_hd__xor2_2
X_07207_ net699 net698 net561 net553 VGND VGND VPWR VPWR _05591_ sky130_fd_sc_hd__and4_1
XFILLER_134_811 VGND VGND VPWR VPWR sky130_fd_sc_hd__fill_1
X_07138_ net674 net673 net436 net426 VGND VGND VPWR VPWR _04838_ sky130_fd_sc_hd__and4_1
XFILLER_4_618 VGND VGND VPWR VPWR sky130_fd_sc_hd__fill_2
XTAP_TAPCELL_ROW_91_1619 VGND VPWR sky130_fd_sc_hd__tapvpwrvgnd_1
XFILLER_121_527 VGND VGND VPWR VPWR sky130_fd_sc_hd__decap_3
XFILLER_121_505 VGND VGND VPWR VPWR sky130_fd_sc_hd__decap_6
X_07069_ _03981_ _04035_ _04046_ VGND VGND VPWR VPWR _04090_ sky130_fd_sc_hd__a21oi_1
XTAP_TAPCELL_ROW_7_401 VGND VPWR sky130_fd_sc_hd__tapvpwrvgnd_1
XFILLER_0_813 VGND VGND VPWR VPWR sky130_fd_sc_hd__decap_8
X_10080_ _02235_ _02534_ _02653_ VGND VGND VPWR VPWR _02655_ sky130_fd_sc_hd__or3_1
XFILLER_59_132 VGND VGND VPWR VPWR sky130_fd_sc_hd__decap_6
XFILLER_114_41 VPWR VGND VPWR VGND sky130_ef_sc_hd__decap_12
XFILLER_47_305 VGND VGND VPWR VPWR sky130_fd_sc_hd__fill_1
XFILLER_114_85 VGND VGND VPWR VPWR sky130_fd_sc_hd__decap_3
XFILLER_90_606 VPWR VGND VPWR VGND sky130_ef_sc_hd__decap_12
XFILLER_75_658 VPWR VGND VPWR VGND sky130_ef_sc_hd__decap_12
XFILLER_47_349 VPWR VGND VPWR VGND sky130_ef_sc_hd__decap_12
X_10982_ net416 net279 VGND VGND VPWR VPWR _03636_ sky130_fd_sc_hd__nand2_1
X_12721_ _01464_ _00104_ _05528_ _05529_ VGND VGND VPWR VPWR _05531_ sky130_fd_sc_hd__or4_1
XFILLER_55_371 VGND VGND VPWR VPWR sky130_fd_sc_hd__decap_4
XFILLER_43_533 VGND VGND VPWR VPWR sky130_fd_sc_hd__decap_3
X_12652_ net480 net402 net400 net489 VGND VGND VPWR VPWR _05455_ sky130_fd_sc_hd__a22o_1
XFILLER_43_555 VGND VGND VPWR VPWR sky130_fd_sc_hd__decap_4
XFILLER_15_257 VGND VGND VPWR VPWR sky130_fd_sc_hd__decap_3
X_11603_ net301 net299 net535 net532 VGND VGND VPWR VPWR _04313_ sky130_fd_sc_hd__and4b_1
XFILLER_15_279 VGND VGND VPWR VPWR sky130_fd_sc_hd__fill_1
XFILLER_24_791 VPWR VGND VPWR VGND sky130_ef_sc_hd__decap_12
XTAP_TAPCELL_ROW_100_1748 VGND VPWR sky130_fd_sc_hd__tapvpwrvgnd_1
XFILLER_90_77 VGND VGND VPWR VPWR sky130_fd_sc_hd__decap_6
X_12583_ _05112_ _05205_ _05204_ VGND VGND VPWR VPWR _05380_ sky130_fd_sc_hd__o21ba_1
XFILLER_30_238 VGND VGND VPWR VPWR sky130_fd_sc_hd__fill_2
X_11534_ _04209_ _04237_ VGND VGND VPWR VPWR _04239_ sky130_fd_sc_hd__xnor2_1
XFILLER_23_71 VGND VGND VPWR VPWR sky130_fd_sc_hd__decap_6
XTAP_TAPCELL_ROW_133_2225 VGND VPWR sky130_fd_sc_hd__tapvpwrvgnd_1
X_11465_ _04162_ _04163_ VGND VGND VPWR VPWR _04164_ sky130_fd_sc_hd__nor2_1
XFILLER_137_693 VPWR VGND VPWR VGND sky130_ef_sc_hd__decap_12
XFILLER_99_42 VPWR VGND VPWR VGND sky130_ef_sc_hd__decap_12
X_13204_ net246 _06056_ VGND VGND VPWR VPWR _06057_ sky130_fd_sc_hd__nand2b_1
X_10416_ net468 net278 VGND VGND VPWR VPWR _03017_ sky130_fd_sc_hd__and2_1
XFILLER_98_706 VGND VGND VPWR VPWR sky130_fd_sc_hd__decap_8
X_11396_ _03427_ _04086_ VGND VGND VPWR VPWR _04088_ sky130_fd_sc_hd__xnor2_1
XFILLER_124_365 VPWR VGND VPWR VGND sky130_ef_sc_hd__decap_12
X_13135_ _05969_ _05981_ VGND VGND VPWR VPWR _05982_ sky130_fd_sc_hd__xnor2_2
X_10347_ _02939_ _02940_ VGND VGND VPWR VPWR _02941_ sky130_fd_sc_hd__nor2_1
X_13066_ _05900_ _05904_ VGND VGND VPWR VPWR _05906_ sky130_fd_sc_hd__xnor2_1
X_10278_ _02857_ _02864_ VGND VGND VPWR VPWR _02867_ sky130_fd_sc_hd__xor2_1
X_12017_ _04725_ _04759_ VGND VGND VPWR VPWR _04760_ sky130_fd_sc_hd__nor2_1
XFILLER_78_463 VPWR VGND VPWR VGND sky130_ef_sc_hd__decap_12
XFILLER_120_571 VGND VGND VPWR VPWR sky130_fd_sc_hd__fill_1
XFILLER_93_400 VPWR VGND VPWR VGND sky130_ef_sc_hd__decap_12
XFILLER_38_316 VPWR VGND VPWR VGND sky130_ef_sc_hd__decap_12
XFILLER_65_135 VPWR VGND VPWR VGND sky130_ef_sc_hd__decap_12
XFILLER_93_477 VGND VGND VPWR VPWR sky130_fd_sc_hd__decap_6
XFILLER_81_617 VPWR VGND VPWR VGND sky130_ef_sc_hd__decap_12
XTAP_TAPCELL_ROW_49_1009 VGND VPWR sky130_fd_sc_hd__tapvpwrvgnd_1
XFILLER_0_53 VGND VGND VPWR VPWR sky130_fd_sc_hd__decap_3
X_12919_ net548 net500 _05743_ VGND VGND VPWR VPWR _05746_ sky130_fd_sc_hd__a21oi_1
XFILLER_74_680 VGND VGND VPWR VPWR sky130_fd_sc_hd__decap_8
XFILLER_19_585 VGND VGND VPWR VPWR sky130_fd_sc_hd__fill_2
XFILLER_61_352 VGND VGND VPWR VPWR sky130_fd_sc_hd__fill_2
XFILLER_21_205 VGND VGND VPWR VPWR sky130_fd_sc_hd__decap_4
XFILLER_9_51 VGND VGND VPWR VPWR sky130_fd_sc_hd__decap_4
XTAP_TAPCELL_ROW_32_756 VGND VPWR sky130_fd_sc_hd__tapvpwrvgnd_1
X_09090_ _01413_ _01575_ VGND VGND VPWR VPWR _01576_ sky130_fd_sc_hd__xnor2_1
X_08110_ _00585_ _00577_ VGND VGND VPWR VPWR _00586_ sky130_fd_sc_hd__nand2b_1
XTAP_TAPCELL_ROW_32_767 VGND VPWR sky130_fd_sc_hd__tapvpwrvgnd_1
XFILLER_119_137 VGND VGND VPWR VPWR sky130_fd_sc_hd__decap_6
X_08041_ _00516_ _00517_ VGND VGND VPWR VPWR _00518_ sky130_fd_sc_hd__xor2_1
XTAP_TAPCELL_ROW_12_480 VGND VPWR sky130_fd_sc_hd__tapvpwrvgnd_1
XFILLER_134_129 VGND VGND VPWR VPWR sky130_fd_sc_hd__decap_3
XFILLER_116_811 VGND VGND VPWR VPWR sky130_fd_sc_hd__fill_1
XFILLER_128_693 VGND VGND VPWR VPWR sky130_fd_sc_hd__decap_3
XFILLER_115_332 VGND VGND VPWR VPWR sky130_fd_sc_hd__decap_4
X_09992_ _02556_ _02557_ VGND VGND VPWR VPWR _02559_ sky130_fd_sc_hd__xor2_1
X_08943_ net517 net54 net53 net508 VGND VGND VPWR VPWR _01415_ sky130_fd_sc_hd__a22o_1
X_08874_ _01337_ _01338_ _01311_ VGND VGND VPWR VPWR _01340_ sky130_fd_sc_hd__o21a_4
XFILLER_97_783 VGND VGND VPWR VPWR sky130_fd_sc_hd__fill_1
XFILLER_28_27 VGND VGND VPWR VPWR sky130_fd_sc_hd__fill_1
XFILLER_29_305 VGND VGND VPWR VPWR sky130_fd_sc_hd__decap_6
XFILLER_29_327 VGND VGND VPWR VPWR sky130_fd_sc_hd__decap_6
XFILLER_84_433 VPWR VGND VPWR VGND sky130_ef_sc_hd__decap_12
XFILLER_57_669 VGND VGND VPWR VPWR sky130_fd_sc_hd__decap_3
XFILLER_45_809 VGND VGND VPWR VPWR sky130_fd_sc_hd__decap_8
XFILLER_29_349 VPWR VGND VPWR VGND sky130_ef_sc_hd__decap_12
X_07825_ net691 net544 VGND VGND VPWR VPWR _00303_ sky130_fd_sc_hd__nand2_1
XTAP_TAPCELL_ROW_88_1570 VGND VPWR sky130_fd_sc_hd__tapvpwrvgnd_1
XFILLER_84_477 VGND VGND VPWR VPWR sky130_fd_sc_hd__decap_6
X_07756_ _00233_ _00234_ VGND VGND VPWR VPWR _00235_ sky130_fd_sc_hd__xnor2_1
XTAP_TAPCELL_ROW_88_1581 VGND VPWR sky130_fd_sc_hd__tapvpwrvgnd_1
XFILLER_65_680 VPWR VGND VPWR VGND sky130_ef_sc_hd__decap_12
XFILLER_44_15 VPWR VGND VPWR VGND sky130_ef_sc_hd__decap_12
XFILLER_25_533 VGND VGND VPWR VPWR sky130_fd_sc_hd__fill_2
XFILLER_37_393 VGND VGND VPWR VPWR sky130_fd_sc_hd__decap_4
X_09426_ _01933_ _01940_ VGND VGND VPWR VPWR _01941_ sky130_fd_sc_hd__xor2_1
XFILLER_80_661 VGND VGND VPWR VPWR sky130_fd_sc_hd__decap_4
X_07687_ _00164_ _00165_ VGND VGND VPWR VPWR _00166_ sky130_fd_sc_hd__or2_1
XFILLER_80_683 VGND VGND VPWR VPWR sky130_fd_sc_hd__fill_2
X_09357_ _01696_ _01865_ VGND VGND VPWR VPWR _01866_ sky130_fd_sc_hd__xor2_1
XFILLER_8_209 VGND VGND VPWR VPWR sky130_fd_sc_hd__decap_8
X_09288_ net453 net64 net65 net461 VGND VGND VPWR VPWR _01792_ sky130_fd_sc_hd__a22o_1
XFILLER_100_65 VPWR VGND VPWR VGND sky130_ef_sc_hd__decap_12
X_08308_ _00721_ _00782_ VGND VGND VPWR VPWR _00783_ sky130_fd_sc_hd__xnor2_1
XFILLER_21_783 VGND VGND VPWR VPWR sky130_fd_sc_hd__fill_1
XFILLER_138_468 VGND VGND VPWR VPWR sky130_fd_sc_hd__decap_3
X_08239_ _00584_ _00586_ _00712_ VGND VGND VPWR VPWR _00714_ sky130_fd_sc_hd__a21o_1
XTAP_TAPCELL_ROW_10_439 VGND VPWR sky130_fd_sc_hd__tapvpwrvgnd_1
XFILLER_119_671 VGND VGND VPWR VPWR sky130_fd_sc_hd__fill_1
XFILLER_134_641 VGND VGND VPWR VPWR sky130_fd_sc_hd__decap_3
XFILLER_107_3 VPWR VGND VPWR VGND sky130_ef_sc_hd__decap_12
X_11250_ _03927_ _03928_ VGND VGND VPWR VPWR _03929_ sky130_fd_sc_hd__xor2_1
XFILLER_134_652 VGND VGND VPWR VPWR sky130_fd_sc_hd__fill_1
X_10201_ _02720_ _02731_ _02730_ VGND VGND VPWR VPWR _02786_ sky130_fd_sc_hd__o21ba_1
XFILLER_106_365 VPWR VGND VPWR VGND sky130_ef_sc_hd__decap_12
X_11181_ _03800_ _03853_ VGND VGND VPWR VPWR _03854_ sky130_fd_sc_hd__xor2_1
X_10132_ _02698_ _02710_ VGND VGND VPWR VPWR _02711_ sky130_fd_sc_hd__xnor2_1
XFILLER_106_387 VGND VGND VPWR VPWR sky130_fd_sc_hd__decap_8
XFILLER_125_51 VGND VGND VPWR VPWR sky130_fd_sc_hd__decap_4
XFILLER_121_357 VGND VGND VPWR VPWR sky130_fd_sc_hd__decap_3
X_10063_ net534 net540 net354 VGND VGND VPWR VPWR _02636_ sky130_fd_sc_hd__mux2_1
XFILLER_121_379 VGND VGND VPWR VPWR sky130_fd_sc_hd__fill_1
XFILLER_88_794 VPWR VGND VPWR VGND sky130_ef_sc_hd__decap_12
XFILLER_75_400 VGND VGND VPWR VPWR sky130_fd_sc_hd__decap_8
XFILLER_47_113 VGND VGND VPWR VPWR sky130_fd_sc_hd__decap_8
XFILLER_0_698 VGND VGND VPWR VPWR sky130_fd_sc_hd__fill_2
XFILLER_85_55 VGND VGND VPWR VPWR sky130_fd_sc_hd__fill_1
XFILLER_48_669 VPWR VGND VPWR VGND sky130_ef_sc_hd__decap_12
XFILLER_47_146 VPWR VGND VPWR VGND sky130_ef_sc_hd__decap_12
XFILLER_28_360 VGND VGND VPWR VPWR sky130_fd_sc_hd__decap_4
XFILLER_16_533 VGND VGND VPWR VPWR sky130_fd_sc_hd__fill_2
XFILLER_18_82 VGND VGND VPWR VPWR sky130_fd_sc_hd__fill_2
X_12704_ _05339_ _05343_ VGND VGND VPWR VPWR _05512_ sky130_fd_sc_hd__nand2_1
X_10965_ net521 net286 VGND VGND VPWR VPWR _03617_ sky130_fd_sc_hd__nand2_4
XFILLER_70_160 VGND VGND VPWR VPWR sky130_fd_sc_hd__fill_1
X_10896_ net553 net309 _03374_ _03373_ VGND VGND VPWR VPWR _03541_ sky130_fd_sc_hd__a31oi_1
X_13684_ clknet_3_0__leaf_clk _00019_ net715 VGND VGND VPWR VPWR net203 sky130_fd_sc_hd__dfrtp_1
XFILLER_16_599 VPWR VGND VPWR VGND sky130_ef_sc_hd__decap_12
X_12635_ _05427_ _05433_ VGND VGND VPWR VPWR _05436_ sky130_fd_sc_hd__xor2_1
XFILLER_129_424 VGND VGND VPWR VPWR sky130_fd_sc_hd__fill_2
X_12566_ _05347_ _05360_ VGND VGND VPWR VPWR _05361_ sky130_fd_sc_hd__nor2_1
XFILLER_7_231 VGND VGND VPWR VPWR sky130_fd_sc_hd__fill_1
XFILLER_11_293 VGND VGND VPWR VPWR sky130_fd_sc_hd__decap_6
X_11517_ net521 net286 _04088_ _04087_ VGND VGND VPWR VPWR _04220_ sky130_fd_sc_hd__a31o_1
X_12497_ net531 net394 VGND VGND VPWR VPWR _05285_ sky130_fd_sc_hd__and2_2
XFILLER_125_641 VGND VGND VPWR VPWR sky130_fd_sc_hd__fill_1
XFILLER_109_181 VGND VGND VPWR VPWR sky130_fd_sc_hd__decap_8
XTAP_TAPCELL_ROW_59_1160 VGND VPWR sky130_fd_sc_hd__tapvpwrvgnd_1
X_11448_ _04142_ _04143_ VGND VGND VPWR VPWR _04146_ sky130_fd_sc_hd__xor2_1
XTAP_TAPCELL_ROW_113_1939 VGND VPWR sky130_fd_sc_hd__tapvpwrvgnd_1
X_11379_ net483 net474 net290 net288 VGND VGND VPWR VPWR _04070_ sky130_fd_sc_hd__and4_1
XFILLER_112_302 VGND VGND VPWR VPWR sky130_fd_sc_hd__decap_6
X_13118_ _05950_ _05962_ VGND VGND VPWR VPWR _05964_ sky130_fd_sc_hd__xor2_1
XFILLER_3_481 VPWR VGND VPWR VGND sky130_ef_sc_hd__decap_12
XFILLER_124_195 VGND VGND VPWR VPWR sky130_fd_sc_hd__fill_1
X_13049_ _05588_ _05757_ _05756_ VGND VGND VPWR VPWR _05888_ sky130_fd_sc_hd__a21oi_1
XPHY_EDGE_ROW_0_Left_139 VGND VGND VPWR VPWR sky130_fd_sc_hd__decap_3
XFILLER_22_3 VPWR VGND VPWR VGND sky130_ef_sc_hd__decap_12
XFILLER_27_809 VGND VGND VPWR VPWR sky130_fd_sc_hd__decap_8
XFILLER_39_669 VGND VGND VPWR VPWR sky130_fd_sc_hd__decap_3
X_08590_ _01049_ _01056_ VGND VGND VPWR VPWR _01058_ sky130_fd_sc_hd__xor2_1
XFILLER_94_775 VGND VGND VPWR VPWR sky130_fd_sc_hd__decap_3
X_07610_ _06688_ _06690_ VGND VGND VPWR VPWR _00090_ sky130_fd_sc_hd__nor2_1
XFILLER_53_138 VGND VGND VPWR VPWR sky130_fd_sc_hd__decap_3
X_07541_ _05985_ _06604_ _06605_ VGND VGND VPWR VPWR _06770_ sky130_fd_sc_hd__o21bai_1
XFILLER_19_393 VGND VGND VPWR VPWR sky130_fd_sc_hd__decap_8
XTAP_TAPCELL_ROW_37_837 VGND VPWR sky130_fd_sc_hd__tapvpwrvgnd_1
XFILLER_50_801 VGND VGND VPWR VPWR sky130_fd_sc_hd__decap_8
X_07472_ _06686_ _06701_ VGND VGND VPWR VPWR _06702_ sky130_fd_sc_hd__nor2_1
XTAP_TAPCELL_ROW_17_550 VGND VPWR sky130_fd_sc_hd__tapvpwrvgnd_1
XFILLER_22_525 VGND VGND VPWR VPWR sky130_fd_sc_hd__decap_6
X_09211_ _01705_ _01706_ VGND VGND VPWR VPWR _01707_ sky130_fd_sc_hd__xnor2_1
XFILLER_14_29 VPWR VGND VPWR VGND sky130_ef_sc_hd__decap_12
XFILLER_22_569 VPWR VGND VPWR VGND sky130_ef_sc_hd__decap_12
X_09142_ _01608_ _01631_ VGND VGND VPWR VPWR _01632_ sky130_fd_sc_hd__xnor2_1
X_09073_ _01548_ _01556_ VGND VGND VPWR VPWR _01557_ sky130_fd_sc_hd__nand2_1
X_08024_ _00470_ _00499_ VGND VGND VPWR VPWR _00501_ sky130_fd_sc_hd__xnor2_2
XFILLER_115_140 VPWR VGND VPWR VGND sky130_ef_sc_hd__decap_12
XFILLER_39_15 VPWR VGND VPWR VGND sky130_ef_sc_hd__decap_12
XFILLER_130_121 VPWR VGND VPWR VGND sky130_ef_sc_hd__decap_12
X_09975_ net525 net342 _02539_ VGND VGND VPWR VPWR _02540_ sky130_fd_sc_hd__and3_1
X_08926_ _01261_ _01395_ VGND VGND VPWR VPWR _01396_ sky130_fd_sc_hd__xnor2_1
XFILLER_76_219 VGND VGND VPWR VPWR sky130_fd_sc_hd__decap_8
X_08857_ _01320_ _01321_ _01322_ VGND VGND VPWR VPWR _01323_ sky130_fd_sc_hd__or3_4
XFILLER_84_241 VGND VGND VPWR VPWR sky130_fd_sc_hd__decap_4
XFILLER_72_403 VGND VGND VPWR VPWR sky130_fd_sc_hd__decap_4
XFILLER_45_617 VPWR VGND VPWR VGND sky130_ef_sc_hd__decap_12
X_07808_ _06731_ _00286_ VGND VGND VPWR VPWR _00287_ sky130_fd_sc_hd__xnor2_1
X_08788_ net595 net585 net359 net357 VGND VGND VPWR VPWR _01254_ sky130_fd_sc_hd__and4_1
XFILLER_55_69 VPWR VGND VPWR VGND sky130_ef_sc_hd__decap_12
XFILLER_45_639 VGND VGND VPWR VPWR sky130_fd_sc_hd__decap_3
XFILLER_44_105 VGND VGND VPWR VPWR sky130_fd_sc_hd__decap_8
XFILLER_72_469 VGND VGND VPWR VPWR sky130_fd_sc_hd__decap_6
X_07739_ _00215_ _00216_ VGND VGND VPWR VPWR _00218_ sky130_fd_sc_hd__and2b_1
XFILLER_111_42 VPWR VGND VPWR VGND sky130_ef_sc_hd__decap_12
XFILLER_53_683 VGND VGND VPWR VPWR sky130_fd_sc_hd__fill_2
X_10750_ _03227_ _03381_ VGND VGND VPWR VPWR _03382_ sky130_fd_sc_hd__xnor2_1
XFILLER_13_503 VGND VGND VPWR VPWR sky130_fd_sc_hd__fill_1
X_09409_ net496 net346 VGND VGND VPWR VPWR _01923_ sky130_fd_sc_hd__nand2_1
XFILLER_52_193 VGND VGND VPWR VPWR sky130_fd_sc_hd__decap_3
X_10681_ net466 net604 net327 net273 VGND VGND VPWR VPWR _03307_ sky130_fd_sc_hd__and4_1
XFILLER_40_344 VPWR VGND VPWR VGND sky130_ef_sc_hd__decap_12
X_12420_ _05142_ _05200_ _05201_ VGND VGND VPWR VPWR _05202_ sky130_fd_sc_hd__nand3_1
XFILLER_71_57 VGND VGND VPWR VPWR sky130_fd_sc_hd__decap_6
XFILLER_138_287 VGND VGND VPWR VPWR sky130_fd_sc_hd__decap_3
XFILLER_138_265 VPWR VGND VPWR VGND sky130_ef_sc_hd__decap_12
X_12351_ _05124_ _05125_ VGND VGND VPWR VPWR _05126_ sky130_fd_sc_hd__xnor2_1
XFILLER_126_438 VPWR VGND VPWR VGND sky130_ef_sc_hd__decap_12
X_12282_ _04997_ _05048_ _05049_ VGND VGND VPWR VPWR _05051_ sky130_fd_sc_hd__or3_4
X_11302_ net609 net317 VGND VGND VPWR VPWR _03986_ sky130_fd_sc_hd__nand2_1
X_11233_ _03739_ _03750_ _03749_ VGND VGND VPWR VPWR _03910_ sky130_fd_sc_hd__a21oi_1
XFILLER_20_94 VGND VGND VPWR VPWR sky130_fd_sc_hd__decap_4
XFILLER_136_83 VGND VGND VPWR VPWR sky130_fd_sc_hd__fill_1
XFILLER_121_121 VGND VGND VPWR VPWR sky130_fd_sc_hd__fill_2
X_11164_ _03833_ _03834_ VGND VGND VPWR VPWR _03835_ sky130_fd_sc_hd__nor2_1
XFILLER_121_154 VPWR VGND VPWR VGND sky130_ef_sc_hd__decap_12
X_10115_ _02596_ _02690_ VGND VGND VPWR VPWR _02692_ sky130_fd_sc_hd__and2_1
XFILLER_96_65 VPWR VGND VPWR VGND sky130_ef_sc_hd__decap_12
XFILLER_48_411 VGND VGND VPWR VPWR sky130_fd_sc_hd__decap_8
X_11095_ _03720_ _03757_ VGND VGND VPWR VPWR _03759_ sky130_fd_sc_hd__xnor2_1
XTAP_TAPCELL_ROW_128_2157 VGND VPWR sky130_fd_sc_hd__tapvpwrvgnd_1
X_10046_ _02615_ _02616_ VGND VGND VPWR VPWR _02617_ sky130_fd_sc_hd__xor2_1
XFILLER_76_775 VGND VGND VPWR VPWR sky130_fd_sc_hd__fill_1
XFILLER_76_764 VGND VGND VPWR VPWR sky130_fd_sc_hd__fill_1
XFILLER_91_756 VPWR VGND VPWR VGND sky130_ef_sc_hd__decap_12
XFILLER_91_723 VGND VGND VPWR VPWR sky130_fd_sc_hd__decap_4
XFILLER_76_797 VPWR VGND VPWR VGND sky130_ef_sc_hd__decap_12
XFILLER_63_447 VGND VGND VPWR VPWR sky130_fd_sc_hd__fill_1
XFILLER_48_488 VGND VGND VPWR VPWR sky130_fd_sc_hd__fill_1
X_11997_ net572 net711 _04737_ _04738_ VGND VGND VPWR VPWR _04739_ sky130_fd_sc_hd__and4_1
XFILLER_51_609 VGND VGND VPWR VPWR sky130_fd_sc_hd__decap_6
X_10948_ net257 net297 VGND VGND VPWR VPWR _03599_ sky130_fd_sc_hd__nor2_1
XFILLER_71_480 VGND VGND VPWR VPWR sky130_fd_sc_hd__decap_4
X_13667_ clknet_3_5__leaf_clk _00061_ net719 VGND VGND VPWR VPWR net186 sky130_fd_sc_hd__dfrtp_1
X_10879_ _03519_ _03520_ VGND VGND VPWR VPWR _03524_ sky130_fd_sc_hd__xnor2_1
X_12618_ _05405_ _05408_ _05416_ VGND VGND VPWR VPWR _05418_ sky130_fd_sc_hd__or3_1
X_13598_ _06300_ _06478_ _06477_ VGND VGND VPWR VPWR _06487_ sky130_fd_sc_hd__o21ai_1
XFILLER_12_580 VGND VGND VPWR VPWR sky130_fd_sc_hd__decap_8
XFILLER_117_405 VPWR VGND VPWR VGND sky130_ef_sc_hd__decap_12
X_12549_ net625 net5 _05339_ _05340_ VGND VGND VPWR VPWR _05343_ sky130_fd_sc_hd__nand4_1
XFILLER_117_449 VPWR VGND VPWR VGND sky130_ef_sc_hd__decap_12
XTAP_TAPCELL_ROW_57_1119 VGND VPWR sky130_fd_sc_hd__tapvpwrvgnd_1
XFILLER_6_41 VPWR VGND VPWR VGND sky130_ef_sc_hd__decap_12
XANTENNA_1 _01355_ VGND VGND VPWR VPWR sky130_fd_sc_hd__diode_2
XFILLER_6_85 VPWR VGND VPWR VGND sky130_ef_sc_hd__decap_12
Xfanout508 net509 VGND VGND VPWR VPWR net508 sky130_fd_sc_hd__clkbuf_2
XFILLER_112_132 VGND VGND VPWR VPWR sky130_fd_sc_hd__fill_1
XFILLER_98_344 VGND VGND VPWR VPWR sky130_fd_sc_hd__decap_4
XTAP_TAPCELL_ROW_70_1319 VGND VPWR sky130_fd_sc_hd__tapvpwrvgnd_1
XTAP_TAPCELL_ROW_70_1308 VGND VPWR sky130_fd_sc_hd__tapvpwrvgnd_1
Xfanout519 net520 VGND VGND VPWR VPWR net519 sky130_fd_sc_hd__buf_2
X_09760_ _02223_ _02306_ VGND VGND VPWR VPWR _02307_ sky130_fd_sc_hd__nand2_1
XFILLER_112_154 VGND VGND VPWR VPWR sky130_fd_sc_hd__fill_2
XFILLER_101_817 VGND VGND VPWR VPWR sky130_fd_sc_hd__decap_3
XFILLER_98_377 VPWR VGND VPWR VGND sky130_ef_sc_hd__decap_12
XFILLER_86_528 VGND VGND VPWR VPWR sky130_fd_sc_hd__decap_4
X_06972_ net526 net147 net684 VGND VGND VPWR VPWR _03030_ sky130_fd_sc_hd__and3_1
X_09691_ _02229_ _02230_ VGND VGND VPWR VPWR _02231_ sky130_fd_sc_hd__xnor2_1
X_08711_ _01165_ _01176_ _01177_ VGND VGND VPWR VPWR _01178_ sky130_fd_sc_hd__nand3_1
XFILLER_67_753 VPWR VGND VPWR VGND sky130_ef_sc_hd__decap_12
X_08642_ _01061_ _01064_ _01108_ VGND VGND VPWR VPWR _01109_ sky130_fd_sc_hd__o21a_1
XFILLER_82_701 VGND VGND VPWR VPWR sky130_fd_sc_hd__fill_1
XFILLER_27_617 VPWR VGND VPWR VGND sky130_ef_sc_hd__decap_12
XFILLER_82_734 VGND VGND VPWR VPWR sky130_fd_sc_hd__fill_1
XFILLER_81_200 VPWR VGND VPWR VGND sky130_ef_sc_hd__decap_12
XFILLER_67_797 VPWR VGND VPWR VGND sky130_ef_sc_hd__decap_12
XFILLER_27_639 VGND VGND VPWR VPWR sky130_fd_sc_hd__decap_3
X_08573_ _01009_ _01040_ VGND VGND VPWR VPWR _01041_ sky130_fd_sc_hd__and2_1
XFILLER_81_233 VGND VGND VPWR VPWR sky130_fd_sc_hd__fill_1
XFILLER_25_39 VPWR VGND VPWR VGND sky130_ef_sc_hd__decap_12
X_07524_ _06743_ _06751_ VGND VGND VPWR VPWR _06753_ sky130_fd_sc_hd__xnor2_1
X_07455_ _06683_ _06684_ VGND VGND VPWR VPWR _06685_ sky130_fd_sc_hd__and2b_1
XFILLER_10_506 VGND VGND VPWR VPWR sky130_fd_sc_hd__decap_4
X_07386_ _06613_ _06614_ VGND VGND VPWR VPWR _06616_ sky130_fd_sc_hd__nor2_1
XFILLER_10_528 VGND VGND VPWR VPWR sky130_fd_sc_hd__decap_4
XFILLER_41_27 VPWR VGND VPWR VGND sky130_ef_sc_hd__decap_12
XFILLER_108_416 VGND VGND VPWR VPWR sky130_fd_sc_hd__decap_4
X_09125_ _01611_ _01612_ VGND VGND VPWR VPWR _01613_ sky130_fd_sc_hd__nand2_1
X_09056_ _01385_ _01537_ VGND VGND VPWR VPWR _01538_ sky130_fd_sc_hd__xnor2_1
XFILLER_136_769 VPWR VGND VPWR VGND sky130_ef_sc_hd__decap_12
XTAP_TAPCELL_ROW_20_589 VGND VPWR sky130_fd_sc_hd__tapvpwrvgnd_1
XFILLER_135_257 VGND VGND VPWR VPWR sky130_fd_sc_hd__fill_1
X_08007_ _00483_ _00477_ VGND VGND VPWR VPWR _00484_ sky130_fd_sc_hd__nand2b_1
XTAP_TAPCELL_ROW_96_1691 VGND VPWR sky130_fd_sc_hd__tapvpwrvgnd_1
XFILLER_116_493 VGND VGND VPWR VPWR sky130_fd_sc_hd__decap_6
XFILLER_1_237 VGND VGND VPWR VPWR sky130_fd_sc_hd__fill_2
X_09958_ _02519_ _02520_ VGND VGND VPWR VPWR _02522_ sky130_fd_sc_hd__nand2_1
XFILLER_106_53 VPWR VGND VPWR VGND sky130_ef_sc_hd__decap_12
XFILLER_104_699 VGND VGND VPWR VPWR sky130_fd_sc_hd__fill_1
XFILLER_89_366 VGND VGND VPWR VPWR sky130_fd_sc_hd__decap_8
XFILLER_49_208 VGND VGND VPWR VPWR sky130_fd_sc_hd__decap_8
X_08909_ net541 net366 _01377_ VGND VGND VPWR VPWR _01378_ sky130_fd_sc_hd__a21o_1
X_09889_ _02446_ VGND VGND VPWR VPWR _02447_ sky130_fd_sc_hd__inv_2
XFILLER_85_561 VGND VGND VPWR VPWR sky130_fd_sc_hd__fill_1
XFILLER_85_550 VGND VGND VPWR VPWR sky130_fd_sc_hd__decap_3
XFILLER_122_41 VPWR VGND VPWR VGND sky130_ef_sc_hd__decap_12
XFILLER_72_222 VGND VGND VPWR VPWR sky130_fd_sc_hd__decap_6
XFILLER_57_296 VGND VGND VPWR VPWR sky130_fd_sc_hd__decap_3
X_11920_ _04655_ _04658_ VGND VGND VPWR VPWR _04659_ sky130_fd_sc_hd__xnor2_1
XFILLER_72_233 VPWR VGND VPWR VGND sky130_ef_sc_hd__decap_12
XFILLER_45_447 VGND VGND VPWR VPWR sky130_fd_sc_hd__fill_1
X_11851_ net248 _04583_ VGND VGND VPWR VPWR _04584_ sky130_fd_sc_hd__xor2_1
XTAP_TAPCELL_ROW_123_2087 VGND VPWR sky130_fd_sc_hd__tapvpwrvgnd_1
XTAP_TAPCELL_ROW_123_2076 VGND VPWR sky130_fd_sc_hd__tapvpwrvgnd_1
XFILLER_122_85 VPWR VGND VPWR VGND sky130_ef_sc_hd__decap_12
XFILLER_60_417 VGND VGND VPWR VPWR sky130_fd_sc_hd__decap_3
XTAP_TAPCELL_ROW_0_281 VGND VPWR sky130_fd_sc_hd__tapvpwrvgnd_1
X_11782_ net249 _04508_ VGND VGND VPWR VPWR _04509_ sky130_fd_sc_hd__or2_1
X_10802_ net426 net279 _03436_ _03437_ VGND VGND VPWR VPWR _03439_ sky130_fd_sc_hd__nand4_1
X_13521_ _06031_ _06292_ _06290_ VGND VGND VPWR VPWR _06404_ sky130_fd_sc_hd__a21oi_1
XTAP_TAPCELL_ROW_0_292 VGND VPWR sky130_fd_sc_hd__tapvpwrvgnd_1
X_10733_ _03224_ _03243_ _03241_ VGND VGND VPWR VPWR _03363_ sky130_fd_sc_hd__o21bai_1
XFILLER_25_193 VGND VGND VPWR VPWR sky130_fd_sc_hd__fill_2
XFILLER_9_304 VGND VGND VPWR VPWR sky130_fd_sc_hd__fill_2
XFILLER_40_141 VGND VGND VPWR VPWR sky130_fd_sc_hd__decap_8
XFILLER_40_152 VPWR VGND VPWR VGND sky130_ef_sc_hd__decap_12
X_13452_ _06327_ _06326_ VGND VGND VPWR VPWR _06328_ sky130_fd_sc_hd__and2b_1
XFILLER_9_337 VGND VGND VPWR VPWR sky130_fd_sc_hd__decap_3
X_10664_ net443 net93 VGND VGND VPWR VPWR _03288_ sky130_fd_sc_hd__nand2_1
XFILLER_127_714 VGND VGND VPWR VPWR sky130_fd_sc_hd__fill_2
X_13383_ _06251_ _06252_ VGND VGND VPWR VPWR _06253_ sky130_fd_sc_hd__nor2_1
X_12403_ _05180_ _05181_ _05179_ VGND VGND VPWR VPWR _05183_ sky130_fd_sc_hd__o21ai_1
X_10595_ _03210_ _03211_ VGND VGND VPWR VPWR _03212_ sky130_fd_sc_hd__nor2_1
XFILLER_127_736 VGND VGND VPWR VPWR sky130_fd_sc_hd__decap_6
X_12334_ _05105_ _05106_ VGND VGND VPWR VPWR _05107_ sky130_fd_sc_hd__or2_1
XFILLER_5_532 VGND VGND VPWR VPWR sky130_fd_sc_hd__decap_4
XFILLER_5_565 VGND VGND VPWR VPWR sky130_fd_sc_hd__fill_1
XPHY_EDGE_ROW_128_Right_128 VGND VGND VPWR VPWR sky130_fd_sc_hd__decap_3
XFILLER_107_482 VGND VGND VPWR VPWR sky130_fd_sc_hd__fill_2
X_12265_ _05029_ _05028_ _05030_ VGND VGND VPWR VPWR _05032_ sky130_fd_sc_hd__a21o_1
X_12196_ _04775_ _04777_ VGND VGND VPWR VPWR _04956_ sky130_fd_sc_hd__nor2_1
X_11216_ net535 net307 net308 net263 VGND VGND VPWR VPWR _03891_ sky130_fd_sc_hd__o2bb2a_1
XFILLER_122_485 VGND VGND VPWR VPWR sky130_fd_sc_hd__decap_3
XFILLER_122_463 VPWR VGND VPWR VGND sky130_ef_sc_hd__decap_12
XFILLER_68_539 VGND VGND VPWR VPWR sky130_fd_sc_hd__fill_1
XFILLER_68_528 VGND VGND VPWR VPWR sky130_fd_sc_hd__decap_4
XTAP_TAPCELL_ROW_52_1049 VGND VPWR sky130_fd_sc_hd__tapvpwrvgnd_1
X_11147_ _03802_ _03815_ VGND VGND VPWR VPWR _03816_ sky130_fd_sc_hd__nor2_1
XFILLER_0_281 VGND VGND VPWR VPWR sky130_fd_sc_hd__fill_2
Xinput160 x3[6] VGND VGND VPWR VPWR net160 sky130_fd_sc_hd__clkbuf_2
X_11078_ _03601_ _03610_ _03608_ VGND VGND VPWR VPWR _03741_ sky130_fd_sc_hd__a21oi_1
X_10029_ _02515_ _02598_ VGND VGND VPWR VPWR _02599_ sky130_fd_sc_hd__and2b_1
XFILLER_76_583 VGND VGND VPWR VPWR sky130_fd_sc_hd__decap_4
XFILLER_49_797 VPWR VGND VPWR VGND sky130_ef_sc_hd__decap_12
XFILLER_48_263 VGND VGND VPWR VPWR sky130_fd_sc_hd__fill_1
XPHY_EDGE_ROW_90_Left_229 VGND VGND VPWR VPWR sky130_fd_sc_hd__decap_3
XFILLER_64_767 VPWR VGND VPWR VGND sky130_ef_sc_hd__decap_12
XTAP_TAPCELL_ROW_67_1270 VGND VPWR sky130_fd_sc_hd__tapvpwrvgnd_1
XFILLER_63_277 VGND VGND VPWR VPWR sky130_fd_sc_hd__decap_3
XTAP_TAPCELL_ROW_47_987 VGND VPWR sky130_fd_sc_hd__tapvpwrvgnd_1
XTAP_TAPCELL_ROW_47_976 VGND VPWR sky130_fd_sc_hd__tapvpwrvgnd_1
XFILLER_16_193 VGND VGND VPWR VPWR sky130_fd_sc_hd__decap_3
X_07240_ _05941_ _05559_ VGND VGND VPWR VPWR _05952_ sky130_fd_sc_hd__and2b_1
XFILLER_118_714 VPWR VGND VPWR VGND sky130_ef_sc_hd__decap_12
X_07171_ _05166_ _05177_ _05188_ VGND VGND VPWR VPWR _05199_ sky130_fd_sc_hd__and3_1
XFILLER_8_392 VPWR VGND VPWR VGND sky130_ef_sc_hd__decap_12
XFILLER_133_739 VPWR VGND VPWR VGND sky130_ef_sc_hd__decap_12
XFILLER_132_216 VGND VGND VPWR VPWR sky130_fd_sc_hd__decap_8
XFILLER_113_430 VPWR VGND VPWR VGND sky130_ef_sc_hd__decap_12
XFILLER_99_653 VGND VGND VPWR VPWR sky130_fd_sc_hd__decap_8
Xfanout305 net79 VGND VGND VPWR VPWR net305 sky130_fd_sc_hd__clkbuf_2
X_09812_ _02232_ _02234_ _02362_ VGND VGND VPWR VPWR _02363_ sky130_fd_sc_hd__o21ai_4
XFILLER_99_697 VGND VGND VPWR VPWR sky130_fd_sc_hd__decap_4
XFILLER_98_174 VGND VGND VPWR VPWR sky130_fd_sc_hd__fill_1
XFILLER_98_141 VPWR VGND VPWR VGND sky130_ef_sc_hd__decap_12
Xfanout338 net6 VGND VGND VPWR VPWR net338 sky130_fd_sc_hd__clkbuf_4
Xfanout327 net66 VGND VGND VPWR VPWR net327 sky130_fd_sc_hd__clkbuf_4
Xfanout316 net72 VGND VGND VPWR VPWR net316 sky130_fd_sc_hd__buf_2
Xfanout349 net52 VGND VGND VPWR VPWR net349 sky130_fd_sc_hd__clkbuf_4
XFILLER_98_185 VGND VGND VPWR VPWR sky130_fd_sc_hd__decap_8
XPHY_EDGE_ROW_129_Left_268 VGND VGND VPWR VPWR sky130_fd_sc_hd__decap_3
X_09743_ _01611_ _02287_ VGND VGND VPWR VPWR _02288_ sky130_fd_sc_hd__nor2_1
XFILLER_55_701 VGND VGND VPWR VPWR sky130_fd_sc_hd__fill_2
X_06955_ _02597_ _02834_ VGND VGND VPWR VPWR _02844_ sky130_fd_sc_hd__xor2_1
X_09674_ _02207_ _02211_ VGND VGND VPWR VPWR _02212_ sky130_fd_sc_hd__and2_1
XFILLER_94_380 VGND VGND VPWR VPWR sky130_fd_sc_hd__decap_4
X_06886_ _01671_ _01682_ _01660_ VGND VGND VPWR VPWR _02096_ sky130_fd_sc_hd__o21a_1
XFILLER_27_414 VPWR VGND VPWR VGND sky130_ef_sc_hd__decap_12
XFILLER_36_27 VGND VGND VPWR VPWR sky130_fd_sc_hd__fill_1
X_08625_ net557 net42 net364 net566 VGND VGND VPWR VPWR _01092_ sky130_fd_sc_hd__a22o_1
XFILLER_82_531 VGND VGND VPWR VPWR sky130_fd_sc_hd__fill_1
XFILLER_54_222 VPWR VGND VPWR VGND sky130_ef_sc_hd__decap_12
XFILLER_27_447 VGND VGND VPWR VPWR sky130_fd_sc_hd__fill_1
X_08556_ net586 net366 net364 net596 VGND VGND VPWR VPWR _01025_ sky130_fd_sc_hd__a22o_1
XFILLER_82_597 VPWR VGND VPWR VGND sky130_ef_sc_hd__decap_12
XFILLER_70_737 VPWR VGND VPWR VGND sky130_ef_sc_hd__decap_12
XFILLER_42_406 VPWR VGND VPWR VGND sky130_ef_sc_hd__decap_12
XFILLER_52_15 VPWR VGND VPWR VGND sky130_ef_sc_hd__decap_12
X_07507_ net698 net554 _06585_ _06584_ VGND VGND VPWR VPWR _06736_ sky130_fd_sc_hd__a31oi_1
XFILLER_22_141 VGND VGND VPWR VPWR sky130_fd_sc_hd__decap_6
XTAP_TAPCELL_ROW_25_659 VGND VPWR sky130_fd_sc_hd__tapvpwrvgnd_1
X_08487_ _00886_ _00888_ VGND VGND VPWR VPWR _00960_ sky130_fd_sc_hd__nand2_1
X_07438_ _01344_ net599 _06666_ _06667_ VGND VGND VPWR VPWR _06668_ sky130_fd_sc_hd__a22o_1
XFILLER_22_163 VGND VGND VPWR VPWR sky130_fd_sc_hd__decap_6
XPHY_EDGE_ROW_138_Left_277 VGND VGND VPWR VPWR sky130_fd_sc_hd__decap_3
XTAP_TAPCELL_ROW_98_1720 VGND VPWR sky130_fd_sc_hd__tapvpwrvgnd_1
X_07369_ _05657_ _05690_ _06597_ VGND VGND VPWR VPWR _06599_ sky130_fd_sc_hd__nand3_1
XFILLER_136_522 VGND VGND VPWR VPWR sky130_fd_sc_hd__decap_3
X_09108_ _01589_ _01592_ _01593_ VGND VGND VPWR VPWR _01595_ sky130_fd_sc_hd__and3_1
X_10380_ _02969_ _02971_ VGND VGND VPWR VPWR _02978_ sky130_fd_sc_hd__xnor2_1
X_09039_ _01383_ _01402_ _01400_ VGND VGND VPWR VPWR _01520_ sky130_fd_sc_hd__o21bai_1
XFILLER_123_238 VGND VGND VPWR VPWR sky130_fd_sc_hd__fill_2
X_12050_ _04792_ _04796_ VGND VGND VPWR VPWR _04797_ sky130_fd_sc_hd__nand2_1
XFILLER_2_557 VGND VGND VPWR VPWR sky130_fd_sc_hd__fill_2
X_11001_ _03463_ _03656_ VGND VGND VPWR VPWR _03657_ sky130_fd_sc_hd__xnor2_1
XTAP_TAPCELL_ROW_125_2116 VGND VPWR sky130_fd_sc_hd__tapvpwrvgnd_1
XTAP_TAPCELL_ROW_125_2105 VGND VPWR sky130_fd_sc_hd__tapvpwrvgnd_1
XFILLER_58_550 VGND VGND VPWR VPWR sky130_fd_sc_hd__fill_2
XFILLER_46_701 VGND VGND VPWR VPWR sky130_fd_sc_hd__fill_2
XTAP_TAPCELL_ROW_5_373 VGND VPWR sky130_fd_sc_hd__tapvpwrvgnd_1
XFILLER_133_51 VGND VGND VPWR VPWR sky130_fd_sc_hd__decap_4
X_12952_ net478 net398 net397 net487 VGND VGND VPWR VPWR _05782_ sky130_fd_sc_hd__a22o_1
XFILLER_93_55 VGND VGND VPWR VPWR sky130_fd_sc_hd__fill_1
XFILLER_45_222 VGND VGND VPWR VPWR sky130_fd_sc_hd__fill_2
XFILLER_18_458 VGND VGND VPWR VPWR sky130_fd_sc_hd__fill_2
X_11903_ _04638_ _04639_ VGND VGND VPWR VPWR _04640_ sky130_fd_sc_hd__xor2_1
X_12883_ _05705_ _05706_ VGND VGND VPWR VPWR _05707_ sky130_fd_sc_hd__and2_1
XFILLER_33_417 VGND VGND VPWR VPWR sky130_fd_sc_hd__decap_4
XFILLER_60_247 VGND VGND VPWR VPWR sky130_fd_sc_hd__fill_2
XFILLER_45_288 VGND VGND VPWR VPWR sky130_fd_sc_hd__decap_8
XTAP_TAPCELL_ROW_44_935 VGND VPWR sky130_fd_sc_hd__tapvpwrvgnd_1
XFILLER_14_620 VPWR VGND VPWR VGND sky130_ef_sc_hd__decap_12
X_11834_ _04478_ _04563_ _04564_ VGND VGND VPWR VPWR _04565_ sky130_fd_sc_hd__a21oi_1
X_11765_ _04465_ _04488_ VGND VGND VPWR VPWR _04490_ sky130_fd_sc_hd__xnor2_1
X_13504_ _06383_ _06384_ VGND VGND VPWR VPWR _06385_ sky130_fd_sc_hd__nand2_1
X_11696_ _04208_ _04282_ _04281_ VGND VGND VPWR VPWR _04415_ sky130_fd_sc_hd__a21oi_1
XFILLER_14_697 VGND VGND VPWR VPWR sky130_fd_sc_hd__decap_3
X_10716_ _03342_ _03343_ _03247_ VGND VGND VPWR VPWR _03345_ sky130_fd_sc_hd__o21a_1
X_13435_ _06307_ _06308_ VGND VGND VPWR VPWR _06309_ sky130_fd_sc_hd__and2b_1
X_10647_ _03135_ _03266_ _03267_ VGND VGND VPWR VPWR _03269_ sky130_fd_sc_hd__and3_1
XTAP_TAPCELL_ROW_136_2278 VGND VPWR sky130_fd_sc_hd__tapvpwrvgnd_1
XTAP_TAPCELL_ROW_136_2267 VGND VPWR sky130_fd_sc_hd__tapvpwrvgnd_1
X_13366_ _05971_ _06133_ _05826_ VGND VGND VPWR VPWR _06234_ sky130_fd_sc_hd__o21ai_1
X_10578_ _03104_ _03105_ _03189_ _03191_ VGND VGND VPWR VPWR _03195_ sky130_fd_sc_hd__o22a_1
X_13297_ _05889_ _06158_ VGND VGND VPWR VPWR _06159_ sky130_fd_sc_hd__nand2_1
X_12317_ _05086_ _05087_ VGND VGND VPWR VPWR _05088_ sky130_fd_sc_hd__or2_1
XFILLER_5_362 VGND VGND VPWR VPWR sky130_fd_sc_hd__fill_1
X_12248_ _04839_ _04841_ _05011_ VGND VGND VPWR VPWR _05014_ sky130_fd_sc_hd__nand3_1
XFILLER_123_783 VGND VGND VPWR VPWR sky130_fd_sc_hd__fill_1
X_12179_ _04936_ _04938_ VGND VGND VPWR VPWR _04939_ sky130_fd_sc_hd__nand2b_1
XFILLER_95_155 VPWR VGND VPWR VGND sky130_ef_sc_hd__decap_12
XFILLER_110_477 VPWR VGND VPWR VGND sky130_ef_sc_hd__decap_12
XFILLER_49_583 VGND VGND VPWR VPWR sky130_fd_sc_hd__decap_8
XFILLER_64_531 VGND VGND VPWR VPWR sky130_fd_sc_hd__fill_1
XFILLER_36_244 VGND VGND VPWR VPWR sky130_fd_sc_hd__decap_8
XFILLER_91_361 VGND VGND VPWR VPWR sky130_fd_sc_hd__decap_8
X_08410_ _00800_ _00883_ VGND VGND VPWR VPWR _00884_ sky130_fd_sc_hd__xnor2_1
X_09390_ _01901_ _01902_ VGND VGND VPWR VPWR _01903_ sky130_fd_sc_hd__nand2_1
XFILLER_91_383 VGND VGND VPWR VPWR sky130_fd_sc_hd__fill_2
XFILLER_52_748 VGND VGND VPWR VPWR sky130_fd_sc_hd__fill_1
X_08341_ _00731_ _00733_ _00743_ VGND VGND VPWR VPWR _00815_ sky130_fd_sc_hd__nand3_1
XFILLER_138_809 VGND VGND VPWR VPWR sky130_fd_sc_hd__decap_3
X_08272_ _00740_ _00746_ VGND VGND VPWR VPWR _00747_ sky130_fd_sc_hd__and2b_1
XFILLER_20_601 VPWR VGND VPWR VGND sky130_ef_sc_hd__decap_12
XTAP_TAPCELL_ROW_22_618 VGND VPWR sky130_fd_sc_hd__tapvpwrvgnd_1
XFILLER_20_645 VGND VGND VPWR VPWR sky130_fd_sc_hd__decap_8
XFILLER_22_29 VPWR VGND VPWR VGND sky130_ef_sc_hd__decap_12
XFILLER_32_494 VGND VGND VPWR VPWR sky130_fd_sc_hd__fill_1
X_07223_ net592 net582 net691 net690 VGND VGND VPWR VPWR _05766_ sky130_fd_sc_hd__and4_1
XFILLER_138_29 VPWR VGND VPWR VGND sky130_ef_sc_hd__decap_12
XFILLER_118_533 VPWR VGND VPWR VGND sky130_ef_sc_hd__decap_12
X_07154_ _04991_ _05002_ VGND VGND VPWR VPWR _05013_ sky130_fd_sc_hd__or2_1
XFILLER_133_503 VGND VGND VPWR VPWR sky130_fd_sc_hd__fill_1
X_07085_ _02802_ _02812_ _02834_ _02597_ VGND VGND VPWR VPWR _04264_ sky130_fd_sc_hd__o2bb2a_1
XFILLER_133_569 VGND VGND VPWR VPWR sky130_fd_sc_hd__fill_1
XTAP_TAPCELL_ROW_93_1650 VGND VPWR sky130_fd_sc_hd__tapvpwrvgnd_1
XFILLER_101_422 VGND VGND VPWR VPWR sky130_fd_sc_hd__fill_2
XFILLER_87_623 VPWR VGND VPWR VGND sky130_ef_sc_hd__decap_12
XFILLER_47_15 VPWR VGND VPWR VGND sky130_ef_sc_hd__decap_12
X_07987_ _00460_ _00461_ VGND VGND VPWR VPWR _00464_ sky130_fd_sc_hd__xor2_1
X_09726_ _02268_ _02259_ VGND VGND VPWR VPWR _02269_ sky130_fd_sc_hd__and2b_1
XFILLER_74_328 VGND VGND VPWR VPWR sky130_fd_sc_hd__decap_3
XTAP_TAPCELL_ROW_2_332 VGND VPWR sky130_fd_sc_hd__tapvpwrvgnd_1
XTAP_TAPCELL_ROW_2_321 VGND VPWR sky130_fd_sc_hd__tapvpwrvgnd_1
XFILLER_27_200 VGND VGND VPWR VPWR sky130_fd_sc_hd__decap_4
XFILLER_28_701 VGND VGND VPWR VPWR sky130_fd_sc_hd__fill_1
X_06938_ net702 net569 _02630_ _02641_ VGND VGND VPWR VPWR _02663_ sky130_fd_sc_hd__a22oi_1
XFILLER_67_391 VGND VGND VPWR VPWR sky130_fd_sc_hd__fill_1
X_09657_ _02190_ _02191_ VGND VGND VPWR VPWR _02193_ sky130_fd_sc_hd__xnor2_1
XFILLER_70_512 VGND VGND VPWR VPWR sky130_fd_sc_hd__decap_3
X_06869_ _01573_ _01889_ VGND VGND VPWR VPWR _01911_ sky130_fd_sc_hd__and2_1
XTAP_TAPCELL_ROW_120_2046 VGND VPWR sky130_fd_sc_hd__tapvpwrvgnd_1
XTAP_TAPCELL_ROW_120_2035 VGND VPWR sky130_fd_sc_hd__tapvpwrvgnd_1
X_08608_ _01003_ _01030_ _01074_ VGND VGND VPWR VPWR _01076_ sky130_fd_sc_hd__o21ba_1
X_09588_ _01789_ _01959_ _02117_ VGND VGND VPWR VPWR _02119_ sky130_fd_sc_hd__and3_1
XFILLER_55_597 VPWR VGND VPWR VGND sky130_ef_sc_hd__decap_12
XFILLER_43_737 VGND VGND VPWR VPWR sky130_fd_sc_hd__fill_2
X_08539_ net471 net339 VGND VGND VPWR VPWR _01008_ sky130_fd_sc_hd__nand2_1
XFILLER_129_809 VPWR VGND VPWR VGND sky130_ef_sc_hd__decap_12
X_11550_ _04247_ _04255_ VGND VGND VPWR VPWR _04256_ sky130_fd_sc_hd__and2_1
XFILLER_137_3 VPWR VGND VPWR VGND sky130_ef_sc_hd__decap_12
XFILLER_50_280 VPWR VGND VPWR VGND sky130_ef_sc_hd__decap_12
XFILLER_10_133 VGND VGND VPWR VPWR sky130_fd_sc_hd__decap_3
XFILLER_7_605 VGND VGND VPWR VPWR sky130_fd_sc_hd__fill_1
XFILLER_11_656 VGND VGND VPWR VPWR sky130_fd_sc_hd__fill_1
X_10501_ net511 net503 net296 net294 VGND VGND VPWR VPWR _03110_ sky130_fd_sc_hd__and4_1
X_13220_ _05969_ _05981_ _05980_ VGND VGND VPWR VPWR _06075_ sky130_fd_sc_hd__a21bo_1
X_11481_ net544 _03880_ VGND VGND VPWR VPWR _04181_ sky130_fd_sc_hd__nand2_1
X_10432_ _03029_ _03034_ _03025_ _03027_ VGND VGND VPWR VPWR _03035_ sky130_fd_sc_hd__a211oi_2
XFILLER_136_363 VGND VGND VPWR VPWR sky130_fd_sc_hd__fill_1
XFILLER_124_514 VGND VGND VPWR VPWR sky130_fd_sc_hd__decap_8
X_13151_ _05315_ _05999_ VGND VGND VPWR VPWR _06000_ sky130_fd_sc_hd__xnor2_2
X_10363_ _02957_ _02956_ VGND VGND VPWR VPWR _02959_ sky130_fd_sc_hd__and2b_1
XFILLER_124_547 VPWR VGND VPWR VGND sky130_ef_sc_hd__decap_12
XFILLER_124_536 VGND VGND VPWR VPWR sky130_fd_sc_hd__decap_4
X_13082_ _05759_ _05768_ _05767_ VGND VGND VPWR VPWR _05924_ sky130_fd_sc_hd__a21oi_1
X_12102_ net656 net338 net353 net645 VGND VGND VPWR VPWR _04854_ sky130_fd_sc_hd__a22o_1
XTAP_TAPCELL_ROW_131_2197 VGND VPWR sky130_fd_sc_hd__tapvpwrvgnd_1
X_12033_ net572 net679 _04775_ _04776_ VGND VGND VPWR VPWR _04778_ sky130_fd_sc_hd__o2bb2a_1
XFILLER_88_77 VGND VGND VPWR VPWR sky130_fd_sc_hd__decap_6
XFILLER_78_601 VGND VGND VPWR VPWR sky130_fd_sc_hd__fill_2
X_10294_ _02824_ _02830_ _02882_ VGND VGND VPWR VPWR _02884_ sky130_fd_sc_hd__nand3_1
XFILLER_105_783 VGND VGND VPWR VPWR sky130_fd_sc_hd__fill_1
XFILLER_120_797 VPWR VGND VPWR VGND sky130_ef_sc_hd__decap_12
Xfanout680 net12 VGND VGND VPWR VPWR net680 sky130_fd_sc_hd__clkbuf_2
XFILLER_65_328 VGND VGND VPWR VPWR sky130_fd_sc_hd__decap_8
Xfanout691 net111 VGND VGND VPWR VPWR net691 sky130_fd_sc_hd__buf_2
XFILLER_46_531 VGND VGND VPWR VPWR sky130_fd_sc_hd__fill_1
XTAP_TAPCELL_ROW_105_1819 VGND VPWR sky130_fd_sc_hd__tapvpwrvgnd_1
X_12935_ _05762_ net247 VGND VGND VPWR VPWR _05763_ sky130_fd_sc_hd__nand2b_1
XFILLER_80_309 VGND VGND VPWR VPWR sky130_fd_sc_hd__decap_4
XFILLER_18_277 VPWR VGND VPWR VGND sky130_ef_sc_hd__decap_12
XFILLER_37_81 VPWR VGND VPWR VGND sky130_ef_sc_hd__decap_12
XFILLER_73_383 VGND VGND VPWR VPWR sky130_fd_sc_hd__decap_3
X_12866_ _05678_ _05687_ VGND VGND VPWR VPWR _05688_ sky130_fd_sc_hd__xor2_1
XFILLER_34_748 VGND VGND VPWR VPWR sky130_fd_sc_hd__decap_8
XFILLER_61_578 VPWR VGND VPWR VGND sky130_ef_sc_hd__decap_12
X_11817_ _04348_ _04442_ VGND VGND VPWR VPWR _04546_ sky130_fd_sc_hd__or2_1
XFILLER_33_258 VGND VGND VPWR VPWR sky130_fd_sc_hd__decap_6
XTAP_TAPCELL_ROW_138_2318 VGND VPWR sky130_fd_sc_hd__tapvpwrvgnd_1
XTAP_TAPCELL_ROW_138_2307 VGND VPWR sky130_fd_sc_hd__tapvpwrvgnd_1
X_12797_ _05609_ _05610_ VGND VGND VPWR VPWR _05612_ sky130_fd_sc_hd__nor2_1
XFILLER_42_781 VPWR VGND VPWR VGND sky130_ef_sc_hd__decap_12
X_11748_ _04469_ _04470_ VGND VGND VPWR VPWR _04472_ sky130_fd_sc_hd__nor2_1
X_11679_ _04391_ _04396_ VGND VGND VPWR VPWR _04397_ sky130_fd_sc_hd__xor2_1
X_13418_ _06288_ _06289_ VGND VGND VPWR VPWR _06292_ sky130_fd_sc_hd__xor2_1
X_13349_ _05696_ _05844_ _06104_ VGND VGND VPWR VPWR _06216_ sky130_fd_sc_hd__and3_1
XFILLER_52_3 VPWR VGND VPWR VGND sky130_ef_sc_hd__decap_12
XFILLER_130_517 VPWR VGND VPWR VGND sky130_ef_sc_hd__decap_12
XTAP_TAPCELL_ROW_75_1380 VGND VPWR sky130_fd_sc_hd__tapvpwrvgnd_1
X_08890_ _01353_ _01354_ _01245_ VGND VGND VPWR VPWR _01358_ sky130_fd_sc_hd__o21ai_2
XFILLER_123_591 VPWR VGND VPWR VGND sky130_ef_sc_hd__decap_12
XTAP_TAPCELL_ROW_75_1391 VGND VPWR sky130_fd_sc_hd__tapvpwrvgnd_1
X_07910_ _00385_ _00386_ VGND VGND VPWR VPWR _00388_ sky130_fd_sc_hd__xnor2_1
XFILLER_111_753 VPWR VGND VPWR VGND sky130_ef_sc_hd__decap_12
X_07841_ _06761_ _06765_ VGND VGND VPWR VPWR _00319_ sky130_fd_sc_hd__nor2_1
XFILLER_111_797 VPWR VGND VPWR VGND sky130_ef_sc_hd__decap_12
XFILLER_68_177 VPWR VGND VPWR VGND sky130_ef_sc_hd__decap_12
X_07772_ _00244_ _00249_ VGND VGND VPWR VPWR _00251_ sky130_fd_sc_hd__xor2_2
X_09511_ net564 net555 net354 VGND VGND VPWR VPWR _02034_ sky130_fd_sc_hd__and3_1
XFILLER_83_136 VGND VGND VPWR VPWR sky130_fd_sc_hd__fill_1
XFILLER_64_361 VGND VGND VPWR VPWR sky130_fd_sc_hd__decap_3
XFILLER_37_553 VGND VGND VPWR VPWR sky130_fd_sc_hd__decap_6
X_09442_ net465 net456 net65 VGND VGND VPWR VPWR _01959_ sky130_fd_sc_hd__o21a_1
XFILLER_52_523 VGND VGND VPWR VPWR sky130_fd_sc_hd__fill_1
XFILLER_24_203 VPWR VGND VPWR VGND sky130_ef_sc_hd__decap_12
X_09373_ _01709_ _01711_ VGND VGND VPWR VPWR _01884_ sky130_fd_sc_hd__nand2_1
XFILLER_52_589 VGND VGND VPWR VPWR sky130_fd_sc_hd__decap_3
XFILLER_33_39 VPWR VGND VPWR VGND sky130_ef_sc_hd__decap_12
X_08324_ _00562_ _00700_ _00699_ VGND VGND VPWR VPWR _00798_ sky130_fd_sc_hd__a21oi_1
XFILLER_138_617 VGND VGND VPWR VPWR sky130_fd_sc_hd__fill_2
XFILLER_137_105 VGND VGND VPWR VPWR sky130_fd_sc_hd__decap_6
X_08255_ _06659_ _00729_ VGND VGND VPWR VPWR _00730_ sky130_fd_sc_hd__xnor2_1
XFILLER_137_149 VPWR VGND VPWR VGND sky130_ef_sc_hd__decap_12
X_08186_ _00660_ _00661_ VGND VGND VPWR VPWR _00662_ sky130_fd_sc_hd__nor2_1
X_07206_ net698 net554 VGND VGND VPWR VPWR _05580_ sky130_fd_sc_hd__nand2_1
XFILLER_106_503 VGND VGND VPWR VPWR sky130_fd_sc_hd__decap_6
X_07137_ net673 net435 net426 net674 VGND VGND VPWR VPWR _04827_ sky130_fd_sc_hd__a22oi_1
XFILLER_133_322 VPWR VGND VPWR VGND sky130_ef_sc_hd__decap_12
XFILLER_106_569 VPWR VGND VPWR VGND sky130_ef_sc_hd__decap_12
X_07068_ _02898_ _04068_ VGND VGND VPWR VPWR _04079_ sky130_fd_sc_hd__nor2_1
XTAP_TAPCELL_ROW_7_402 VGND VPWR sky130_fd_sc_hd__tapvpwrvgnd_1
XFILLER_87_431 VGND VGND VPWR VPWR sky130_fd_sc_hd__decap_6
XFILLER_47_328 VGND VGND VPWR VPWR sky130_fd_sc_hd__decap_8
XFILLER_114_53 VPWR VGND VPWR VGND sky130_ef_sc_hd__decap_12
X_09709_ _02248_ _02250_ VGND VGND VPWR VPWR _02251_ sky130_fd_sc_hd__or2_1
XFILLER_90_618 VPWR VGND VPWR VGND sky130_ef_sc_hd__decap_12
XFILLER_62_309 VGND VGND VPWR VPWR sky130_fd_sc_hd__decap_4
XFILLER_55_361 VGND VGND VPWR VPWR sky130_fd_sc_hd__decap_3
X_10981_ _03633_ _03634_ VGND VGND VPWR VPWR _03635_ sky130_fd_sc_hd__and2b_1
X_12720_ _01464_ _00104_ _05528_ _05529_ VGND VGND VPWR VPWR _05530_ sky130_fd_sc_hd__o31ai_1
XFILLER_55_383 VGND VGND VPWR VPWR sky130_fd_sc_hd__decap_8
XFILLER_15_225 VPWR VGND VPWR VGND sky130_ef_sc_hd__decap_12
XFILLER_130_41 VPWR VGND VPWR VGND sky130_ef_sc_hd__decap_12
X_12651_ net489 net480 net402 net400 VGND VGND VPWR VPWR _05454_ sky130_fd_sc_hd__and4_1
XFILLER_130_85 VPWR VGND VPWR VGND sky130_ef_sc_hd__decap_12
XFILLER_70_375 VPWR VGND VPWR VGND sky130_ef_sc_hd__decap_12
X_11602_ net544 _00436_ _04181_ net299 VGND VGND VPWR VPWR _04312_ sky130_fd_sc_hd__o211ai_2
XFILLER_31_729 VPWR VGND VPWR VGND sky130_ef_sc_hd__decap_12
XTAP_TAPCELL_ROW_100_1749 VGND VPWR sky130_fd_sc_hd__tapvpwrvgnd_1
X_12582_ _05273_ _05377_ VGND VGND VPWR VPWR _05379_ sky130_fd_sc_hd__xor2_1
X_11533_ _04209_ _04237_ VGND VGND VPWR VPWR _04238_ sky130_fd_sc_hd__and2b_1
XTAP_TAPCELL_ROW_133_2226 VGND VPWR sky130_fd_sc_hd__tapvpwrvgnd_1
XFILLER_7_457 VGND VGND VPWR VPWR sky130_fd_sc_hd__fill_2
XFILLER_7_446 VGND VGND VPWR VPWR sky130_fd_sc_hd__fill_2
X_11464_ _04012_ _04015_ _04160_ VGND VGND VPWR VPWR _04163_ sky130_fd_sc_hd__o21a_1
XFILLER_99_54 VGND VGND VPWR VPWR sky130_fd_sc_hd__fill_2
X_13203_ net247 _06054_ VGND VGND VPWR VPWR _06056_ sky130_fd_sc_hd__xnor2_1
X_10415_ _02842_ _03007_ _03015_ VGND VGND VPWR VPWR _03016_ sky130_fd_sc_hd__nand3_1
XFILLER_136_171 VGND VGND VPWR VPWR sky130_fd_sc_hd__fill_1
X_11395_ _03426_ _04086_ VGND VGND VPWR VPWR _04087_ sky130_fd_sc_hd__and2_1
XTAP_TAPCELL_ROW_115_1970 VGND VPWR sky130_fd_sc_hd__tapvpwrvgnd_1
X_13134_ _05970_ _05979_ VGND VGND VPWR VPWR _05981_ sky130_fd_sc_hd__xor2_2
X_10346_ _02936_ _02938_ VGND VGND VPWR VPWR _02940_ sky130_fd_sc_hd__and2_1
X_13065_ _05900_ _05901_ _05903_ VGND VGND VPWR VPWR _05905_ sky130_fd_sc_hd__or3_1
X_10277_ _02857_ _02864_ VGND VGND VPWR VPWR _02865_ sky130_fd_sc_hd__nand2_1
X_12016_ net523 net400 VGND VGND VPWR VPWR _04759_ sky130_fd_sc_hd__nand2_1
XFILLER_93_412 VPWR VGND VPWR VGND sky130_ef_sc_hd__decap_12
XFILLER_78_475 VGND VGND VPWR VPWR sky130_fd_sc_hd__fill_1
XFILLER_38_328 VPWR VGND VPWR VGND sky130_ef_sc_hd__decap_12
XFILLER_65_147 VPWR VGND VPWR VGND sky130_ef_sc_hd__decap_12
XFILLER_81_629 VPWR VGND VPWR VGND sky130_ef_sc_hd__decap_12
XFILLER_65_169 VPWR VGND VPWR VGND sky130_ef_sc_hd__decap_12
XFILLER_46_361 VGND VGND VPWR VPWR sky130_fd_sc_hd__decap_3
XFILLER_34_501 VPWR VGND VPWR VGND sky130_ef_sc_hd__decap_12
X_12918_ net548 net500 _05743_ VGND VGND VPWR VPWR _05745_ sky130_fd_sc_hd__and3_1
XFILLER_0_98 VPWR VGND VPWR VGND sky130_ef_sc_hd__decap_12
X_12849_ _05667_ _05669_ VGND VGND VPWR VPWR _05670_ sky130_fd_sc_hd__xor2_1
XFILLER_15_781 VGND VGND VPWR VPWR sky130_fd_sc_hd__decap_3
XFILLER_34_578 VGND VGND VPWR VPWR sky130_fd_sc_hd__decap_8
XFILLER_34_589 VGND VGND VPWR VPWR sky130_fd_sc_hd__decap_8
XFILLER_30_740 VPWR VGND VPWR VGND sky130_ef_sc_hd__decap_12
XTAP_TAPCELL_ROW_32_757 VGND VPWR sky130_fd_sc_hd__tapvpwrvgnd_1
XFILLER_119_105 VGND VGND VPWR VPWR sky130_fd_sc_hd__decap_6
XTAP_TAPCELL_ROW_32_768 VGND VPWR sky130_fd_sc_hd__tapvpwrvgnd_1
X_08040_ net610 net705 VGND VGND VPWR VPWR _00517_ sky130_fd_sc_hd__nand2_1
XTAP_TAPCELL_ROW_12_470 VGND VPWR sky130_fd_sc_hd__tapvpwrvgnd_1
XFILLER_128_672 VGND VGND VPWR VPWR sky130_fd_sc_hd__fill_2
XTAP_TAPCELL_ROW_77_1420 VGND VPWR sky130_fd_sc_hd__tapvpwrvgnd_1
X_09991_ _02556_ _02557_ VGND VGND VPWR VPWR _02558_ sky130_fd_sc_hd__nor2_1
XFILLER_130_336 VPWR VGND VPWR VGND sky130_ef_sc_hd__decap_12
X_08942_ net517 net508 net54 net53 VGND VGND VPWR VPWR _01414_ sky130_fd_sc_hd__nand4_1
XFILLER_88_239 VPWR VGND VPWR VGND sky130_ef_sc_hd__decap_12
X_08873_ _01311_ _01337_ _01338_ VGND VGND VPWR VPWR _01339_ sky130_fd_sc_hd__nor3_4
XFILLER_111_561 VGND VGND VPWR VPWR sky130_fd_sc_hd__decap_4
XFILLER_96_261 VGND VGND VPWR VPWR sky130_fd_sc_hd__fill_1
XFILLER_96_250 VGND VGND VPWR VPWR sky130_fd_sc_hd__fill_2
XFILLER_84_445 VPWR VGND VPWR VGND sky130_ef_sc_hd__decap_12
XFILLER_56_147 VGND VGND VPWR VPWR sky130_fd_sc_hd__fill_1
X_07824_ net689 _00299_ _00301_ VGND VGND VPWR VPWR _00302_ sky130_fd_sc_hd__a21bo_1
X_07755_ net442 net663 VGND VGND VPWR VPWR _00234_ sky130_fd_sc_hd__nand2_1
XFILLER_44_309 VPWR VGND VPWR VGND sky130_ef_sc_hd__decap_12
XTAP_TAPCELL_ROW_88_1582 VGND VPWR sky130_fd_sc_hd__tapvpwrvgnd_1
XTAP_TAPCELL_ROW_88_1571 VGND VPWR sky130_fd_sc_hd__tapvpwrvgnd_1
XFILLER_65_692 VPWR VGND VPWR VGND sky130_ef_sc_hd__decap_12
X_07686_ _06750_ _06752_ _00163_ VGND VGND VPWR VPWR _00165_ sky130_fd_sc_hd__and3_1
X_09425_ _01934_ _01938_ VGND VGND VPWR VPWR _01940_ sky130_fd_sc_hd__xor2_1
XFILLER_44_27 VGND VGND VPWR VPWR sky130_fd_sc_hd__fill_1
XFILLER_25_567 VGND VGND VPWR VPWR sky130_fd_sc_hd__fill_1
XFILLER_13_729 VGND VGND VPWR VPWR sky130_fd_sc_hd__decap_6
X_09356_ _01862_ _01863_ VGND VGND VPWR VPWR _01865_ sky130_fd_sc_hd__xor2_1
X_09287_ net461 net453 net64 net65 VGND VGND VPWR VPWR _01790_ sky130_fd_sc_hd__nand4_1
XFILLER_100_77 VGND VGND VPWR VPWR sky130_fd_sc_hd__decap_6
XFILLER_60_26 VGND VGND VPWR VPWR sky130_fd_sc_hd__fill_2
X_08307_ _00779_ _00780_ VGND VGND VPWR VPWR _00782_ sky130_fd_sc_hd__xnor2_1
XFILLER_21_751 VPWR VGND VPWR VGND sky130_ef_sc_hd__decap_12
X_08238_ _00584_ _00586_ _00712_ VGND VGND VPWR VPWR _00713_ sky130_fd_sc_hd__a21oi_1
X_10200_ _02698_ _02710_ _02697_ VGND VGND VPWR VPWR _02785_ sky130_fd_sc_hd__a21oi_1
X_08169_ net434 net425 net661 VGND VGND VPWR VPWR _00645_ sky130_fd_sc_hd__o21ai_1
XFILLER_134_664 VGND VGND VPWR VPWR sky130_fd_sc_hd__fill_1
XFILLER_69_57 VPWR VGND VPWR VGND sky130_ef_sc_hd__decap_12
X_11180_ _03849_ _03851_ VGND VGND VPWR VPWR _03853_ sky130_fd_sc_hd__xnor2_1
XFILLER_134_686 VGND VGND VPWR VPWR sky130_fd_sc_hd__fill_2
XFILLER_133_185 VGND VGND VPWR VPWR sky130_fd_sc_hd__fill_1
XFILLER_133_163 VGND VGND VPWR VPWR sky130_fd_sc_hd__decap_4
X_10131_ _02699_ _02708_ VGND VGND VPWR VPWR _02710_ sky130_fd_sc_hd__xnor2_1
XFILLER_121_314 VPWR VGND VPWR VGND sky130_ef_sc_hd__decap_12
XFILLER_106_377 VGND VGND VPWR VPWR sky130_fd_sc_hd__decap_4
X_10062_ _02526_ _02553_ _02552_ VGND VGND VPWR VPWR _02635_ sky130_fd_sc_hd__a21oi_1
XFILLER_88_740 VGND VGND VPWR VPWR sky130_fd_sc_hd__decap_3
XFILLER_94_209 VPWR VGND VPWR VGND sky130_ef_sc_hd__decap_12
XFILLER_0_677 VGND VGND VPWR VPWR sky130_fd_sc_hd__fill_1
XFILLER_47_169 VPWR VGND VPWR VGND sky130_ef_sc_hd__decap_12
XFILLER_47_158 VGND VGND VPWR VPWR sky130_fd_sc_hd__decap_6
XFILLER_62_106 VPWR VGND VPWR VGND sky130_ef_sc_hd__decap_12
XFILLER_56_681 VGND VGND VPWR VPWR sky130_fd_sc_hd__fill_1
XFILLER_44_821 VGND VGND VPWR VPWR sky130_fd_sc_hd__decap_3
XFILLER_90_459 VGND VGND VPWR VPWR sky130_fd_sc_hd__fill_2
X_12703_ _05489_ _05510_ VGND VGND VPWR VPWR _05511_ sky130_fd_sc_hd__xnor2_1
X_10964_ _03427_ _03614_ VGND VGND VPWR VPWR _03616_ sky130_fd_sc_hd__xnor2_1
XFILLER_71_673 VPWR VGND VPWR VGND sky130_ef_sc_hd__decap_12
X_13683_ clknet_3_0__leaf_clk _00018_ net715 VGND VGND VPWR VPWR net202 sky130_fd_sc_hd__dfrtp_1
XFILLER_16_589 VGND VGND VPWR VPWR sky130_fd_sc_hd__decap_3
X_10895_ _03415_ _03451_ _03450_ VGND VGND VPWR VPWR _03540_ sky130_fd_sc_hd__a21oi_1
X_12634_ _05427_ _05433_ VGND VGND VPWR VPWR _05435_ sky130_fd_sc_hd__nand2b_1
XFILLER_12_740 VPWR VGND VPWR VGND sky130_ef_sc_hd__decap_12
XFILLER_31_548 VGND VGND VPWR VPWR sky130_fd_sc_hd__decap_4
XFILLER_31_559 VGND VGND VPWR VPWR sky130_fd_sc_hd__fill_1
X_12565_ _05357_ _05358_ VGND VGND VPWR VPWR _05360_ sky130_fd_sc_hd__xor2_1
XFILLER_8_722 VGND VGND VPWR VPWR sky130_fd_sc_hd__decap_6
XFILLER_129_447 VGND VGND VPWR VPWR sky130_fd_sc_hd__fill_1
XFILLER_8_755 VGND VGND VPWR VPWR sky130_fd_sc_hd__fill_1
XFILLER_7_221 VGND VGND VPWR VPWR sky130_fd_sc_hd__decap_3
X_11516_ _04212_ _04217_ VGND VGND VPWR VPWR _04219_ sky130_fd_sc_hd__xnor2_1
X_12496_ _05281_ _05282_ VGND VGND VPWR VPWR _05284_ sky130_fd_sc_hd__xnor2_1
XFILLER_7_265 VGND VGND VPWR VPWR sky130_fd_sc_hd__fill_1
XTAP_TAPCELL_ROW_59_1150 VGND VPWR sky130_fd_sc_hd__tapvpwrvgnd_1
X_11447_ _04142_ _04143_ VGND VGND VPWR VPWR _04144_ sky130_fd_sc_hd__nor2_1
XFILLER_124_141 VPWR VGND VPWR VGND sky130_ef_sc_hd__decap_12
XTAP_TAPCELL_ROW_59_1161 VGND VPWR sky130_fd_sc_hd__tapvpwrvgnd_1
X_11378_ _03952_ _03968_ _03967_ VGND VGND VPWR VPWR _04069_ sky130_fd_sc_hd__a21oi_1
X_13117_ _05960_ _05961_ VGND VGND VPWR VPWR _05962_ sky130_fd_sc_hd__xnor2_1
X_10329_ _02915_ _02917_ VGND VGND VPWR VPWR _02922_ sky130_fd_sc_hd__xnor2_1
XFILLER_112_358 VGND VGND VPWR VPWR sky130_fd_sc_hd__decap_6
XFILLER_112_347 VGND VGND VPWR VPWR sky130_fd_sc_hd__fill_1
XTAP_TAPCELL_ROW_72_1350 VGND VPWR sky130_fd_sc_hd__tapvpwrvgnd_1
XFILLER_3_493 VGND VGND VPWR VPWR sky130_fd_sc_hd__decap_8
X_13048_ _05732_ _05875_ _05874_ VGND VGND VPWR VPWR _05887_ sky130_fd_sc_hd__a21o_1
XFILLER_39_615 VGND VGND VPWR VPWR sky130_fd_sc_hd__fill_1
XFILLER_94_754 VGND VGND VPWR VPWR sky130_fd_sc_hd__fill_2
XFILLER_15_3 VPWR VGND VPWR VGND sky130_ef_sc_hd__decap_12
XFILLER_26_309 VGND VGND VPWR VPWR sky130_fd_sc_hd__decap_4
XFILLER_94_798 VPWR VGND VPWR VGND sky130_ef_sc_hd__decap_12
X_07540_ _06760_ _06766_ VGND VGND VPWR VPWR _06769_ sky130_fd_sc_hd__xor2_1
XFILLER_47_670 VGND VGND VPWR VPWR sky130_fd_sc_hd__fill_2
XTAP_TAPCELL_ROW_37_838 VGND VPWR sky130_fd_sc_hd__tapvpwrvgnd_1
X_07471_ _06698_ _06699_ VGND VGND VPWR VPWR _06701_ sky130_fd_sc_hd__xor2_1
XFILLER_61_150 VGND VGND VPWR VPWR sky130_fd_sc_hd__fill_1
XFILLER_50_813 VGND VGND VPWR VPWR sky130_fd_sc_hd__decap_6
XTAP_TAPCELL_ROW_17_540 VGND VPWR sky130_fd_sc_hd__tapvpwrvgnd_1
XTAP_TAPCELL_ROW_17_551 VGND VPWR sky130_fd_sc_hd__tapvpwrvgnd_1
XFILLER_34_386 VGND VGND VPWR VPWR sky130_fd_sc_hd__decap_8
X_09210_ net550 net361 VGND VGND VPWR VPWR _01706_ sky130_fd_sc_hd__nand2_1
X_09141_ _01467_ _01629_ VGND VGND VPWR VPWR _01631_ sky130_fd_sc_hd__xor2_1
X_09072_ _01549_ _01555_ VGND VGND VPWR VPWR _01556_ sky130_fd_sc_hd__xor2_1
X_08023_ _00470_ _00499_ VGND VGND VPWR VPWR _00500_ sky130_fd_sc_hd__and2b_1
XFILLER_30_29 VPWR VGND VPWR VGND sky130_ef_sc_hd__decap_12
XFILLER_115_152 VGND VGND VPWR VPWR sky130_fd_sc_hd__decap_4
XFILLER_89_537 VGND VGND VPWR VPWR sky130_fd_sc_hd__decap_8
XFILLER_130_133 VGND VGND VPWR VPWR sky130_fd_sc_hd__decap_3
X_09974_ net255 _02538_ VGND VGND VPWR VPWR _02539_ sky130_fd_sc_hd__xnor2_1
XFILLER_39_27 VPWR VGND VPWR VGND sky130_ef_sc_hd__decap_12
X_08925_ _01384_ _01394_ VGND VGND VPWR VPWR _01395_ sky130_fd_sc_hd__xor2_1
XPHY_EDGE_ROW_110_Left_249 VGND VGND VPWR VPWR sky130_fd_sc_hd__decap_3
XFILLER_85_710 VGND VGND VPWR VPWR sky130_fd_sc_hd__fill_1
XFILLER_69_261 VGND VGND VPWR VPWR sky130_fd_sc_hd__decap_6
X_08856_ net646 net372 net371 net652 VGND VGND VPWR VPWR _01322_ sky130_fd_sc_hd__a22oi_2
XFILLER_85_743 VGND VGND VPWR VPWR sky130_fd_sc_hd__decap_8
XFILLER_84_253 VPWR VGND VPWR VGND sky130_ef_sc_hd__decap_12
XFILLER_57_478 VPWR VGND VPWR VGND sky130_ef_sc_hd__decap_12
X_07807_ _00283_ _00284_ VGND VGND VPWR VPWR _00286_ sky130_fd_sc_hd__xnor2_1
X_08787_ _01251_ _01252_ VGND VGND VPWR VPWR _01253_ sky130_fd_sc_hd__nand2_1
XFILLER_72_437 VGND VGND VPWR VPWR sky130_fd_sc_hd__fill_1
XFILLER_45_629 VGND VGND VPWR VPWR sky130_fd_sc_hd__decap_3
X_07738_ _00216_ _00215_ VGND VGND VPWR VPWR _00217_ sky130_fd_sc_hd__nand2b_1
XFILLER_25_331 VGND VGND VPWR VPWR sky130_fd_sc_hd__fill_1
XFILLER_37_180 VPWR VGND VPWR VGND sky130_ef_sc_hd__decap_12
XFILLER_111_54 VGND VGND VPWR VPWR sky130_fd_sc_hd__fill_2
XFILLER_53_673 VGND VGND VPWR VPWR sky130_fd_sc_hd__decap_6
XFILLER_52_161 VGND VGND VPWR VPWR sky130_fd_sc_hd__fill_2
X_07669_ _00145_ _00146_ VGND VGND VPWR VPWR _00148_ sky130_fd_sc_hd__xor2_1
X_09408_ net509 net345 net343 net515 VGND VGND VPWR VPWR _01922_ sky130_fd_sc_hd__a22o_1
XFILLER_52_183 VGND VGND VPWR VPWR sky130_fd_sc_hd__decap_4
XFILLER_13_548 VGND VGND VPWR VPWR sky130_fd_sc_hd__decap_3
XFILLER_13_559 VGND VGND VPWR VPWR sky130_fd_sc_hd__fill_1
X_10680_ net604 net327 net272 net466 VGND VGND VPWR VPWR _03306_ sky130_fd_sc_hd__a22oi_1
X_09339_ _01670_ _01673_ _01845_ _01847_ VGND VGND VPWR VPWR _01848_ sky130_fd_sc_hd__o211ai_2
XFILLER_40_356 VGND VGND VPWR VPWR sky130_fd_sc_hd__decap_8
XPHY_EDGE_ROW_109_Right_109 VGND VGND VPWR VPWR sky130_fd_sc_hd__decap_3
XFILLER_138_277 VGND VGND VPWR VPWR sky130_fd_sc_hd__decap_3
X_12350_ _04974_ _04976_ VGND VGND VPWR VPWR _05125_ sky130_fd_sc_hd__nand2_1
XFILLER_107_631 VGND VGND VPWR VPWR sky130_fd_sc_hd__decap_4
X_12281_ _04997_ _05048_ _05049_ VGND VGND VPWR VPWR _05050_ sky130_fd_sc_hd__nor3_1
X_11301_ _03983_ _03984_ VGND VGND VPWR VPWR _03985_ sky130_fd_sc_hd__and2b_1
XFILLER_106_141 VGND VGND VPWR VPWR sky130_fd_sc_hd__decap_8
X_11232_ _03899_ _03908_ VGND VGND VPWR VPWR _03909_ sky130_fd_sc_hd__xnor2_1
X_11163_ _03831_ _03832_ net609 net319 VGND VGND VPWR VPWR _03834_ sky130_fd_sc_hd__and4bb_1
XFILLER_134_494 VPWR VGND VPWR VGND sky130_ef_sc_hd__decap_12
XFILLER_122_645 VPWR VGND VPWR VGND sky130_ef_sc_hd__decap_12
X_10114_ _02596_ _02690_ VGND VGND VPWR VPWR _02691_ sky130_fd_sc_hd__nor2_1
XFILLER_121_166 VGND VGND VPWR VPWR sky130_fd_sc_hd__fill_2
XFILLER_96_77 VGND VGND VPWR VPWR sky130_fd_sc_hd__decap_6
XTAP_TAPCELL_ROW_54_1080 VGND VPWR sky130_fd_sc_hd__tapvpwrvgnd_1
X_11094_ _03720_ _03757_ VGND VGND VPWR VPWR _03758_ sky130_fd_sc_hd__nand2_1
XTAP_TAPCELL_ROW_128_2158 VGND VPWR sky130_fd_sc_hd__tapvpwrvgnd_1
X_10045_ _01581_ _02538_ _02540_ VGND VGND VPWR VPWR _02616_ sky130_fd_sc_hd__a21oi_1
XFILLER_76_754 VGND VGND VPWR VPWR sky130_fd_sc_hd__fill_2
XFILLER_48_434 VPWR VGND VPWR VGND sky130_ef_sc_hd__decap_12
XFILLER_0_474 VGND VGND VPWR VPWR sky130_fd_sc_hd__fill_2
XFILLER_0_485 VGND VGND VPWR VPWR sky130_fd_sc_hd__fill_1
XFILLER_48_467 VGND VGND VPWR VPWR sky130_fd_sc_hd__decap_3
XFILLER_36_607 VGND VGND VPWR VPWR sky130_fd_sc_hd__decap_6
XFILLER_17_821 VGND VGND VPWR VPWR sky130_fd_sc_hd__decap_3
X_11996_ net584 net695 net679 net594 VGND VGND VPWR VPWR _04738_ sky130_fd_sc_hd__a22o_1
XFILLER_91_768 VPWR VGND VPWR VGND sky130_ef_sc_hd__decap_12
XFILLER_90_267 VPWR VGND VPWR VGND sky130_ef_sc_hd__decap_12
XFILLER_50_109 VGND VGND VPWR VPWR sky130_fd_sc_hd__decap_8
XFILLER_45_81 VPWR VGND VPWR VGND sky130_ef_sc_hd__decap_12
X_10947_ _03595_ _03596_ VGND VGND VPWR VPWR _03597_ sky130_fd_sc_hd__and2b_1
XFILLER_32_813 VGND VGND VPWR VPWR sky130_fd_sc_hd__decap_6
X_13666_ clknet_3_5__leaf_clk _00060_ net719 VGND VGND VPWR VPWR net185 sky130_fd_sc_hd__dfrtp_1
XFILLER_43_183 VPWR VGND VPWR VGND sky130_ef_sc_hd__decap_12
X_12617_ _05413_ _05414_ VGND VGND VPWR VPWR _05416_ sky130_fd_sc_hd__xor2_1
X_10878_ _03521_ VGND VGND VPWR VPWR _03523_ sky130_fd_sc_hd__inv_2
XFILLER_31_378 VGND VGND VPWR VPWR sky130_fd_sc_hd__decap_6
X_13597_ _06407_ _06482_ _06408_ _06484_ _06480_ VGND VGND VPWR VPWR _06485_ sky130_fd_sc_hd__o32a_1
XFILLER_117_417 VGND VGND VPWR VPWR sky130_fd_sc_hd__decap_3
X_12548_ net625 net5 _05339_ _05340_ VGND VGND VPWR VPWR _05342_ sky130_fd_sc_hd__a22o_1
X_12479_ _05263_ _05265_ VGND VGND VPWR VPWR _05266_ sky130_fd_sc_hd__nand2_1
XANTENNA_2 _01376_ VGND VGND VPWR VPWR sky130_fd_sc_hd__diode_2
XFILLER_6_53 VPWR VGND VPWR VGND sky130_ef_sc_hd__decap_12
XFILLER_125_461 VPWR VGND VPWR VGND sky130_ef_sc_hd__decap_12
XFILLER_98_301 VGND VGND VPWR VPWR sky130_fd_sc_hd__fill_1
XFILLER_6_97 VGND VGND VPWR VPWR sky130_fd_sc_hd__decap_6
XFILLER_113_667 VGND VGND VPWR VPWR sky130_fd_sc_hd__fill_1
XFILLER_113_645 VGND VGND VPWR VPWR sky130_fd_sc_hd__fill_2
XFILLER_112_111 VGND VGND VPWR VPWR sky130_fd_sc_hd__fill_1
Xfanout509 net149 VGND VGND VPWR VPWR net509 sky130_fd_sc_hd__buf_2
XTAP_TAPCELL_ROW_70_1309 VGND VPWR sky130_fd_sc_hd__tapvpwrvgnd_1
XFILLER_113_689 VGND VGND VPWR VPWR sky130_fd_sc_hd__decap_6
XFILLER_100_306 VGND VGND VPWR VPWR sky130_fd_sc_hd__fill_2
XFILLER_98_389 VPWR VGND VPWR VGND sky130_ef_sc_hd__decap_12
XFILLER_79_570 VPWR VGND VPWR VGND sky130_ef_sc_hd__decap_12
XFILLER_58_209 VPWR VGND VPWR VGND sky130_ef_sc_hd__decap_12
X_06971_ net519 net682 VGND VGND VPWR VPWR _03019_ sky130_fd_sc_hd__nand2_1
X_09690_ net260 net347 VGND VGND VPWR VPWR _02230_ sky130_fd_sc_hd__nor2_1
X_08710_ _01169_ _01170_ _01175_ VGND VGND VPWR VPWR _01177_ sky130_fd_sc_hd__a21o_1
XFILLER_100_339 VGND VGND VPWR VPWR sky130_fd_sc_hd__decap_3
XFILLER_67_721 VGND VGND VPWR VPWR sky130_fd_sc_hd__decap_6
X_08641_ _01102_ _01104_ VGND VGND VPWR VPWR _01108_ sky130_fd_sc_hd__xnor2_1
XFILLER_67_765 VPWR VGND VPWR VGND sky130_ef_sc_hd__decap_12
XFILLER_66_253 VGND VGND VPWR VPWR sky130_fd_sc_hd__decap_8
XFILLER_81_212 VPWR VGND VPWR VGND sky130_ef_sc_hd__decap_12
X_08572_ _01037_ _01038_ VGND VGND VPWR VPWR _01040_ sky130_fd_sc_hd__xnor2_1
XTAP_TAPCELL_ROW_85_1530 VGND VPWR sky130_fd_sc_hd__tapvpwrvgnd_1
XFILLER_82_757 VGND VGND VPWR VPWR sky130_fd_sc_hd__decap_8
XFILLER_26_139 VGND VGND VPWR VPWR sky130_fd_sc_hd__fill_1
XFILLER_81_278 VGND VGND VPWR VPWR sky130_fd_sc_hd__fill_2
XFILLER_35_673 VPWR VGND VPWR VGND sky130_ef_sc_hd__decap_12
X_07523_ _06743_ _06751_ VGND VGND VPWR VPWR _06752_ sky130_fd_sc_hd__or2_1
X_07454_ _06681_ _06682_ _06678_ VGND VGND VPWR VPWR _06684_ sky130_fd_sc_hd__a21o_1
XFILLER_50_643 VGND VGND VPWR VPWR sky130_fd_sc_hd__fill_1
XFILLER_22_323 VPWR VGND VPWR VGND sky130_ef_sc_hd__decap_12
X_07385_ _06613_ _06614_ VGND VGND VPWR VPWR _06615_ sky130_fd_sc_hd__nand2_1
XFILLER_41_39 VPWR VGND VPWR VGND sky130_ef_sc_hd__decap_12
X_09124_ net461 net330 VGND VGND VPWR VPWR _01612_ sky130_fd_sc_hd__nand2_1
X_09055_ _01534_ _01535_ VGND VGND VPWR VPWR _01537_ sky130_fd_sc_hd__xnor2_1
X_08006_ _00478_ _00480_ VGND VGND VPWR VPWR _00483_ sky130_fd_sc_hd__xnor2_1
XFILLER_104_612 VGND VGND VPWR VPWR sky130_fd_sc_hd__decap_8
XTAP_TAPCELL_ROW_96_1692 VGND VPWR sky130_fd_sc_hd__tapvpwrvgnd_1
XFILLER_104_645 VPWR VGND VPWR VGND sky130_ef_sc_hd__decap_12
XFILLER_103_111 VGND VGND VPWR VPWR sky130_fd_sc_hd__fill_1
X_09957_ _02410_ _02422_ _02409_ VGND VGND VPWR VPWR _02520_ sky130_fd_sc_hd__a21oi_1
XFILLER_89_389 VGND VGND VPWR VPWR sky130_fd_sc_hd__decap_3
XFILLER_77_529 VGND VGND VPWR VPWR sky130_fd_sc_hd__fill_2
X_08908_ _01373_ _01374_ VGND VGND VPWR VPWR _01377_ sky130_fd_sc_hd__xnor2_1
XFILLER_106_65 VPWR VGND VPWR VGND sky130_ef_sc_hd__decap_12
XFILLER_103_199 VGND VGND VPWR VPWR sky130_fd_sc_hd__decap_3
XFILLER_57_220 VGND VGND VPWR VPWR sky130_fd_sc_hd__decap_4
X_09888_ _02442_ _02443_ VGND VGND VPWR VPWR _02446_ sky130_fd_sc_hd__xnor2_1
XFILLER_85_540 VGND VGND VPWR VPWR sky130_fd_sc_hd__fill_1
XFILLER_58_765 VPWR VGND VPWR VGND sky130_ef_sc_hd__decap_12
XFILLER_18_607 VGND VGND VPWR VPWR sky130_fd_sc_hd__fill_2
XFILLER_18_618 VGND VGND VPWR VPWR sky130_fd_sc_hd__fill_2
X_08839_ _01302_ _01303_ _01304_ VGND VGND VPWR VPWR _01305_ sky130_fd_sc_hd__and3_1
XFILLER_122_53 VPWR VGND VPWR VGND sky130_ef_sc_hd__decap_12
XFILLER_72_245 VGND VGND VPWR VPWR sky130_fd_sc_hd__decap_6
X_11850_ _04507_ _04582_ VGND VGND VPWR VPWR _04583_ sky130_fd_sc_hd__nand2b_1
XTAP_TAPCELL_ROW_123_2088 VGND VPWR sky130_fd_sc_hd__tapvpwrvgnd_1
XTAP_TAPCELL_ROW_123_2077 VGND VPWR sky130_fd_sc_hd__tapvpwrvgnd_1
XFILLER_122_97 VGND VGND VPWR VPWR sky130_fd_sc_hd__decap_6
X_11781_ _04385_ _04386_ _04382_ VGND VGND VPWR VPWR _04508_ sky130_fd_sc_hd__a21o_1
XFILLER_14_813 VGND VGND VPWR VPWR sky130_fd_sc_hd__decap_8
X_10801_ net426 net279 _03436_ _03437_ VGND VGND VPWR VPWR _03438_ sky130_fd_sc_hd__a22o_1
XFILLER_32_109 VPWR VGND VPWR VGND sky130_ef_sc_hd__decap_12
X_13520_ _06176_ _06401_ VGND VGND VPWR VPWR _06403_ sky130_fd_sc_hd__xnor2_1
X_10732_ _03222_ _03360_ VGND VGND VPWR VPWR _03362_ sky130_fd_sc_hd__xnor2_1
XTAP_TAPCELL_ROW_0_282 VGND VPWR sky130_fd_sc_hd__tapvpwrvgnd_1
XTAP_TAPCELL_ROW_0_293 VGND VPWR sky130_fd_sc_hd__tapvpwrvgnd_1
XFILLER_15_51 VGND VGND VPWR VPWR sky130_fd_sc_hd__decap_4
X_13451_ _06233_ _06243_ _06232_ VGND VGND VPWR VPWR _06327_ sky130_fd_sc_hd__o21a_1
X_10663_ _03283_ _03286_ VGND VGND VPWR VPWR _03287_ sky130_fd_sc_hd__xnor2_1
XFILLER_40_164 VPWR VGND VPWR VGND sky130_ef_sc_hd__decap_12
X_13382_ net487 net478 net395 VGND VGND VPWR VPWR _06252_ sky130_fd_sc_hd__o21ai_1
X_12402_ _05179_ _05180_ _05181_ VGND VGND VPWR VPWR _05182_ sky130_fd_sc_hd__or3_1
X_10594_ net553 net310 net309 net561 VGND VGND VPWR VPWR _03211_ sky130_fd_sc_hd__a22oi_1
XFILLER_40_197 VGND VGND VPWR VPWR sky130_fd_sc_hd__decap_4
XFILLER_127_748 VGND VGND VPWR VPWR sky130_fd_sc_hd__decap_4
X_12333_ _05102_ _05104_ VGND VGND VPWR VPWR _05106_ sky130_fd_sc_hd__and2b_1
X_12264_ _05028_ _05029_ _05030_ VGND VGND VPWR VPWR _05031_ sky130_fd_sc_hd__nand3_1
XFILLER_122_442 VPWR VGND VPWR VGND sky130_ef_sc_hd__decap_12
X_12195_ _04953_ _04954_ VGND VGND VPWR VPWR _04955_ sky130_fd_sc_hd__xnor2_1
X_11215_ net308 net307 net532 net535 VGND VGND VPWR VPWR _03890_ sky130_fd_sc_hd__and4b_1
XFILLER_122_475 VGND VGND VPWR VPWR sky130_fd_sc_hd__fill_1
XFILLER_95_315 VGND VGND VPWR VPWR sky130_fd_sc_hd__fill_1
X_11146_ _03808_ _03814_ VGND VGND VPWR VPWR _03815_ sky130_fd_sc_hd__xnor2_1
XFILLER_95_337 VPWR VGND VPWR VGND sky130_ef_sc_hd__decap_12
XFILLER_1_783 VGND VGND VPWR VPWR sky130_fd_sc_hd__fill_1
X_11077_ _03577_ _03579_ _03575_ VGND VGND VPWR VPWR _03739_ sky130_fd_sc_hd__a21o_1
X_10028_ _02495_ _02504_ _02503_ VGND VGND VPWR VPWR _02598_ sky130_fd_sc_hd__a21o_1
Xinput161 x3[7] VGND VGND VPWR VPWR net161 sky130_fd_sc_hd__clkbuf_2
Xinput150 x2[4] VGND VGND VPWR VPWR net150 sky130_fd_sc_hd__clkbuf_1
XFILLER_64_724 VPWR VGND VPWR VGND sky130_ef_sc_hd__decap_12
XFILLER_64_779 VGND VGND VPWR VPWR sky130_fd_sc_hd__decap_4
XFILLER_64_757 VGND VGND VPWR VPWR sky130_fd_sc_hd__fill_1
XFILLER_91_576 VGND VGND VPWR VPWR sky130_fd_sc_hd__fill_1
XTAP_TAPCELL_ROW_47_977 VGND VPWR sky130_fd_sc_hd__tapvpwrvgnd_1
X_11979_ _04715_ _04719_ VGND VGND VPWR VPWR _04720_ sky130_fd_sc_hd__xnor2_1
XTAP_TAPCELL_ROW_67_1271 VGND VPWR sky130_fd_sc_hd__tapvpwrvgnd_1
XFILLER_16_161 VGND VGND VPWR VPWR sky130_fd_sc_hd__decap_4
XFILLER_20_805 VGND VGND VPWR VPWR sky130_fd_sc_hd__decap_6
XTAP_TAPCELL_ROW_27_690 VGND VPWR sky130_fd_sc_hd__tapvpwrvgnd_1
XFILLER_32_643 VGND VGND VPWR VPWR sky130_fd_sc_hd__fill_1
X_13649_ clknet_3_5__leaf_clk _00032_ net719 VGND VGND VPWR VPWR net168 sky130_fd_sc_hd__dfrtp_1
XFILLER_82_3 VPWR VGND VPWR VGND sky130_ef_sc_hd__decap_12
XTAP_TAPCELL_ROW_80_1460 VGND VPWR sky130_fd_sc_hd__tapvpwrvgnd_1
X_07170_ _03379_ _03511_ _03500_ VGND VGND VPWR VPWR _05188_ sky130_fd_sc_hd__a21bo_1
XFILLER_118_726 VPWR VGND VPWR VGND sky130_ef_sc_hd__decap_12
XFILLER_133_718 VGND VGND VPWR VPWR sky130_fd_sc_hd__decap_3
XFILLER_126_781 VPWR VGND VPWR VGND sky130_ef_sc_hd__decap_12
X_09811_ net496 _00342_ net342 VGND VGND VPWR VPWR _02362_ sky130_fd_sc_hd__o21a_1
Xfanout339 net59 VGND VGND VPWR VPWR net339 sky130_fd_sc_hd__buf_2
XFILLER_113_442 VGND VGND VPWR VPWR sky130_fd_sc_hd__decap_6
XFILLER_101_604 VGND VGND VPWR VPWR sky130_fd_sc_hd__decap_4
XFILLER_98_153 VGND VGND VPWR VPWR sky130_fd_sc_hd__decap_8
Xfanout306 net307 VGND VGND VPWR VPWR net306 sky130_fd_sc_hd__buf_2
Xfanout317 net71 VGND VGND VPWR VPWR net317 sky130_fd_sc_hd__clkbuf_4
Xfanout328 net66 VGND VGND VPWR VPWR net328 sky130_fd_sc_hd__buf_1
X_09742_ _02285_ _02286_ VGND VGND VPWR VPWR _02287_ sky130_fd_sc_hd__xnor2_1
X_06954_ _02771_ _02802_ _02823_ VGND VGND VPWR VPWR _02834_ sky130_fd_sc_hd__a21o_1
X_09673_ _02057_ _02210_ VGND VGND VPWR VPWR _02211_ sky130_fd_sc_hd__xnor2_1
X_06885_ _02041_ _02074_ VGND VGND VPWR VPWR _02085_ sky130_fd_sc_hd__xnor2_1
XFILLER_27_426 VGND VGND VPWR VPWR sky130_fd_sc_hd__decap_3
X_08624_ _01055_ _01090_ VGND VGND VPWR VPWR _01091_ sky130_fd_sc_hd__nor2_1
XFILLER_54_234 VGND VGND VPWR VPWR sky130_fd_sc_hd__fill_2
X_08555_ _01022_ _01023_ VGND VGND VPWR VPWR _01024_ sky130_fd_sc_hd__nand2_1
XFILLER_82_587 VGND VGND VPWR VPWR sky130_fd_sc_hd__fill_1
XFILLER_54_267 VPWR VGND VPWR VGND sky130_ef_sc_hd__decap_12
XFILLER_42_418 VGND VGND VPWR VPWR sky130_fd_sc_hd__fill_2
XFILLER_70_749 VGND VGND VPWR VPWR sky130_fd_sc_hd__decap_6
X_07506_ _06624_ _06652_ _06653_ _06655_ _06623_ VGND VGND VPWR VPWR _06735_ sky130_fd_sc_hd__a32o_1
XFILLER_54_289 VPWR VGND VPWR VGND sky130_ef_sc_hd__decap_12
XFILLER_35_492 VGND VGND VPWR VPWR sky130_fd_sc_hd__fill_1
XFILLER_52_27 VGND VGND VPWR VPWR sky130_fd_sc_hd__fill_1
X_08486_ _00799_ _00958_ VGND VGND VPWR VPWR _00959_ sky130_fd_sc_hd__xnor2_1
X_07437_ net710 net612 net605 net267 VGND VGND VPWR VPWR _06667_ sky130_fd_sc_hd__a22o_1
XFILLER_109_704 VGND VGND VPWR VPWR sky130_fd_sc_hd__fill_1
XTAP_TAPCELL_ROW_98_1721 VGND VPWR sky130_fd_sc_hd__tapvpwrvgnd_1
XFILLER_7_809 VPWR VGND VPWR VGND sky130_ef_sc_hd__decap_12
XFILLER_22_197 VGND VGND VPWR VPWR sky130_fd_sc_hd__decap_6
X_07368_ _05657_ _05690_ _06597_ VGND VGND VPWR VPWR _06598_ sky130_fd_sc_hd__a21o_1
X_09107_ net431 net336 _01590_ _01591_ VGND VGND VPWR VPWR _01593_ sky130_fd_sc_hd__nand4_1
XFILLER_109_737 VPWR VGND VPWR VGND sky130_ef_sc_hd__decap_12
XFILLER_108_247 VGND VGND VPWR VPWR sky130_fd_sc_hd__fill_2
X_07299_ net267 net611 VGND VGND VPWR VPWR _06530_ sky130_fd_sc_hd__nand2_1
X_09038_ _01381_ _01516_ VGND VGND VPWR VPWR _01519_ sky130_fd_sc_hd__xnor2_1
XFILLER_123_217 VGND VGND VPWR VPWR sky130_fd_sc_hd__decap_3
XFILLER_117_75 VGND VGND VPWR VPWR sky130_fd_sc_hd__fill_1
XFILLER_77_13 VPWR VGND VPWR VGND sky130_ef_sc_hd__decap_12
X_11000_ net325 net599 VGND VGND VPWR VPWR _03656_ sky130_fd_sc_hd__and2b_1
XFILLER_77_337 VPWR VGND VPWR VGND sky130_ef_sc_hd__decap_12
XFILLER_77_57 VGND VGND VPWR VPWR sky130_fd_sc_hd__decap_8
XTAP_TAPCELL_ROW_125_2106 VGND VPWR sky130_fd_sc_hd__tapvpwrvgnd_1
XTAP_TAPCELL_ROW_125_2117 VGND VPWR sky130_fd_sc_hd__tapvpwrvgnd_1
XFILLER_100_670 VGND VGND VPWR VPWR sky130_fd_sc_hd__decap_3
X_12951_ net487 net478 net398 net397 VGND VGND VPWR VPWR _05781_ sky130_fd_sc_hd__and4_1
XTAP_TAPCELL_ROW_5_374 VGND VPWR sky130_fd_sc_hd__tapvpwrvgnd_1
XFILLER_85_381 VGND VGND VPWR VPWR sky130_fd_sc_hd__decap_8
X_12882_ _05521_ _05539_ _05537_ VGND VGND VPWR VPWR _05706_ sky130_fd_sc_hd__a21bo_1
X_11902_ _04440_ _04467_ VGND VGND VPWR VPWR _04639_ sky130_fd_sc_hd__xnor2_1
XTAP_TAPCELL_ROW_107_1850 VGND VPWR sky130_fd_sc_hd__tapvpwrvgnd_1
XFILLER_61_727 VGND VGND VPWR VPWR sky130_fd_sc_hd__fill_1
XFILLER_45_267 VPWR VGND VPWR VGND sky130_ef_sc_hd__decap_12
X_11833_ _04470_ _04473_ _04475_ _04476_ VGND VGND VPWR VPWR _04564_ sky130_fd_sc_hd__nor4_1
XFILLER_60_215 VGND VGND VPWR VPWR sky130_fd_sc_hd__decap_6
XTAP_TAPCELL_ROW_44_936 VGND VPWR sky130_fd_sc_hd__tapvpwrvgnd_1
XFILLER_14_632 VGND VGND VPWR VPWR sky130_fd_sc_hd__fill_1
X_11764_ _04488_ _04465_ VGND VGND VPWR VPWR _04489_ sky130_fd_sc_hd__and2b_1
X_13503_ _06381_ _06382_ _06368_ VGND VGND VPWR VPWR _06384_ sky130_fd_sc_hd__o21ai_1
X_11695_ _04344_ _04413_ VGND VGND VPWR VPWR _04414_ sky130_fd_sc_hd__xnor2_1
XFILLER_9_113 VGND VGND VPWR VPWR sky130_fd_sc_hd__decap_6
X_10715_ _03247_ _03342_ _03343_ VGND VGND VPWR VPWR _03344_ sky130_fd_sc_hd__nor3_1
X_13434_ _05315_ _06220_ _06305_ VGND VGND VPWR VPWR _06308_ sky130_fd_sc_hd__or3_1
X_10646_ _03266_ _03267_ _03135_ VGND VGND VPWR VPWR _03268_ sky130_fd_sc_hd__a21oi_1
XTAP_TAPCELL_ROW_136_2268 VGND VPWR sky130_fd_sc_hd__tapvpwrvgnd_1
X_13365_ _06230_ _06231_ VGND VGND VPWR VPWR _06233_ sky130_fd_sc_hd__xor2_1
X_10577_ _03104_ _03105_ _03189_ _03191_ VGND VGND VPWR VPWR _03193_ sky130_fd_sc_hd__or4_4
XFILLER_115_729 VGND VGND VPWR VPWR sky130_fd_sc_hd__decap_6
XFILLER_108_781 VPWR VGND VPWR VGND sky130_ef_sc_hd__decap_12
X_13296_ _06155_ _06156_ VGND VGND VPWR VPWR _06158_ sky130_fd_sc_hd__xor2_2
X_12316_ _04948_ _05085_ VGND VGND VPWR VPWR _05087_ sky130_fd_sc_hd__and2_1
X_12247_ _04839_ _04841_ _05011_ VGND VGND VPWR VPWR _05012_ sky130_fd_sc_hd__a21o_1
XFILLER_122_250 VGND VGND VPWR VPWR sky130_fd_sc_hd__fill_2
XFILLER_96_635 VGND VGND VPWR VPWR sky130_fd_sc_hd__fill_1
X_12178_ _04933_ _04935_ _04749_ VGND VGND VPWR VPWR _04938_ sky130_fd_sc_hd__a21o_1
XFILLER_49_540 VGND VGND VPWR VPWR sky130_fd_sc_hd__decap_8
X_11129_ _03781_ _03796_ VGND VGND VPWR VPWR _03797_ sky130_fd_sc_hd__xnor2_1
XFILLER_110_489 VPWR VGND VPWR VGND sky130_ef_sc_hd__decap_12
XFILLER_95_167 VGND VGND VPWR VPWR sky130_fd_sc_hd__fill_1
XTAP_TAPCELL_ROW_69_1300 VGND VPWR sky130_fd_sc_hd__tapvpwrvgnd_1
XFILLER_67_90 VGND VGND VPWR VPWR sky130_fd_sc_hd__decap_4
XFILLER_36_267 VPWR VGND VPWR VGND sky130_ef_sc_hd__decap_12
XFILLER_60_760 VPWR VGND VPWR VGND sky130_ef_sc_hd__decap_12
X_08340_ _00731_ _00733_ _00743_ VGND VGND VPWR VPWR _00814_ sky130_fd_sc_hd__a21o_1
X_08271_ _00744_ _00745_ VGND VGND VPWR VPWR _00746_ sky130_fd_sc_hd__nor2_1
XTAP_TAPCELL_ROW_22_619 VGND VPWR sky130_fd_sc_hd__tapvpwrvgnd_1
X_07222_ net581 net689 VGND VGND VPWR VPWR _05755_ sky130_fd_sc_hd__nand2_1
X_07153_ net467 net666 _03358_ VGND VGND VPWR VPWR _05002_ sky130_fd_sc_hd__a21oi_1
XFILLER_9_680 VGND VGND VPWR VPWR sky130_fd_sc_hd__fill_1
XFILLER_118_545 VPWR VGND VPWR VGND sky130_ef_sc_hd__decap_12
X_07084_ _02866_ _02898_ _02855_ VGND VGND VPWR VPWR _04253_ sky130_fd_sc_hd__a21oi_1
XFILLER_133_559 VGND VGND VPWR VPWR sky130_fd_sc_hd__fill_1
XTAP_TAPCELL_ROW_93_1651 VGND VPWR sky130_fd_sc_hd__tapvpwrvgnd_1
XFILLER_87_635 VPWR VGND VPWR VGND sky130_ef_sc_hd__decap_12
XFILLER_59_337 VPWR VGND VPWR VGND sky130_ef_sc_hd__decap_12
XFILLER_101_456 VPWR VGND VPWR VGND sky130_ef_sc_hd__decap_12
XFILLER_101_445 VGND VGND VPWR VPWR sky130_fd_sc_hd__decap_3
XFILLER_47_27 VPWR VGND VPWR VGND sky130_ef_sc_hd__decap_12
X_07986_ _00460_ _00461_ VGND VGND VPWR VPWR _00463_ sky130_fd_sc_hd__and2_1
X_09725_ _02262_ _02267_ VGND VGND VPWR VPWR _02268_ sky130_fd_sc_hd__xnor2_1
XTAP_TAPCELL_ROW_2_322 VGND VPWR sky130_fd_sc_hd__tapvpwrvgnd_1
X_06937_ _02619_ _02641_ net702 net569 VGND VGND VPWR VPWR _02652_ sky130_fd_sc_hd__and4b_1
X_09656_ _02190_ _02191_ VGND VGND VPWR VPWR _02192_ sky130_fd_sc_hd__nand2_1
XTAP_TAPCELL_ROW_2_333 VGND VPWR sky130_fd_sc_hd__tapvpwrvgnd_1
XFILLER_28_757 VPWR VGND VPWR VGND sky130_ef_sc_hd__decap_12
X_08607_ _01003_ _01030_ _01074_ VGND VGND VPWR VPWR _01075_ sky130_fd_sc_hd__nor3b_1
XFILLER_103_55 VGND VGND VPWR VPWR sky130_fd_sc_hd__fill_1
XFILLER_82_362 VGND VGND VPWR VPWR sky130_fd_sc_hd__fill_2
X_06868_ _01573_ _01889_ VGND VGND VPWR VPWR _01900_ sky130_fd_sc_hd__nor2_1
XFILLER_63_15 VPWR VGND VPWR VGND sky130_ef_sc_hd__decap_12
XFILLER_55_576 VGND VGND VPWR VPWR sky130_fd_sc_hd__decap_4
XFILLER_43_716 VPWR VGND VPWR VGND sky130_ef_sc_hd__decap_12
XTAP_TAPCELL_ROW_120_2036 VGND VPWR sky130_fd_sc_hd__tapvpwrvgnd_1
X_09587_ net448 net329 VGND VGND VPWR VPWR _02117_ sky130_fd_sc_hd__and2_1
XFILLER_70_524 VGND VGND VPWR VPWR sky130_fd_sc_hd__fill_1
X_08538_ _01005_ _01006_ VGND VGND VPWR VPWR _01007_ sky130_fd_sc_hd__nor2_1
X_08469_ _00940_ _00941_ VGND VGND VPWR VPWR _00942_ sky130_fd_sc_hd__nor2_1
XFILLER_23_473 VPWR VGND VPWR VGND sky130_ef_sc_hd__decap_12
XFILLER_128_309 VPWR VGND VPWR VGND sky130_ef_sc_hd__decap_12
XTAP_TAPCELL_ROW_102_1780 VGND VPWR sky130_fd_sc_hd__tapvpwrvgnd_1
XFILLER_50_292 VPWR VGND VPWR VGND sky130_ef_sc_hd__decap_12
X_10500_ net494 net83 VGND VGND VPWR VPWR _03109_ sky130_fd_sc_hd__nand2_1
XFILLER_137_821 VGND VGND VPWR VPWR sky130_fd_sc_hd__decap_3
XFILLER_10_145 VGND VGND VPWR VPWR sky130_fd_sc_hd__fill_1
X_11480_ net544 _03880_ VGND VGND VPWR VPWR _04180_ sky130_fd_sc_hd__and2_1
XFILLER_11_668 VGND VGND VPWR VPWR sky130_fd_sc_hd__decap_4
XFILLER_6_138 VGND VGND VPWR VPWR sky130_fd_sc_hd__fill_2
XFILLER_12_41 VPWR VGND VPWR VGND sky130_ef_sc_hd__decap_12
X_10431_ _03029_ _03032_ _03033_ VGND VGND VPWR VPWR _03034_ sky130_fd_sc_hd__nand3_1
XFILLER_128_41 VPWR VGND VPWR VGND sky130_ef_sc_hd__decap_12
X_13150_ _05995_ _05997_ VGND VGND VPWR VPWR _05999_ sky130_fd_sc_hd__xnor2_2
X_10362_ _02956_ _02957_ VGND VGND VPWR VPWR _02958_ sky130_fd_sc_hd__and2b_1
XFILLER_128_85 VPWR VGND VPWR VGND sky130_ef_sc_hd__decap_12
XFILLER_124_559 VPWR VGND VPWR VGND sky130_ef_sc_hd__decap_12
X_13081_ _05912_ _05921_ VGND VGND VPWR VPWR _05923_ sky130_fd_sc_hd__xor2_1
X_12101_ net656 net645 net338 net353 VGND VGND VPWR VPWR _04853_ sky130_fd_sc_hd__nand4_1
XFILLER_2_300 VGND VGND VPWR VPWR sky130_fd_sc_hd__fill_1
X_10293_ _02824_ _02830_ _02882_ VGND VGND VPWR VPWR _02883_ sky130_fd_sc_hd__a21oi_1
XTAP_TAPCELL_ROW_131_2198 VGND VPWR sky130_fd_sc_hd__tapvpwrvgnd_1
X_12032_ _04775_ _04776_ net572 net679 VGND VGND VPWR VPWR _04777_ sky130_fd_sc_hd__and4bb_1
XFILLER_104_261 VGND VGND VPWR VPWR sky130_fd_sc_hd__fill_1
XFILLER_104_250 VGND VGND VPWR VPWR sky130_fd_sc_hd__fill_2
XFILLER_78_613 VPWR VGND VPWR VGND sky130_ef_sc_hd__decap_12
XFILLER_120_765 VGND VGND VPWR VPWR sky130_fd_sc_hd__fill_2
XFILLER_66_819 VGND VGND VPWR VPWR sky130_fd_sc_hd__fill_1
Xfanout670 net671 VGND VGND VPWR VPWR net670 sky130_fd_sc_hd__buf_2
Xfanout681 net119 VGND VGND VPWR VPWR net681 sky130_fd_sc_hd__clkbuf_4
XFILLER_18_201 VGND VGND VPWR VPWR sky130_fd_sc_hd__fill_1
Xfanout692 net111 VGND VGND VPWR VPWR net692 sky130_fd_sc_hd__dlymetal6s2s_1
X_12934_ _05623_ _05626_ _05622_ VGND VGND VPWR VPWR _05762_ sky130_fd_sc_hd__a21oi_1
XFILLER_46_565 VPWR VGND VPWR VGND sky130_ef_sc_hd__decap_12
XPHY_EDGE_ROW_16_Right_16 VGND VGND VPWR VPWR sky130_fd_sc_hd__decap_3
XFILLER_37_93 VPWR VGND VPWR VGND sky130_ef_sc_hd__decap_12
X_12865_ _05680_ _05685_ VGND VGND VPWR VPWR _05687_ sky130_fd_sc_hd__xor2_1
XFILLER_18_289 VGND VGND VPWR VPWR sky130_fd_sc_hd__decap_8
X_12796_ _05609_ _05610_ VGND VGND VPWR VPWR _05611_ sky130_fd_sc_hd__nand2_1
XTAP_TAPCELL_ROW_64_1230 VGND VPWR sky130_fd_sc_hd__tapvpwrvgnd_1
X_11816_ _04348_ _04445_ _04346_ VGND VGND VPWR VPWR _04545_ sky130_fd_sc_hd__a21o_1
XTAP_TAPCELL_ROW_138_2319 VGND VPWR sky130_fd_sc_hd__tapvpwrvgnd_1
XTAP_TAPCELL_ROW_138_2308 VGND VPWR sky130_fd_sc_hd__tapvpwrvgnd_1
XFILLER_53_81 VGND VGND VPWR VPWR sky130_fd_sc_hd__decap_4
X_11747_ net270 _03426_ net410 VGND VGND VPWR VPWR _04470_ sky130_fd_sc_hd__and3b_1
XFILLER_42_793 VPWR VGND VPWR VGND sky130_ef_sc_hd__decap_12
XFILLER_41_281 VPWR VGND VPWR VGND sky130_ef_sc_hd__decap_12
XFILLER_128_821 VGND VGND VPWR VPWR sky130_fd_sc_hd__decap_3
X_11678_ _03617_ _04394_ VGND VGND VPWR VPWR _04396_ sky130_fd_sc_hd__xor2_1
X_13417_ _06288_ _06289_ VGND VGND VPWR VPWR _06290_ sky130_fd_sc_hd__nor2_1
X_10629_ net476 net297 VGND VGND VPWR VPWR _03250_ sky130_fd_sc_hd__nand2_1
XPHY_EDGE_ROW_25_Right_25 VGND VGND VPWR VPWR sky130_fd_sc_hd__decap_3
X_13348_ _05696_ _06104_ VGND VGND VPWR VPWR _06215_ sky130_fd_sc_hd__nor2_1
XFILLER_115_559 VGND VGND VPWR VPWR sky130_fd_sc_hd__fill_1
XFILLER_115_537 VGND VGND VPWR VPWR sky130_fd_sc_hd__decap_8
XFILLER_6_694 VGND VGND VPWR VPWR sky130_fd_sc_hd__fill_1
X_13279_ _06125_ _06137_ VGND VGND VPWR VPWR _06140_ sky130_fd_sc_hd__nor2_1
XTAP_TAPCELL_ROW_75_1381 VGND VPWR sky130_fd_sc_hd__tapvpwrvgnd_1
XFILLER_45_3 VPWR VGND VPWR VGND sky130_ef_sc_hd__decap_12
XFILLER_130_529 VGND VGND VPWR VPWR sky130_fd_sc_hd__decap_3
XFILLER_123_581 VGND VGND VPWR VPWR sky130_fd_sc_hd__decap_4
XTAP_TAPCELL_ROW_75_1392 VGND VPWR sky130_fd_sc_hd__tapvpwrvgnd_1
XFILLER_111_765 VPWR VGND VPWR VGND sky130_ef_sc_hd__decap_12
XFILLER_96_454 VGND VGND VPWR VPWR sky130_fd_sc_hd__fill_1
X_07840_ _00196_ _00205_ _00204_ VGND VGND VPWR VPWR _00318_ sky130_fd_sc_hd__a21o_1
XFILLER_83_104 VGND VGND VPWR VPWR sky130_fd_sc_hd__fill_2
XFILLER_68_189 VGND VGND VPWR VPWR sky130_fd_sc_hd__decap_6
XFILLER_68_156 VPWR VGND VPWR VGND sky130_ef_sc_hd__decap_12
X_07771_ _00244_ _00249_ VGND VGND VPWR VPWR _00250_ sky130_fd_sc_hd__and2_1
X_09510_ _01912_ _01949_ _01948_ VGND VGND VPWR VPWR _02033_ sky130_fd_sc_hd__a21oi_1
XFILLER_84_649 VGND VGND VPWR VPWR sky130_fd_sc_hd__fill_1
XFILLER_49_370 VGND VGND VPWR VPWR sky130_fd_sc_hd__fill_1
XPHY_EDGE_ROW_34_Right_34 VGND VGND VPWR VPWR sky130_fd_sc_hd__decap_3
XFILLER_37_576 VGND VGND VPWR VPWR sky130_fd_sc_hd__decap_4
X_09441_ _01956_ _01957_ VGND VGND VPWR VPWR _01958_ sky130_fd_sc_hd__xnor2_1
XFILLER_24_215 VPWR VGND VPWR VGND sky130_ef_sc_hd__decap_12
X_09372_ _01879_ _01882_ VGND VGND VPWR VPWR _01883_ sky130_fd_sc_hd__xnor2_1
XFILLER_52_546 VGND VGND VPWR VPWR sky130_fd_sc_hd__decap_3
X_08323_ _00718_ _00720_ VGND VGND VPWR VPWR _00797_ sky130_fd_sc_hd__nor2_1
XFILLER_33_771 VPWR VGND VPWR VGND sky130_ef_sc_hd__decap_12
XFILLER_20_421 VGND VGND VPWR VPWR sky130_fd_sc_hd__fill_1
X_08254_ _00727_ _00728_ VGND VGND VPWR VPWR _00729_ sky130_fd_sc_hd__nor2_1
XPHY_EDGE_ROW_43_Right_43 VGND VGND VPWR VPWR sky130_fd_sc_hd__decap_3
X_07205_ _03314_ _04772_ _04794_ VGND VGND VPWR VPWR _05570_ sky130_fd_sc_hd__a21o_1
X_08185_ _00501_ _00540_ _00539_ VGND VGND VPWR VPWR _00661_ sky130_fd_sc_hd__a21oi_2
XFILLER_134_813 VGND VGND VPWR VPWR sky130_fd_sc_hd__decap_8
XFILLER_118_353 VGND VGND VPWR VPWR sky130_fd_sc_hd__decap_8
X_07136_ _04794_ _04805_ VGND VGND VPWR VPWR _04816_ sky130_fd_sc_hd__or2_1
XFILLER_133_334 VGND VGND VPWR VPWR sky130_fd_sc_hd__fill_2
X_07067_ net106 net562 _02887_ VGND VGND VPWR VPWR _04068_ sky130_fd_sc_hd__a21oi_1
XFILLER_133_356 VGND VGND VPWR VPWR sky130_fd_sc_hd__decap_3
XTAP_TAPCELL_ROW_7_403 VGND VPWR sky130_fd_sc_hd__tapvpwrvgnd_1
XFILLER_133_389 VGND VGND VPWR VPWR sky130_fd_sc_hd__decap_3
XFILLER_99_281 VGND VGND VPWR VPWR sky130_fd_sc_hd__decap_8
XFILLER_58_15 VPWR VGND VPWR VGND sky130_ef_sc_hd__decap_12
XFILLER_59_167 VGND VGND VPWR VPWR sky130_fd_sc_hd__fill_1
XPHY_EDGE_ROW_52_Right_52 VGND VGND VPWR VPWR sky130_fd_sc_hd__decap_3
X_09708_ _02090_ _02098_ _02097_ VGND VGND VPWR VPWR _02250_ sky130_fd_sc_hd__a21oi_1
XFILLER_114_65 VPWR VGND VPWR VGND sky130_ef_sc_hd__decap_12
X_07969_ _00442_ _00445_ VGND VGND VPWR VPWR _00446_ sky130_fd_sc_hd__xor2_1
XFILLER_83_660 VPWR VGND VPWR VGND sky130_ef_sc_hd__decap_12
X_10980_ net433 net276 net278 net424 VGND VGND VPWR VPWR _03634_ sky130_fd_sc_hd__a22o_1
X_09639_ _02172_ _02174_ VGND VGND VPWR VPWR _02175_ sky130_fd_sc_hd__xnor2_1
XFILLER_28_587 VGND VGND VPWR VPWR sky130_fd_sc_hd__fill_1
XFILLER_130_53 VPWR VGND VPWR VGND sky130_ef_sc_hd__decap_12
X_12650_ _05314_ _05336_ _05335_ VGND VGND VPWR VPWR _05453_ sky130_fd_sc_hd__a21o_1
XFILLER_15_237 VPWR VGND VPWR VGND sky130_ef_sc_hd__decap_12
XFILLER_130_97 VPWR VGND VPWR VGND sky130_ef_sc_hd__decap_12
XFILLER_70_387 VGND VGND VPWR VPWR sky130_fd_sc_hd__decap_8
X_11601_ _04236_ _04238_ VGND VGND VPWR VPWR _04311_ sky130_fd_sc_hd__nor2_1
X_12581_ _05273_ _05377_ VGND VGND VPWR VPWR _05378_ sky130_fd_sc_hd__or2_1
XPHY_EDGE_ROW_61_Right_61 VGND VGND VPWR VPWR sky130_fd_sc_hd__decap_3
XFILLER_23_281 VGND VGND VPWR VPWR sky130_fd_sc_hd__decap_8
X_11532_ _04211_ _04235_ VGND VGND VPWR VPWR _04237_ sky130_fd_sc_hd__xnor2_1
XFILLER_23_51 VGND VGND VPWR VPWR sky130_fd_sc_hd__decap_4
XTAP_TAPCELL_ROW_133_2227 VGND VPWR sky130_fd_sc_hd__tapvpwrvgnd_1
XFILLER_128_139 VGND VGND VPWR VPWR sky130_fd_sc_hd__fill_1
X_11463_ _04161_ VGND VGND VPWR VPWR _04162_ sky130_fd_sc_hd__inv_2
XFILLER_11_498 VGND VGND VPWR VPWR sky130_fd_sc_hd__fill_1
XFILLER_23_84 VGND VGND VPWR VPWR sky130_fd_sc_hd__decap_6
X_13202_ _06054_ net247 VGND VGND VPWR VPWR _06055_ sky130_fd_sc_hd__nand2b_1
X_10414_ _03004_ _03006_ _03005_ VGND VGND VPWR VPWR _03015_ sky130_fd_sc_hd__o21ai_1
XFILLER_124_323 VPWR VGND VPWR VGND sky130_ef_sc_hd__decap_12
XFILLER_124_312 VGND VGND VPWR VPWR sky130_fd_sc_hd__decap_4
X_13133_ _05970_ _05979_ VGND VGND VPWR VPWR _05980_ sky130_fd_sc_hd__nand2_1
X_11394_ net276 net410 VGND VGND VPWR VPWR _04086_ sky130_fd_sc_hd__and2b_1
XFILLER_124_345 VPWR VGND VPWR VGND sky130_ef_sc_hd__decap_12
XTAP_TAPCELL_ROW_115_1971 VGND VPWR sky130_fd_sc_hd__tapvpwrvgnd_1
XTAP_TAPCELL_ROW_115_1960 VGND VPWR sky130_fd_sc_hd__tapvpwrvgnd_1
X_10345_ _02936_ _02938_ VGND VGND VPWR VPWR _02939_ sky130_fd_sc_hd__nor2_1
X_13064_ _05901_ _05903_ VGND VGND VPWR VPWR _05904_ sky130_fd_sc_hd__nor2_1
XFILLER_97_218 VGND VGND VPWR VPWR sky130_fd_sc_hd__decap_6
XFILLER_78_421 VGND VGND VPWR VPWR sky130_fd_sc_hd__decap_8
XPHY_EDGE_ROW_70_Right_70 VGND VGND VPWR VPWR sky130_fd_sc_hd__decap_3
XFILLER_2_141 VGND VGND VPWR VPWR sky130_fd_sc_hd__fill_1
XFILLER_2_163 VGND VGND VPWR VPWR sky130_fd_sc_hd__fill_1
X_10276_ _02858_ _02862_ VGND VGND VPWR VPWR _02864_ sky130_fd_sc_hd__xnor2_1
X_12015_ net529 net400 VGND VGND VPWR VPWR _04758_ sky130_fd_sc_hd__nand2_1
XFILLER_78_443 VGND VGND VPWR VPWR sky130_fd_sc_hd__decap_8
XFILLER_93_424 VGND VGND VPWR VPWR sky130_fd_sc_hd__decap_6
XFILLER_66_638 VGND VGND VPWR VPWR sky130_fd_sc_hd__decap_6
XFILLER_93_457 VGND VGND VPWR VPWR sky130_fd_sc_hd__fill_1
XFILLER_65_159 VGND VGND VPWR VPWR sky130_fd_sc_hd__decap_8
X_12917_ _05741_ _05742_ VGND VGND VPWR VPWR _05743_ sky130_fd_sc_hd__nor2_1
XFILLER_80_129 VGND VGND VPWR VPWR sky130_fd_sc_hd__decap_8
XFILLER_62_811 VGND VGND VPWR VPWR sky130_fd_sc_hd__fill_1
XFILLER_46_373 VGND VGND VPWR VPWR sky130_fd_sc_hd__fill_1
XFILLER_0_77 VGND VGND VPWR VPWR sky130_fd_sc_hd__decap_3
XFILLER_34_513 VPWR VGND VPWR VGND sky130_ef_sc_hd__decap_12
X_12848_ net445 net382 VGND VGND VPWR VPWR _05669_ sky130_fd_sc_hd__nand2_1
XFILLER_64_80 VGND VGND VPWR VPWR sky130_fd_sc_hd__decap_4
XPHY_EDGE_ROW_14_Left_153 VGND VGND VPWR VPWR sky130_fd_sc_hd__decap_3
X_12779_ _05415_ _05418_ VGND VGND VPWR VPWR _05593_ sky130_fd_sc_hd__nand2_1
XFILLER_9_86 VPWR VGND VPWR VGND sky130_ef_sc_hd__decap_12
XFILLER_30_752 VGND VGND VPWR VPWR sky130_fd_sc_hd__decap_4
XTAP_TAPCELL_ROW_32_758 VGND VPWR sky130_fd_sc_hd__tapvpwrvgnd_1
XTAP_TAPCELL_ROW_32_769 VGND VPWR sky130_fd_sc_hd__tapvpwrvgnd_1
XTAP_TAPCELL_ROW_12_471 VGND VPWR sky130_fd_sc_hd__tapvpwrvgnd_1
XFILLER_134_109 VPWR VGND VPWR VGND sky130_ef_sc_hd__decap_12
XFILLER_116_813 VGND VGND VPWR VPWR sky130_fd_sc_hd__decap_6
XTAP_TAPCELL_ROW_77_1421 VGND VPWR sky130_fd_sc_hd__tapvpwrvgnd_1
XTAP_TAPCELL_ROW_77_1410 VGND VPWR sky130_fd_sc_hd__tapvpwrvgnd_1
XFILLER_127_183 VGND VGND VPWR VPWR sky130_fd_sc_hd__fill_1
X_09990_ _02388_ _02426_ _02425_ VGND VGND VPWR VPWR _02557_ sky130_fd_sc_hd__a21boi_1
XTAP_TAPCELL_ROW_90_1610 VGND VPWR sky130_fd_sc_hd__tapvpwrvgnd_1
XPHY_EDGE_ROW_23_Left_162 VGND VGND VPWR VPWR sky130_fd_sc_hd__decap_3
X_08941_ net506 net54 VGND VGND VPWR VPWR _01413_ sky130_fd_sc_hd__nand2_1
XFILLER_130_348 VGND VGND VPWR VPWR sky130_fd_sc_hd__decap_4
X_08872_ _01334_ _01335_ _01336_ VGND VGND VPWR VPWR _01338_ sky130_fd_sc_hd__a21oi_2
XFILLER_97_741 VGND VGND VPWR VPWR sky130_fd_sc_hd__fill_2
XFILLER_28_29 VPWR VGND VPWR VGND sky130_ef_sc_hd__decap_12
X_07823_ net559 net689 net688 net563 VGND VGND VPWR VPWR _00301_ sky130_fd_sc_hd__a22o_1
XFILLER_56_115 VGND VGND VPWR VPWR sky130_fd_sc_hd__decap_8
XFILLER_84_457 VGND VGND VPWR VPWR sky130_fd_sc_hd__decap_4
X_07754_ _00075_ _00232_ VGND VGND VPWR VPWR _00233_ sky130_fd_sc_hd__nor2_1
XFILLER_56_159 VPWR VGND VPWR VGND sky130_ef_sc_hd__decap_12
XTAP_TAPCELL_ROW_88_1572 VGND VPWR sky130_fd_sc_hd__tapvpwrvgnd_1
XFILLER_25_502 VGND VGND VPWR VPWR sky130_fd_sc_hd__fill_2
XFILLER_37_384 VGND VGND VPWR VPWR sky130_fd_sc_hd__fill_1
X_07685_ _06750_ _06752_ _00163_ VGND VGND VPWR VPWR _00164_ sky130_fd_sc_hd__a21oi_1
X_09424_ _01934_ _01938_ VGND VGND VPWR VPWR _01939_ sky130_fd_sc_hd__and2_1
XFILLER_64_181 VPWR VGND VPWR VGND sky130_ef_sc_hd__decap_12
XPHY_EDGE_ROW_32_Left_171 VGND VGND VPWR VPWR sky130_fd_sc_hd__decap_3
XFILLER_52_365 VPWR VGND VPWR VGND sky130_ef_sc_hd__decap_12
X_09355_ _01862_ _01863_ VGND VGND VPWR VPWR _01864_ sky130_fd_sc_hd__nor2_1
XFILLER_138_426 VGND VGND VPWR VPWR sky130_fd_sc_hd__decap_4
XFILLER_138_415 VGND VGND VPWR VPWR sky130_fd_sc_hd__fill_1
X_09286_ net461 net453 net329 VGND VGND VPWR VPWR _01789_ sky130_fd_sc_hd__nand3_1
X_08306_ _00779_ _00780_ VGND VGND VPWR VPWR _00781_ sky130_fd_sc_hd__nand2b_1
XFILLER_21_763 VPWR VGND VPWR VGND sky130_ef_sc_hd__decap_12
X_08237_ _00710_ _00711_ VGND VGND VPWR VPWR _00712_ sky130_fd_sc_hd__or2_1
XFILLER_21_785 VPWR VGND VPWR VGND sky130_ef_sc_hd__decap_12
XFILLER_119_673 VGND VGND VPWR VPWR sky130_fd_sc_hd__fill_1
Xclkbuf_3_0__f_clk clknet_0_clk VGND VGND VPWR VPWR clknet_3_0__leaf_clk sky130_fd_sc_hd__clkbuf_16
X_08168_ net434 net425 net661 VGND VGND VPWR VPWR _00644_ sky130_fd_sc_hd__and3_1
XFILLER_4_428 VGND VGND VPWR VPWR sky130_fd_sc_hd__decap_8
XPHY_EDGE_ROW_41_Left_180 VGND VGND VPWR VPWR sky130_fd_sc_hd__decap_3
XFILLER_133_142 VGND VGND VPWR VPWR sky130_fd_sc_hd__fill_1
XFILLER_122_805 VGND VGND VPWR VPWR sky130_fd_sc_hd__decap_6
X_07119_ _02920_ _02942_ _02931_ VGND VGND VPWR VPWR _04634_ sky130_fd_sc_hd__o21bai_1
X_08099_ _00572_ _00573_ VGND VGND VPWR VPWR _00575_ sky130_fd_sc_hd__xnor2_1
X_10130_ _02708_ _02699_ VGND VGND VPWR VPWR _02709_ sky130_fd_sc_hd__nand2b_1
XFILLER_121_326 VGND VGND VPWR VPWR sky130_fd_sc_hd__decap_8
XFILLER_79_218 VGND VGND VPWR VPWR sky130_fd_sc_hd__fill_1
XFILLER_69_69 VPWR VGND VPWR VGND sky130_ef_sc_hd__decap_12
X_10061_ _02472_ _02486_ _02484_ VGND VGND VPWR VPWR _02634_ sky130_fd_sc_hd__o21bai_1
XFILLER_121_337 VPWR VGND VPWR VGND sky130_ef_sc_hd__decap_12
XFILLER_0_645 VPWR VGND VPWR VGND sky130_ef_sc_hd__decap_12
XFILLER_48_605 VGND VGND VPWR VPWR sky130_fd_sc_hd__fill_1
XTAP_TAPCELL_ROW_110_1890 VGND VPWR sky130_fd_sc_hd__tapvpwrvgnd_1
XFILLER_85_57 VPWR VGND VPWR VGND sky130_ef_sc_hd__decap_12
XFILLER_75_435 VGND VGND VPWR VPWR sky130_fd_sc_hd__fill_1
XFILLER_90_427 VPWR VGND VPWR VGND sky130_ef_sc_hd__decap_12
XFILLER_62_118 VPWR VGND VPWR VGND sky130_ef_sc_hd__decap_12
XTAP_TAPCELL_ROW_48_1000 VGND VPWR sky130_fd_sc_hd__tapvpwrvgnd_1
XFILLER_44_811 VGND VGND VPWR VPWR sky130_fd_sc_hd__fill_1
X_10963_ _03426_ _03614_ VGND VGND VPWR VPWR _03615_ sky130_fd_sc_hd__and2_1
X_12702_ _05508_ _05509_ VGND VGND VPWR VPWR _05510_ sky130_fd_sc_hd__nor2_1
XFILLER_71_652 VPWR VGND VPWR VGND sky130_ef_sc_hd__decap_12
XFILLER_71_685 VPWR VGND VPWR VGND sky130_ef_sc_hd__decap_12
X_13682_ clknet_3_0__leaf_clk _00017_ net715 VGND VGND VPWR VPWR net201 sky130_fd_sc_hd__dfrtp_1
X_10894_ _03391_ _03407_ _03406_ VGND VGND VPWR VPWR _03539_ sky130_fd_sc_hd__o21ai_1
X_12633_ _05433_ _05427_ VGND VGND VPWR VPWR _05434_ sky130_fd_sc_hd__and2b_1
X_12564_ _05357_ _05358_ VGND VGND VPWR VPWR _05359_ sky130_fd_sc_hd__and2b_1
XFILLER_8_701 VGND VGND VPWR VPWR sky130_fd_sc_hd__fill_1
XFILLER_12_752 VGND VGND VPWR VPWR sky130_fd_sc_hd__decap_4
XFILLER_34_83 VGND VGND VPWR VPWR sky130_fd_sc_hd__fill_1
XFILLER_79_9 VPWR VGND VPWR VGND sky130_ef_sc_hd__decap_12
X_11515_ _04212_ _04217_ VGND VGND VPWR VPWR _04218_ sky130_fd_sc_hd__nand2b_1
X_12495_ net420 net391 _05282_ VGND VGND VPWR VPWR _05283_ sky130_fd_sc_hd__and3_1
XTAP_TAPCELL_ROW_59_1151 VGND VPWR sky130_fd_sc_hd__tapvpwrvgnd_1
X_11446_ _03969_ _03996_ _03995_ VGND VGND VPWR VPWR _04143_ sky130_fd_sc_hd__a21oi_1
XFILLER_125_654 VGND VGND VPWR VPWR sky130_fd_sc_hd__fill_1
X_11377_ _03933_ _03946_ _03945_ VGND VGND VPWR VPWR _04067_ sky130_fd_sc_hd__o21a_1
XFILLER_124_153 VPWR VGND VPWR VGND sky130_ef_sc_hd__decap_12
X_13116_ _05796_ _05804_ _05803_ VGND VGND VPWR VPWR _05961_ sky130_fd_sc_hd__a21oi_1
X_10328_ _02913_ _02918_ VGND VGND VPWR VPWR _02921_ sky130_fd_sc_hd__xor2_1
XFILLER_124_197 VPWR VGND VPWR VGND sky130_ef_sc_hd__decap_12
X_13047_ _05884_ _05885_ VGND VGND VPWR VPWR _00027_ sky130_fd_sc_hd__nor2_1
XTAP_TAPCELL_ROW_72_1340 VGND VPWR sky130_fd_sc_hd__tapvpwrvgnd_1
XFILLER_79_774 VGND VGND VPWR VPWR sky130_fd_sc_hd__decap_8
X_10259_ net468 net279 _02843_ VGND VGND VPWR VPWR _02846_ sky130_fd_sc_hd__and3_1
XFILLER_39_649 VGND VGND VPWR VPWR sky130_fd_sc_hd__fill_1
XFILLER_93_265 VPWR VGND VPWR VGND sky130_ef_sc_hd__decap_12
XFILLER_81_405 VGND VGND VPWR VPWR sky130_fd_sc_hd__fill_2
XFILLER_66_468 VGND VGND VPWR VPWR sky130_fd_sc_hd__decap_8
XFILLER_38_148 VGND VGND VPWR VPWR sky130_fd_sc_hd__decap_8
XFILLER_81_427 VGND VGND VPWR VPWR sky130_fd_sc_hd__fill_2
XTAP_TAPCELL_ROW_37_839 VGND VPWR sky130_fd_sc_hd__tapvpwrvgnd_1
XFILLER_81_449 VGND VGND VPWR VPWR sky130_fd_sc_hd__decap_8
XFILLER_34_321 VGND VGND VPWR VPWR sky130_fd_sc_hd__fill_2
X_07470_ _06698_ _06699_ VGND VGND VPWR VPWR _06700_ sky130_fd_sc_hd__and2b_1
XTAP_TAPCELL_ROW_17_541 VGND VPWR sky130_fd_sc_hd__tapvpwrvgnd_1
XTAP_TAPCELL_ROW_17_552 VGND VPWR sky130_fd_sc_hd__tapvpwrvgnd_1
XFILLER_22_516 VGND VGND VPWR VPWR sky130_fd_sc_hd__fill_2
XFILLER_34_365 VPWR VGND VPWR VGND sky130_ef_sc_hd__decap_12
X_09140_ _01467_ _01629_ VGND VGND VPWR VPWR _01630_ sky130_fd_sc_hd__nor2_1
X_09071_ _01550_ _01554_ VGND VGND VPWR VPWR _01555_ sky130_fd_sc_hd__xnor2_1
XFILLER_30_571 VGND VGND VPWR VPWR sky130_fd_sc_hd__decap_6
X_08022_ _00471_ _00497_ VGND VGND VPWR VPWR _00499_ sky130_fd_sc_hd__xnor2_1
XFILLER_104_805 VGND VGND VPWR VPWR sky130_fd_sc_hd__decap_6
XFILLER_89_505 VGND VGND VPWR VPWR sky130_fd_sc_hd__decap_6
X_09973_ net330 net413 VGND VGND VPWR VPWR _02538_ sky130_fd_sc_hd__and2b_1
XFILLER_115_164 VGND VGND VPWR VPWR sky130_fd_sc_hd__decap_4
X_08924_ _01391_ _01392_ VGND VGND VPWR VPWR _01394_ sky130_fd_sc_hd__xor2_1
XFILLER_103_337 VGND VGND VPWR VPWR sky130_fd_sc_hd__decap_4
XFILLER_39_39 VPWR VGND VPWR VGND sky130_ef_sc_hd__decap_12
X_08855_ net646 net652 net372 net370 VGND VGND VPWR VPWR _01321_ sky130_fd_sc_hd__and4_1
XFILLER_97_593 VPWR VGND VPWR VGND sky130_ef_sc_hd__decap_12
X_08786_ _01094_ _01250_ VGND VGND VPWR VPWR _01252_ sky130_fd_sc_hd__or2_1
X_07806_ _00283_ _00284_ VGND VGND VPWR VPWR _00285_ sky130_fd_sc_hd__and2b_1
XPHY_EDGE_ROW_2_Right_2 VGND VGND VPWR VPWR sky130_fd_sc_hd__decap_3
XFILLER_85_799 VGND VGND VPWR VPWR sky130_fd_sc_hd__decap_4
XFILLER_84_287 VGND VGND VPWR VPWR sky130_fd_sc_hd__decap_8
XFILLER_84_265 VGND VGND VPWR VPWR sky130_fd_sc_hd__decap_8
X_07737_ _06798_ _06807_ _06806_ VGND VGND VPWR VPWR _00216_ sky130_fd_sc_hd__a21oi_1
XFILLER_53_641 VPWR VGND VPWR VGND sky130_ef_sc_hd__decap_12
XFILLER_37_192 VGND VGND VPWR VPWR sky130_fd_sc_hd__fill_2
XFILLER_41_803 VGND VGND VPWR VPWR sky130_fd_sc_hd__fill_1
X_07668_ _00145_ _00146_ VGND VGND VPWR VPWR _00147_ sky130_fd_sc_hd__nor2_1
X_09407_ net345 _01919_ VGND VGND VPWR VPWR _01921_ sky130_fd_sc_hd__nand2_1
X_07599_ net442 net665 _00076_ _00077_ VGND VGND VPWR VPWR _00079_ sky130_fd_sc_hd__nand4_1
X_09338_ _01843_ _01844_ _01743_ VGND VGND VPWR VPWR _01847_ sky130_fd_sc_hd__o21ai_1
XFILLER_40_379 VPWR VGND VPWR VGND sky130_ef_sc_hd__decap_12
X_09269_ _01764_ _01770_ VGND VGND VPWR VPWR _01771_ sky130_fd_sc_hd__and2_1
X_11300_ net618 net316 net314 net627 VGND VGND VPWR VPWR _03984_ sky130_fd_sc_hd__a22o_1
XFILLER_119_481 VGND VGND VPWR VPWR sky130_fd_sc_hd__fill_2
X_12280_ _05045_ _05047_ _04888_ _04891_ VGND VGND VPWR VPWR _05049_ sky130_fd_sc_hd__o211a_1
XFILLER_4_225 VPWR VGND VPWR VGND sky130_ef_sc_hd__decap_12
X_11231_ _03900_ _03906_ VGND VGND VPWR VPWR _03908_ sky130_fd_sc_hd__xor2_1
XFILLER_20_41 VPWR VGND VPWR VGND sky130_ef_sc_hd__decap_12
XFILLER_136_41 VPWR VGND VPWR VGND sky130_ef_sc_hd__decap_12
XFILLER_122_613 VPWR VGND VPWR VGND sky130_ef_sc_hd__decap_12
XFILLER_20_85 VGND VGND VPWR VPWR sky130_fd_sc_hd__fill_2
X_11162_ net609 net319 _03831_ _03832_ VGND VGND VPWR VPWR _03833_ sky130_fd_sc_hd__o2bb2a_1
XFILLER_136_85 VPWR VGND VPWR VGND sky130_ef_sc_hd__decap_12
XFILLER_122_657 VGND VGND VPWR VPWR sky130_fd_sc_hd__decap_6
X_10113_ _02515_ _02688_ VGND VGND VPWR VPWR _02690_ sky130_fd_sc_hd__xor2_1
XTAP_TAPCELL_ROW_112_1930 VGND VPWR sky130_fd_sc_hd__tapvpwrvgnd_1
XTAP_TAPCELL_ROW_54_1081 VGND VPWR sky130_fd_sc_hd__tapvpwrvgnd_1
X_11093_ _03738_ _03756_ VGND VGND VPWR VPWR _03757_ sky130_fd_sc_hd__xnor2_1
XTAP_TAPCELL_ROW_128_2159 VGND VPWR sky130_fd_sc_hd__tapvpwrvgnd_1
XTAP_TAPCELL_ROW_128_2148 VGND VPWR sky130_fd_sc_hd__tapvpwrvgnd_1
X_10044_ _02610_ _02614_ VGND VGND VPWR VPWR _02615_ sky130_fd_sc_hd__xnor2_1
XFILLER_75_254 VGND VGND VPWR VPWR sky130_fd_sc_hd__decap_3
XFILLER_48_446 VGND VGND VPWR VPWR sky130_fd_sc_hd__fill_2
XFILLER_90_202 VPWR VGND VPWR VGND sky130_ef_sc_hd__decap_12
XFILLER_35_129 VPWR VGND VPWR VGND sky130_ef_sc_hd__decap_12
X_11995_ _04736_ VGND VGND VPWR VPWR _04737_ sky130_fd_sc_hd__inv_2
XFILLER_90_279 VPWR VGND VPWR VGND sky130_ef_sc_hd__decap_12
X_10946_ net476 net295 net293 net485 VGND VGND VPWR VPWR _03596_ sky130_fd_sc_hd__a22o_1
X_13665_ clknet_3_5__leaf_clk _00059_ net719 VGND VGND VPWR VPWR net184 sky130_fd_sc_hd__dfrtp_1
XFILLER_45_93 VPWR VGND VPWR VGND sky130_ef_sc_hd__decap_12
XFILLER_43_195 VPWR VGND VPWR VGND sky130_ef_sc_hd__decap_12
X_10877_ _03520_ _03519_ VGND VGND VPWR VPWR _03521_ sky130_fd_sc_hd__and2b_1
XTAP_TAPCELL_ROW_14_500 VGND VPWR sky130_fd_sc_hd__tapvpwrvgnd_1
XFILLER_16_387 VGND VGND VPWR VPWR sky130_fd_sc_hd__decap_4
X_12616_ _05413_ _05414_ VGND VGND VPWR VPWR _05415_ sky130_fd_sc_hd__nand2b_1
X_13596_ _06405_ _06481_ VGND VGND VPWR VPWR _06484_ sky130_fd_sc_hd__nor2_1
XFILLER_8_531 VGND VGND VPWR VPWR sky130_fd_sc_hd__fill_1
XFILLER_129_245 VGND VGND VPWR VPWR sky130_fd_sc_hd__decap_8
X_12547_ net633 net6 net321 net639 VGND VGND VPWR VPWR _05340_ sky130_fd_sc_hd__a22o_1
X_12478_ _04955_ _04957_ _05101_ _05099_ _05090_ VGND VGND VPWR VPWR _05265_ sky130_fd_sc_hd__a32o_1
XANTENNA_3 _01376_ VGND VGND VPWR VPWR sky130_fd_sc_hd__diode_2
XFILLER_8_586 VGND VGND VPWR VPWR sky130_fd_sc_hd__fill_2
XFILLER_6_65 VPWR VGND VPWR VGND sky130_ef_sc_hd__decap_12
X_11429_ _04122_ _04124_ VGND VGND VPWR VPWR _04125_ sky130_fd_sc_hd__and2_1
XFILLER_125_473 VGND VGND VPWR VPWR sky130_fd_sc_hd__decap_6
XFILLER_4_781 VPWR VGND VPWR VGND sky130_ef_sc_hd__decap_12
X_06970_ net526 net682 VGND VGND VPWR VPWR _03008_ sky130_fd_sc_hd__nand2_1
XFILLER_39_402 VGND VGND VPWR VPWR sky130_fd_sc_hd__decap_8
XFILLER_100_329 VGND VGND VPWR VPWR sky130_fd_sc_hd__decap_3
XFILLER_79_582 VGND VGND VPWR VPWR sky130_fd_sc_hd__fill_1
X_08640_ _01100_ _01105_ VGND VGND VPWR VPWR _01107_ sky130_fd_sc_hd__xor2_1
XFILLER_67_777 VGND VGND VPWR VPWR sky130_fd_sc_hd__decap_6
XFILLER_39_446 VGND VGND VPWR VPWR sky130_fd_sc_hd__fill_2
XFILLER_39_479 VGND VGND VPWR VPWR sky130_fd_sc_hd__fill_1
X_08571_ net471 net336 _01037_ VGND VGND VPWR VPWR _01039_ sky130_fd_sc_hd__and3_1
XTAP_TAPCELL_ROW_85_1531 VGND VPWR sky130_fd_sc_hd__tapvpwrvgnd_1
XFILLER_19_181 VPWR VGND VPWR VGND sky130_ef_sc_hd__decap_12
XFILLER_23_803 VGND VGND VPWR VPWR sky130_fd_sc_hd__fill_1
X_07522_ _06748_ _06749_ VGND VGND VPWR VPWR _06751_ sky130_fd_sc_hd__xnor2_1
X_07453_ _06678_ _06681_ _06682_ VGND VGND VPWR VPWR _06683_ sky130_fd_sc_hd__and3_1
XFILLER_35_685 VGND VGND VPWR VPWR sky130_fd_sc_hd__decap_6
XFILLER_22_335 VGND VGND VPWR VPWR sky130_fd_sc_hd__fill_1
X_09123_ net472 net329 VGND VGND VPWR VPWR _01611_ sky130_fd_sc_hd__nand2_4
XFILLER_50_699 VGND VGND VPWR VPWR sky130_fd_sc_hd__fill_1
X_07384_ _04406_ _04428_ _05854_ _05843_ _05744_ VGND VGND VPWR VPWR _06614_ sky130_fd_sc_hd__a32o_1
XFILLER_136_705 VPWR VGND VPWR VGND sky130_ef_sc_hd__decap_12
X_09054_ net595 net354 _01534_ VGND VGND VPWR VPWR _01536_ sky130_fd_sc_hd__and3_1
X_08005_ net493 _00197_ VGND VGND VPWR VPWR _00482_ sky130_fd_sc_hd__nand2_2
XFILLER_116_462 VGND VGND VPWR VPWR sky130_fd_sc_hd__fill_1
XTAP_TAPCELL_ROW_96_1693 VGND VPWR sky130_fd_sc_hd__tapvpwrvgnd_1
XFILLER_89_302 VGND VGND VPWR VPWR sky130_fd_sc_hd__decap_8
XFILLER_104_657 VPWR VGND VPWR VGND sky130_ef_sc_hd__decap_12
X_09956_ _02509_ _02518_ VGND VGND VPWR VPWR _02519_ sky130_fd_sc_hd__xnor2_1
X_09887_ _02442_ _02443_ VGND VGND VPWR VPWR _02444_ sky130_fd_sc_hd__nor2_1
X_08907_ _01374_ _01373_ VGND VGND VPWR VPWR _01375_ sky130_fd_sc_hd__nand2b_1
XFILLER_106_77 VGND VGND VPWR VPWR sky130_fd_sc_hd__decap_6
X_08838_ net447 net340 _01146_ _01145_ VGND VGND VPWR VPWR _01304_ sky130_fd_sc_hd__a31o_1
XFILLER_73_703 VGND VGND VPWR VPWR sky130_fd_sc_hd__fill_1
XFILLER_58_777 VPWR VGND VPWR VGND sky130_ef_sc_hd__decap_12
XFILLER_57_276 VGND VGND VPWR VPWR sky130_fd_sc_hd__decap_4
XFILLER_122_65 VPWR VGND VPWR VGND sky130_ef_sc_hd__decap_12
X_08769_ _01228_ _01231_ _01230_ VGND VGND VPWR VPWR _01236_ sky130_fd_sc_hd__a21o_1
XFILLER_45_449 VGND VGND VPWR VPWR sky130_fd_sc_hd__decap_8
XTAP_TAPCELL_ROW_123_2089 VGND VPWR sky130_fd_sc_hd__tapvpwrvgnd_1
XTAP_TAPCELL_ROW_123_2078 VGND VPWR sky130_fd_sc_hd__tapvpwrvgnd_1
XFILLER_72_257 VGND VGND VPWR VPWR sky130_fd_sc_hd__fill_1
X_11780_ net249 _04382_ VGND VGND VPWR VPWR _04507_ sky130_fd_sc_hd__nor2_1
XFILLER_14_803 VGND VGND VPWR VPWR sky130_fd_sc_hd__decap_8
X_10800_ net443 net277 net93 net435 VGND VGND VPWR VPWR _03437_ sky130_fd_sc_hd__a22o_1
XFILLER_81_780 VGND VGND VPWR VPWR sky130_fd_sc_hd__decap_4
X_10731_ _03083_ _03221_ _03360_ VGND VGND VPWR VPWR _03361_ sky130_fd_sc_hd__or3_1
XTAP_TAPCELL_ROW_0_283 VGND VPWR sky130_fd_sc_hd__tapvpwrvgnd_1
XTAP_TAPCELL_ROW_0_294 VGND VPWR sky130_fd_sc_hd__tapvpwrvgnd_1
X_13450_ _06317_ _06324_ VGND VGND VPWR VPWR _06326_ sky130_fd_sc_hd__xnor2_1
X_12401_ net645 net321 net303 net653 VGND VGND VPWR VPWR _05181_ sky130_fd_sc_hd__a22oi_2
XFILLER_41_699 VPWR VGND VPWR VGND sky130_ef_sc_hd__decap_12
XFILLER_9_317 VGND VGND VPWR VPWR sky130_fd_sc_hd__decap_8
X_10662_ _03284_ _03285_ VGND VGND VPWR VPWR _03286_ sky130_fd_sc_hd__and2b_1
XFILLER_40_176 VGND VGND VPWR VPWR sky130_fd_sc_hd__decap_6
X_13381_ net487 net478 net395 VGND VGND VPWR VPWR _06251_ sky130_fd_sc_hd__and3_1
X_10593_ net561 net553 net310 net309 VGND VGND VPWR VPWR _03210_ sky130_fd_sc_hd__and4_1
X_12332_ _05104_ _05102_ VGND VGND VPWR VPWR _05105_ sky130_fd_sc_hd__and2b_1
XFILLER_5_501 VGND VGND VPWR VPWR sky130_fd_sc_hd__decap_3
XFILLER_31_51 VGND VGND VPWR VPWR sky130_fd_sc_hd__decap_4
XFILLER_126_248 VGND VGND VPWR VPWR sky130_fd_sc_hd__fill_1
X_12263_ _04852_ _04854_ _04853_ VGND VGND VPWR VPWR _05030_ sky130_fd_sc_hd__a21bo_1
XTAP_TAPCELL_ROW_56_1110 VGND VPWR sky130_fd_sc_hd__tapvpwrvgnd_1
XFILLER_5_578 VPWR VGND VPWR VGND sky130_ef_sc_hd__decap_12
X_11214_ _03887_ _03888_ VGND VGND VPWR VPWR _03889_ sky130_fd_sc_hd__xnor2_1
XFILLER_134_281 VGND VGND VPWR VPWR sky130_fd_sc_hd__fill_1
X_12194_ net573 net660 VGND VGND VPWR VPWR _04954_ sky130_fd_sc_hd__nand2_1
XFILLER_122_454 VGND VGND VPWR VPWR sky130_fd_sc_hd__decap_3
X_11145_ _03811_ _03812_ VGND VGND VPWR VPWR _03814_ sky130_fd_sc_hd__xnor2_1
X_11076_ _03548_ _03737_ VGND VGND VPWR VPWR _03738_ sky130_fd_sc_hd__xnor2_1
Xinput140 x1[2] VGND VGND VPWR VPWR net140 sky130_fd_sc_hd__clkbuf_1
X_10027_ _02262_ _02514_ _02122_ VGND VGND VPWR VPWR _02596_ sky130_fd_sc_hd__a21oi_2
XFILLER_95_349 VPWR VGND VPWR VGND sky130_ef_sc_hd__decap_12
Xinput151 x2[5] VGND VGND VPWR VPWR net151 sky130_fd_sc_hd__clkbuf_1
XFILLER_91_500 VGND VGND VPWR VPWR sky130_fd_sc_hd__decap_4
XFILLER_64_736 VGND VGND VPWR VPWR sky130_fd_sc_hd__fill_1
XFILLER_56_92 VPWR VGND VPWR VGND sky130_ef_sc_hd__decap_12
XFILLER_17_630 VGND VGND VPWR VPWR sky130_fd_sc_hd__decap_6
X_11978_ _04716_ _04717_ VGND VGND VPWR VPWR _04719_ sky130_fd_sc_hd__nor2_1
XFILLER_63_257 VPWR VGND VPWR VGND sky130_ef_sc_hd__decap_12
XTAP_TAPCELL_ROW_47_978 VGND VPWR sky130_fd_sc_hd__tapvpwrvgnd_1
XTAP_TAPCELL_ROW_67_1272 VGND VPWR sky130_fd_sc_hd__tapvpwrvgnd_1
X_10929_ _03569_ _03574_ VGND VGND VPWR VPWR _03578_ sky130_fd_sc_hd__xor2_1
XFILLER_32_622 VGND VGND VPWR VPWR sky130_fd_sc_hd__fill_1
XTAP_TAPCELL_ROW_27_691 VGND VPWR sky130_fd_sc_hd__tapvpwrvgnd_1
X_13648_ clknet_3_5__leaf_clk _00031_ net719 VGND VGND VPWR VPWR net167 sky130_fd_sc_hd__dfrtp_1
XTAP_TAPCELL_ROW_80_1461 VGND VPWR sky130_fd_sc_hd__tapvpwrvgnd_1
XFILLER_32_699 VGND VGND VPWR VPWR sky130_fd_sc_hd__fill_1
X_13579_ _06466_ _06464_ VGND VGND VPWR VPWR _06467_ sky130_fd_sc_hd__nand2b_1
XFILLER_31_198 VGND VGND VPWR VPWR sky130_fd_sc_hd__fill_2
XFILLER_118_738 VPWR VGND VPWR VGND sky130_ef_sc_hd__decap_12
XFILLER_126_793 VPWR VGND VPWR VGND sky130_ef_sc_hd__decap_12
XPHY_EDGE_ROW_99_Right_99 VGND VGND VPWR VPWR sky130_fd_sc_hd__decap_3
X_09810_ _02258_ _02270_ _02269_ VGND VGND VPWR VPWR _02361_ sky130_fd_sc_hd__a21oi_1
XFILLER_113_465 VGND VGND VPWR VPWR sky130_fd_sc_hd__fill_2
Xfanout329 net65 VGND VGND VPWR VPWR net329 sky130_fd_sc_hd__clkbuf_4
Xfanout307 net78 VGND VGND VPWR VPWR net307 sky130_fd_sc_hd__clkbuf_2
Xfanout318 net71 VGND VGND VPWR VPWR net318 sky130_fd_sc_hd__clkbuf_2
X_09741_ net372 net601 VGND VGND VPWR VPWR _02286_ sky130_fd_sc_hd__nand2b_1
XFILLER_86_316 VPWR VGND VPWR VGND sky130_ef_sc_hd__decap_12
X_06953_ _02802_ _02812_ VGND VGND VPWR VPWR _02823_ sky130_fd_sc_hd__nor2_1
X_09672_ net250 _02208_ VGND VGND VPWR VPWR _02210_ sky130_fd_sc_hd__xnor2_1
X_06884_ _02052_ _02063_ VGND VGND VPWR VPWR _02074_ sky130_fd_sc_hd__or2_1
XFILLER_27_405 VGND VGND VPWR VPWR sky130_fd_sc_hd__fill_1
X_08623_ _01088_ _01089_ VGND VGND VPWR VPWR _01090_ sky130_fd_sc_hd__nand2_1
XPHY_EDGE_ROW_6_Left_145 VGND VGND VPWR VPWR sky130_fd_sc_hd__decap_3
XFILLER_36_29 VPWR VGND VPWR VGND sky130_ef_sc_hd__decap_12
XFILLER_39_287 VPWR VGND VPWR VGND sky130_ef_sc_hd__decap_12
X_08554_ _01001_ _01021_ VGND VGND VPWR VPWR _01023_ sky130_fd_sc_hd__nand2b_1
XFILLER_54_279 VGND VGND VPWR VPWR sky130_fd_sc_hd__fill_2
X_07505_ _06601_ _06616_ _06615_ VGND VGND VPWR VPWR _06734_ sky130_fd_sc_hd__o21ai_1
XFILLER_22_110 VPWR VGND VPWR VGND sky130_ef_sc_hd__decap_12
X_08485_ _00955_ _00956_ VGND VGND VPWR VPWR _00958_ sky130_fd_sc_hd__xnor2_1
X_07436_ net267 net710 net612 net605 VGND VGND VPWR VPWR _06666_ sky130_fd_sc_hd__nand4_1
XTAP_TAPCELL_ROW_98_1722 VGND VPWR sky130_fd_sc_hd__tapvpwrvgnd_1
X_07367_ _06587_ _06595_ VGND VGND VPWR VPWR _06597_ sky130_fd_sc_hd__xnor2_1
X_09106_ net431 net336 _01590_ _01591_ VGND VGND VPWR VPWR _01592_ sky130_fd_sc_hd__a22o_1
XFILLER_109_749 VPWR VGND VPWR VGND sky130_ef_sc_hd__decap_12
XFILLER_6_309 VGND VGND VPWR VPWR sky130_fd_sc_hd__decap_6
X_09037_ _01251_ _01380_ _01516_ VGND VGND VPWR VPWR _01517_ sky130_fd_sc_hd__or3_1
X_07298_ _06524_ _06527_ VGND VGND VPWR VPWR _06529_ sky130_fd_sc_hd__xnor2_1
XFILLER_136_579 VGND VGND VPWR VPWR sky130_fd_sc_hd__decap_8
XFILLER_117_760 VGND VGND VPWR VPWR sky130_fd_sc_hd__decap_6
XFILLER_77_25 VPWR VGND VPWR VGND sky130_ef_sc_hd__decap_12
XTAP_TAPCELL_ROW_125_2107 VGND VPWR sky130_fd_sc_hd__tapvpwrvgnd_1
X_09939_ _01610_ _02500_ VGND VGND VPWR VPWR _02501_ sky130_fd_sc_hd__and2_1
XFILLER_93_809 VPWR VGND VPWR VGND sky130_ef_sc_hd__decap_12
XFILLER_77_349 VGND VGND VPWR VPWR sky130_fd_sc_hd__decap_3
XTAP_TAPCELL_ROW_51_1040 VGND VPWR sky130_fd_sc_hd__tapvpwrvgnd_1
XTAP_TAPCELL_ROW_125_2118 VGND VPWR sky130_fd_sc_hd__tapvpwrvgnd_1
X_12950_ _05660_ _05676_ _05675_ VGND VGND VPWR VPWR _05780_ sky130_fd_sc_hd__a21oi_1
XTAP_TAPCELL_ROW_5_375 VGND VPWR sky130_fd_sc_hd__tapvpwrvgnd_1
XFILLER_93_57 VPWR VGND VPWR VGND sky130_ef_sc_hd__decap_12
XFILLER_85_393 VPWR VGND VPWR VGND sky130_ef_sc_hd__decap_12
X_12881_ _05688_ _05704_ VGND VGND VPWR VPWR _05705_ sky130_fd_sc_hd__xnor2_1
XFILLER_18_438 VPWR VGND VPWR VGND sky130_ef_sc_hd__decap_12
X_11901_ _03964_ _04105_ _04368_ _04637_ VGND VGND VPWR VPWR _04638_ sky130_fd_sc_hd__a31o_1
XTAP_TAPCELL_ROW_107_1851 VGND VPWR sky130_fd_sc_hd__tapvpwrvgnd_1
XFILLER_73_566 VGND VGND VPWR VPWR sky130_fd_sc_hd__decap_4
X_11832_ _04470_ _04473_ _04476_ VGND VGND VPWR VPWR _04563_ sky130_fd_sc_hd__o21ai_1
XFILLER_73_588 VGND VGND VPWR VPWR sky130_fd_sc_hd__decap_8
XFILLER_45_279 VGND VGND VPWR VPWR sky130_fd_sc_hd__fill_1
XTAP_TAPCELL_ROW_44_937 VGND VPWR sky130_fd_sc_hd__tapvpwrvgnd_1
XFILLER_13_110 VGND VGND VPWR VPWR sky130_fd_sc_hd__fill_2
X_11763_ _04486_ _04487_ VGND VGND VPWR VPWR _04488_ sky130_fd_sc_hd__or2_1
X_13502_ _06368_ _06381_ _06382_ VGND VGND VPWR VPWR _06383_ sky130_fd_sc_hd__or3_1
X_11694_ _04410_ _04411_ VGND VGND VPWR VPWR _04413_ sky130_fd_sc_hd__xor2_1
X_10714_ _03340_ _03341_ _03184_ _03186_ VGND VGND VPWR VPWR _03343_ sky130_fd_sc_hd__a211oi_2
XTAP_TAPCELL_ROW_24_650 VGND VPWR sky130_fd_sc_hd__tapvpwrvgnd_1
X_13433_ _05315_ _06305_ _06220_ VGND VGND VPWR VPWR _06307_ sky130_fd_sc_hd__o21a_1
XTAP_TAPCELL_ROW_62_1191 VGND VPWR sky130_fd_sc_hd__tapvpwrvgnd_1
X_10645_ net528 net288 _03121_ VGND VGND VPWR VPWR _03267_ sky130_fd_sc_hd__nand3_2
XTAP_TAPCELL_ROW_136_2269 VGND VPWR sky130_fd_sc_hd__tapvpwrvgnd_1
X_13364_ _06231_ _06230_ VGND VGND VPWR VPWR _06232_ sky130_fd_sc_hd__nand2b_1
XFILLER_42_83 VGND VGND VPWR VPWR sky130_fd_sc_hd__fill_1
XFILLER_6_821 VGND VGND VPWR VPWR sky130_fd_sc_hd__decap_3
XFILLER_127_557 VGND VGND VPWR VPWR sky130_fd_sc_hd__decap_3
X_12315_ _04948_ _05085_ VGND VGND VPWR VPWR _05086_ sky130_fd_sc_hd__nor2_1
X_10576_ _03104_ _03105_ _03189_ _03191_ VGND VGND VPWR VPWR _03192_ sky130_fd_sc_hd__nor4_1
X_13295_ _06155_ _06156_ VGND VGND VPWR VPWR _06157_ sky130_fd_sc_hd__or2_1
XFILLER_114_229 VGND VGND VPWR VPWR sky130_fd_sc_hd__fill_1
XFILLER_108_793 VPWR VGND VPWR VGND sky130_ef_sc_hd__decap_12
X_12246_ _05000_ _05010_ VGND VGND VPWR VPWR _05011_ sky130_fd_sc_hd__xnor2_1
XFILLER_5_375 VPWR VGND VPWR VGND sky130_ef_sc_hd__decap_12
X_12177_ _04749_ _04933_ _04935_ VGND VGND VPWR VPWR _04936_ sky130_fd_sc_hd__and3_1
XFILLER_123_785 VPWR VGND VPWR VGND sky130_ef_sc_hd__decap_12
XFILLER_122_262 VPWR VGND VPWR VGND sky130_ef_sc_hd__decap_12
XFILLER_95_113 VPWR VGND VPWR VGND sky130_ef_sc_hd__decap_12
XFILLER_95_102 VGND VGND VPWR VPWR sky130_fd_sc_hd__decap_8
XFILLER_3_55 VGND VGND VPWR VPWR sky130_fd_sc_hd__fill_1
X_11128_ _03791_ _03792_ VGND VGND VPWR VPWR _03796_ sky130_fd_sc_hd__xnor2_1
XFILLER_68_349 VPWR VGND VPWR VGND sky130_ef_sc_hd__decap_12
XTAP_TAPCELL_ROW_69_1301 VGND VPWR sky130_fd_sc_hd__tapvpwrvgnd_1
XFILLER_49_574 VGND VGND VPWR VPWR sky130_fd_sc_hd__fill_2
X_11059_ _03593_ _03628_ _03627_ VGND VGND VPWR VPWR _03720_ sky130_fd_sc_hd__a21o_1
XFILLER_64_533 VGND VGND VPWR VPWR sky130_fd_sc_hd__decap_4
XFILLER_52_717 VGND VGND VPWR VPWR sky130_fd_sc_hd__fill_2
XFILLER_51_216 VGND VGND VPWR VPWR sky130_fd_sc_hd__fill_2
XFILLER_24_419 VGND VGND VPWR VPWR sky130_fd_sc_hd__fill_1
XFILLER_36_279 VGND VGND VPWR VPWR sky130_fd_sc_hd__fill_1
XFILLER_60_772 VGND VGND VPWR VPWR sky130_fd_sc_hd__decap_8
X_08270_ _00634_ _00636_ _00743_ VGND VGND VPWR VPWR _00745_ sky130_fd_sc_hd__and3_1
X_07221_ net114 net485 _04656_ _04645_ VGND VGND VPWR VPWR _05744_ sky130_fd_sc_hd__a31o_1
X_07152_ net467 net666 _03358_ VGND VGND VPWR VPWR _04991_ sky130_fd_sc_hd__and3_1
XFILLER_20_669 VGND VGND VPWR VPWR sky130_fd_sc_hd__decap_4
XFILLER_118_557 VGND VGND VPWR VPWR sky130_fd_sc_hd__decap_6
XFILLER_133_505 VGND VGND VPWR VPWR sky130_fd_sc_hd__fill_2
X_07083_ _04177_ _04232_ VGND VGND VPWR VPWR _00048_ sky130_fd_sc_hd__xor2_1
XFILLER_105_218 VGND VGND VPWR VPWR sky130_fd_sc_hd__fill_1
XTAP_TAPCELL_ROW_93_1652 VGND VPWR sky130_fd_sc_hd__tapvpwrvgnd_1
XTAP_TAPCELL_ROW_93_1641 VGND VPWR sky130_fd_sc_hd__tapvpwrvgnd_1
XFILLER_114_741 VGND VGND VPWR VPWR sky130_fd_sc_hd__decap_4
XFILLER_113_273 VGND VGND VPWR VPWR sky130_fd_sc_hd__decap_6
XFILLER_101_402 VPWR VGND VPWR VGND sky130_ef_sc_hd__decap_12
XFILLER_99_474 VGND VGND VPWR VPWR sky130_fd_sc_hd__decap_4
XFILLER_59_316 VGND VGND VPWR VPWR sky130_fd_sc_hd__decap_6
XFILLER_87_647 VPWR VGND VPWR VGND sky130_ef_sc_hd__decap_12
XFILLER_59_349 VGND VGND VPWR VPWR sky130_fd_sc_hd__decap_3
X_07985_ _00460_ _00461_ VGND VGND VPWR VPWR _00462_ sky130_fd_sc_hd__or2_1
X_09724_ _02265_ _02266_ VGND VGND VPWR VPWR _02267_ sky130_fd_sc_hd__nor2_1
XFILLER_101_468 VPWR VGND VPWR VGND sky130_ef_sc_hd__decap_12
XFILLER_47_39 VPWR VGND VPWR VGND sky130_ef_sc_hd__decap_12
XTAP_TAPCELL_ROW_2_323 VGND VPWR sky130_fd_sc_hd__tapvpwrvgnd_1
X_06936_ net581 net699 net697 net590 VGND VGND VPWR VPWR _02641_ sky130_fd_sc_hd__a22o_1
X_09655_ net549 net357 _02036_ _02035_ VGND VGND VPWR VPWR _02191_ sky130_fd_sc_hd__a31o_1
XFILLER_95_680 VGND VGND VPWR VPWR sky130_fd_sc_hd__decap_6
XFILLER_67_393 VGND VGND VPWR VPWR sky130_fd_sc_hd__fill_2
X_06867_ _01867_ _01878_ VGND VGND VPWR VPWR _01889_ sky130_fd_sc_hd__nand2_1
XFILLER_55_544 VGND VGND VPWR VPWR sky130_fd_sc_hd__decap_6
XTAP_TAPCELL_ROW_2_334 VGND VPWR sky130_fd_sc_hd__tapvpwrvgnd_1
X_08606_ _01072_ _01073_ VGND VGND VPWR VPWR _01074_ sky130_fd_sc_hd__and2b_1
XFILLER_28_769 VPWR VGND VPWR VGND sky130_ef_sc_hd__decap_12
XTAP_TAPCELL_ROW_120_2037 VGND VPWR sky130_fd_sc_hd__tapvpwrvgnd_1
X_09586_ _01960_ _01962_ _01789_ VGND VGND VPWR VPWR _02116_ sky130_fd_sc_hd__o21a_1
XFILLER_63_27 VPWR VGND VPWR VGND sky130_ef_sc_hd__decap_12
XFILLER_27_279 VGND VGND VPWR VPWR sky130_fd_sc_hd__fill_1
X_08537_ net657 net646 net378 net375 VGND VGND VPWR VPWR _01006_ sky130_fd_sc_hd__and4_1
XFILLER_23_441 VGND VGND VPWR VPWR sky130_fd_sc_hd__fill_2
X_08468_ _00842_ _00844_ _00939_ VGND VGND VPWR VPWR _00941_ sky130_fd_sc_hd__nor3_1
XFILLER_23_463 VGND VGND VPWR VPWR sky130_fd_sc_hd__fill_1
XTAP_TAPCELL_ROW_102_1781 VGND VPWR sky130_fd_sc_hd__tapvpwrvgnd_1
X_07419_ _04697_ _06192_ _06171_ VGND VGND VPWR VPWR _06649_ sky130_fd_sc_hd__a21o_1
XFILLER_23_485 VPWR VGND VPWR VGND sky130_ef_sc_hd__decap_12
X_08399_ _00859_ _00871_ _00872_ VGND VGND VPWR VPWR _00873_ sky130_fd_sc_hd__or3_1
XFILLER_6_117 VGND VGND VPWR VPWR sky130_fd_sc_hd__decap_8
X_10430_ _03020_ _03028_ _02846_ VGND VGND VPWR VPWR _03033_ sky130_fd_sc_hd__a21o_1
XFILLER_136_321 VGND VGND VPWR VPWR sky130_fd_sc_hd__decap_4
XFILLER_10_179 VGND VGND VPWR VPWR sky130_fd_sc_hd__fill_2
XFILLER_12_53 VPWR VGND VPWR VGND sky130_ef_sc_hd__decap_12
XFILLER_128_53 VPWR VGND VPWR VGND sky130_ef_sc_hd__decap_12
X_10361_ net296 _02819_ _02895_ _02900_ VGND VGND VPWR VPWR _02957_ sky130_fd_sc_hd__o31ai_1
XFILLER_128_97 VPWR VGND VPWR VGND sky130_ef_sc_hd__decap_12
X_13080_ _05921_ _05912_ VGND VGND VPWR VPWR _05922_ sky130_fd_sc_hd__nand2b_1
X_12100_ net640 net369 VGND VGND VPWR VPWR _04852_ sky130_fd_sc_hd__and2_1
X_10292_ _02880_ _02881_ VGND VGND VPWR VPWR _02882_ sky130_fd_sc_hd__or2_1
XTAP_TAPCELL_ROW_131_2199 VGND VPWR sky130_fd_sc_hd__tapvpwrvgnd_1
XFILLER_105_741 VPWR VGND VPWR VGND sky130_ef_sc_hd__decap_12
X_12031_ net594 net577 net659 net584 VGND VGND VPWR VPWR _04776_ sky130_fd_sc_hd__a22oi_1
XFILLER_5_3 VPWR VGND VPWR VGND sky130_ef_sc_hd__decap_12
XFILLER_105_785 VPWR VGND VPWR VGND sky130_ef_sc_hd__decap_12
XFILLER_78_625 VGND VGND VPWR VPWR sky130_fd_sc_hd__decap_3
XFILLER_77_113 VPWR VGND VPWR VGND sky130_ef_sc_hd__decap_12
Xfanout660 net13 VGND VGND VPWR VPWR net660 sky130_fd_sc_hd__clkbuf_2
XFILLER_93_617 VGND VGND VPWR VPWR sky130_fd_sc_hd__decap_3
XFILLER_77_157 VGND VGND VPWR VPWR sky130_fd_sc_hd__decap_8
XPHY_EDGE_ROW_69_Left_208 VGND VGND VPWR VPWR sky130_fd_sc_hd__decap_3
Xfanout671 net124 VGND VGND VPWR VPWR net671 sky130_fd_sc_hd__buf_2
Xfanout682 net118 VGND VGND VPWR VPWR net682 sky130_fd_sc_hd__clkbuf_4
Xfanout693 net110 VGND VGND VPWR VPWR net693 sky130_fd_sc_hd__buf_2
X_12933_ _05429_ _05432_ VGND VGND VPWR VPWR _05761_ sky130_fd_sc_hd__nor2_1
XFILLER_92_149 VPWR VGND VPWR VGND sky130_ef_sc_hd__decap_12
XFILLER_46_533 VGND VGND VPWR VPWR sky130_fd_sc_hd__decap_8
XTAP_TAPCELL_ROW_29_720 VGND VPWR sky130_fd_sc_hd__tapvpwrvgnd_1
XFILLER_61_503 VGND VGND VPWR VPWR sky130_fd_sc_hd__fill_1
XFILLER_46_577 VGND VGND VPWR VPWR sky130_fd_sc_hd__decap_4
XFILLER_18_235 VPWR VGND VPWR VGND sky130_ef_sc_hd__decap_12
XFILLER_34_717 VGND VGND VPWR VPWR sky130_fd_sc_hd__fill_1
X_12864_ _05680_ _05685_ VGND VGND VPWR VPWR _05686_ sky130_fd_sc_hd__and2_1
X_12795_ _05425_ _05441_ _05440_ VGND VGND VPWR VPWR _05610_ sky130_fd_sc_hd__o21ai_1
XTAP_TAPCELL_ROW_64_1231 VGND VPWR sky130_fd_sc_hd__tapvpwrvgnd_1
XTAP_TAPCELL_ROW_64_1220 VGND VPWR sky130_fd_sc_hd__tapvpwrvgnd_1
X_11815_ _04543_ _04544_ VGND VGND VPWR VPWR _00017_ sky130_fd_sc_hd__nor2_1
XTAP_TAPCELL_ROW_138_2309 VGND VPWR sky130_fd_sc_hd__tapvpwrvgnd_1
XFILLER_14_452 VGND VGND VPWR VPWR sky130_fd_sc_hd__decap_6
XFILLER_14_474 VGND VGND VPWR VPWR sky130_fd_sc_hd__fill_2
X_11746_ net256 net270 _03427_ VGND VGND VPWR VPWR _04469_ sky130_fd_sc_hd__o21a_1
XPHY_EDGE_ROW_78_Left_217 VGND VGND VPWR VPWR sky130_fd_sc_hd__decap_3
XFILLER_41_293 VGND VGND VPWR VPWR sky130_fd_sc_hd__decap_8
XFILLER_14_496 VGND VGND VPWR VPWR sky130_fd_sc_hd__decap_3
XFILLER_128_811 VGND VGND VPWR VPWR sky130_fd_sc_hd__fill_1
X_11677_ _04392_ _04393_ VGND VGND VPWR VPWR _04394_ sky130_fd_sc_hd__nor2_1
X_13416_ _06033_ _06154_ _06153_ VGND VGND VPWR VPWR _06289_ sky130_fd_sc_hd__a21oi_1
X_10628_ _03123_ _03124_ _03127_ VGND VGND VPWR VPWR _03249_ sky130_fd_sc_hd__a21oi_1
XFILLER_127_365 VPWR VGND VPWR VGND sky130_ef_sc_hd__decap_12
XFILLER_115_516 VGND VGND VPWR VPWR sky130_fd_sc_hd__decap_6
X_13347_ _06179_ _06211_ VGND VGND VPWR VPWR _06213_ sky130_fd_sc_hd__xnor2_1
XFILLER_6_662 VPWR VGND VPWR VGND sky130_ef_sc_hd__decap_12
X_10559_ _03169_ _03170_ _03171_ VGND VGND VPWR VPWR _03174_ sky130_fd_sc_hd__nand3_1
X_13278_ _06125_ _06137_ VGND VGND VPWR VPWR _06139_ sky130_fd_sc_hd__and2_1
XFILLER_130_508 VGND VGND VPWR VPWR sky130_fd_sc_hd__decap_3
X_12229_ _04983_ _04990_ VGND VGND VPWR VPWR _04993_ sky130_fd_sc_hd__xnor2_1
XFILLER_111_700 VPWR VGND VPWR VGND sky130_ef_sc_hd__decap_12
XPHY_EDGE_ROW_87_Left_226 VGND VGND VPWR VPWR sky130_fd_sc_hd__decap_3
XTAP_TAPCELL_ROW_75_1393 VGND VPWR sky130_fd_sc_hd__tapvpwrvgnd_1
XTAP_TAPCELL_ROW_75_1382 VGND VPWR sky130_fd_sc_hd__tapvpwrvgnd_1
XFILLER_68_102 VGND VGND VPWR VPWR sky130_fd_sc_hd__decap_3
XFILLER_38_3 VPWR VGND VPWR VGND sky130_ef_sc_hd__decap_12
XFILLER_110_210 VPWR VGND VPWR VGND sky130_ef_sc_hd__decap_12
XFILLER_111_777 VGND VGND VPWR VPWR sky130_fd_sc_hd__decap_6
XFILLER_96_477 VGND VGND VPWR VPWR sky130_fd_sc_hd__decap_4
XFILLER_68_168 VGND VGND VPWR VPWR sky130_fd_sc_hd__fill_2
X_07770_ _06658_ _00247_ VGND VGND VPWR VPWR _00249_ sky130_fd_sc_hd__xnor2_1
X_09440_ net418 net335 VGND VGND VPWR VPWR _01957_ sky130_fd_sc_hd__nand2_1
XFILLER_64_385 VGND VGND VPWR VPWR sky130_fd_sc_hd__fill_2
XFILLER_24_227 VGND VGND VPWR VPWR sky130_fd_sc_hd__decap_8
XFILLER_37_599 VPWR VGND VPWR VGND sky130_ef_sc_hd__decap_12
X_09371_ _01880_ _01881_ VGND VGND VPWR VPWR _01882_ sky130_fd_sc_hd__nor2_1
XFILLER_52_569 VPWR VGND VPWR VGND sky130_ef_sc_hd__decap_12
XFILLER_24_249 VGND VGND VPWR VPWR sky130_fd_sc_hd__decap_3
XPHY_EDGE_ROW_96_Left_235 VGND VGND VPWR VPWR sky130_fd_sc_hd__decap_3
XFILLER_33_783 VGND VGND VPWR VPWR sky130_fd_sc_hd__fill_1
X_08322_ _00795_ _00796_ VGND VGND VPWR VPWR _00044_ sky130_fd_sc_hd__xnor2_1
X_08253_ net705 net603 net598 net704 VGND VGND VPWR VPWR _00728_ sky130_fd_sc_hd__and4b_1
XFILLER_32_282 VPWR VGND VPWR VGND sky130_ef_sc_hd__decap_12
X_07204_ _04329_ _04340_ _04482_ _04460_ _02782_ VGND VGND VPWR VPWR _05559_ sky130_fd_sc_hd__a32o_1
XFILLER_118_321 VPWR VGND VPWR VGND sky130_ef_sc_hd__decap_12
X_08184_ _00620_ _00659_ VGND VGND VPWR VPWR _00660_ sky130_fd_sc_hd__xnor2_2
XFILLER_20_477 VPWR VGND VPWR VGND sky130_ef_sc_hd__decap_12
XFILLER_118_365 VGND VGND VPWR VPWR sky130_fd_sc_hd__decap_4
X_07135_ _04558_ _04783_ VGND VGND VPWR VPWR _04805_ sky130_fd_sc_hd__and2b_1
XFILLER_118_376 VGND VGND VPWR VPWR sky130_fd_sc_hd__fill_2
X_07066_ _03981_ _04035_ _04046_ VGND VGND VPWR VPWR _04057_ sky130_fd_sc_hd__and3_1
XTAP_TAPCELL_ROW_7_404 VGND VPWR sky130_fd_sc_hd__tapvpwrvgnd_1
XFILLER_121_519 VGND VGND VPWR VPWR sky130_fd_sc_hd__decap_8
XFILLER_87_411 VGND VGND VPWR VPWR sky130_fd_sc_hd__fill_1
XFILLER_58_27 VGND VGND VPWR VPWR sky130_fd_sc_hd__fill_1
XFILLER_114_593 VGND VGND VPWR VPWR sky130_fd_sc_hd__fill_1
XFILLER_87_444 VGND VGND VPWR VPWR sky130_fd_sc_hd__decap_4
XFILLER_59_113 VPWR VGND VPWR VGND sky130_ef_sc_hd__decap_12
XFILLER_75_617 VGND VGND VPWR VPWR sky130_fd_sc_hd__fill_2
X_07968_ _00443_ _00444_ VGND VGND VPWR VPWR _00445_ sky130_fd_sc_hd__nor2_1
X_09707_ _02240_ _02247_ VGND VGND VPWR VPWR _02248_ sky130_fd_sc_hd__xnor2_1
X_06919_ _02434_ _02445_ VGND VGND VPWR VPWR _02456_ sky130_fd_sc_hd__or2_1
XFILLER_28_511 VGND VGND VPWR VPWR sky130_fd_sc_hd__decap_8
XFILLER_114_77 VGND VGND VPWR VPWR sky130_fd_sc_hd__decap_6
XFILLER_74_26 VGND VGND VPWR VPWR sky130_fd_sc_hd__fill_2
X_07899_ _00372_ _00374_ _00375_ VGND VGND VPWR VPWR _00377_ sky130_fd_sc_hd__and3_2
XFILLER_55_341 VGND VGND VPWR VPWR sky130_fd_sc_hd__fill_1
XFILLER_28_544 VGND VGND VPWR VPWR sky130_fd_sc_hd__decap_4
XFILLER_28_555 VPWR VGND VPWR VGND sky130_ef_sc_hd__decap_12
X_09638_ _01688_ _02019_ _02018_ VGND VGND VPWR VPWR _02174_ sky130_fd_sc_hd__a21oi_1
XTAP_TAPCELL_ROW_104_1810 VGND VPWR sky130_fd_sc_hd__tapvpwrvgnd_1
XFILLER_43_525 VGND VGND VPWR VPWR sky130_fd_sc_hd__decap_8
X_09569_ _02091_ _02095_ VGND VGND VPWR VPWR _02098_ sky130_fd_sc_hd__xor2_1
XFILLER_70_344 VGND VGND VPWR VPWR sky130_fd_sc_hd__decap_6
XFILLER_70_322 VPWR VGND VPWR VGND sky130_ef_sc_hd__decap_12
XFILLER_15_249 VGND VGND VPWR VPWR sky130_fd_sc_hd__decap_8
XFILLER_31_709 VPWR VGND VPWR VGND sky130_ef_sc_hd__decap_12
XFILLER_130_65 VPWR VGND VPWR VGND sky130_ef_sc_hd__decap_12
X_12580_ _05373_ _05375_ VGND VGND VPWR VPWR _05377_ sky130_fd_sc_hd__xor2_1
X_11600_ _04187_ _04203_ _04202_ VGND VGND VPWR VPWR _04310_ sky130_fd_sc_hd__o21ai_1
XFILLER_24_750 VGND VGND VPWR VPWR sky130_fd_sc_hd__decap_6
X_11531_ _04235_ _04211_ VGND VGND VPWR VPWR _04236_ sky130_fd_sc_hd__and2b_1
X_11462_ _04012_ _04015_ _04160_ VGND VGND VPWR VPWR _04161_ sky130_fd_sc_hd__or3_2
XTAP_TAPCELL_ROW_133_2228 VGND VPWR sky130_fd_sc_hd__tapvpwrvgnd_1
X_13201_ _05936_ _05939_ VGND VGND VPWR VPWR _06054_ sky130_fd_sc_hd__nor2_1
X_11393_ _03955_ _03957_ _03954_ VGND VGND VPWR VPWR _04085_ sky130_fd_sc_hd__o21ba_1
X_10413_ net468 net276 _03011_ _03012_ VGND VGND VPWR VPWR _03014_ sky130_fd_sc_hd__a22o_1
X_13132_ _05971_ _05977_ VGND VGND VPWR VPWR _05979_ sky130_fd_sc_hd__xnor2_2
X_10344_ net562 net74 _02937_ VGND VGND VPWR VPWR _02938_ sky130_fd_sc_hd__nand3_1
XFILLER_124_357 VGND VGND VPWR VPWR sky130_fd_sc_hd__decap_6
XFILLER_124_335 VGND VGND VPWR VPWR sky130_fd_sc_hd__decap_4
XTAP_TAPCELL_ROW_115_1972 VGND VPWR sky130_fd_sc_hd__tapvpwrvgnd_1
XTAP_TAPCELL_ROW_115_1961 VGND VPWR sky130_fd_sc_hd__tapvpwrvgnd_1
X_13063_ net539 net500 net578 net265 VGND VGND VPWR VPWR _05903_ sky130_fd_sc_hd__o2bb2a_1
X_10275_ _02858_ _02862_ VGND VGND VPWR VPWR _02863_ sky130_fd_sc_hd__nand2b_1
X_12014_ _04754_ _04756_ VGND VGND VPWR VPWR _04757_ sky130_fd_sc_hd__or2_1
XFILLER_78_433 VGND VGND VPWR VPWR sky130_fd_sc_hd__fill_2
XFILLER_2_197 VGND VGND VPWR VPWR sky130_fd_sc_hd__fill_1
XFILLER_78_477 VGND VGND VPWR VPWR sky130_fd_sc_hd__decap_6
XFILLER_66_617 VGND VGND VPWR VPWR sky130_fd_sc_hd__decap_4
Xfanout490 net491 VGND VGND VPWR VPWR net490 sky130_fd_sc_hd__clkbuf_2
XFILLER_93_447 VGND VGND VPWR VPWR sky130_fd_sc_hd__fill_1
XFILLER_19_522 VGND VGND VPWR VPWR sky130_fd_sc_hd__decap_6
XFILLER_19_533 VPWR VGND VPWR VGND sky130_ef_sc_hd__decap_12
X_12916_ net555 net422 net408 net564 VGND VGND VPWR VPWR _05742_ sky130_fd_sc_hd__a22oi_1
XFILLER_19_577 VGND VGND VPWR VPWR sky130_fd_sc_hd__fill_1
XFILLER_34_525 VGND VGND VPWR VPWR sky130_fd_sc_hd__fill_1
X_12847_ _05497_ net380 _00231_ VGND VGND VPWR VPWR _05667_ sky130_fd_sc_hd__and3b_1
XFILLER_15_750 VGND VGND VPWR VPWR sky130_fd_sc_hd__decap_4
XFILLER_15_761 VGND VGND VPWR VPWR sky130_fd_sc_hd__fill_2
X_12778_ _05587_ _05590_ VGND VGND VPWR VPWR _05592_ sky130_fd_sc_hd__xnor2_1
XFILLER_61_399 VPWR VGND VPWR VGND sky130_ef_sc_hd__decap_12
X_11729_ _04446_ _04447_ VGND VGND VPWR VPWR _04451_ sky130_fd_sc_hd__xnor2_1
XTAP_TAPCELL_ROW_32_759 VGND VPWR sky130_fd_sc_hd__tapvpwrvgnd_1
XFILLER_9_98 VPWR VGND VPWR VGND sky130_ef_sc_hd__decap_12
XTAP_TAPCELL_ROW_12_472 VGND VPWR sky130_fd_sc_hd__tapvpwrvgnd_1
XFILLER_128_652 VPWR VGND VPWR VGND sky130_ef_sc_hd__decap_12
XTAP_TAPCELL_ROW_77_1422 VGND VPWR sky130_fd_sc_hd__tapvpwrvgnd_1
XTAP_TAPCELL_ROW_77_1411 VGND VPWR sky130_fd_sc_hd__tapvpwrvgnd_1
XFILLER_6_481 VGND VGND VPWR VPWR sky130_fd_sc_hd__fill_1
XTAP_TAPCELL_ROW_90_1600 VGND VPWR sky130_fd_sc_hd__tapvpwrvgnd_1
XFILLER_130_316 VGND VGND VPWR VPWR sky130_fd_sc_hd__fill_1
XFILLER_130_305 VGND VGND VPWR VPWR sky130_fd_sc_hd__decap_3
X_08940_ net497 net349 VGND VGND VPWR VPWR _01412_ sky130_fd_sc_hd__nand2_1
XFILLER_103_519 VPWR VGND VPWR VGND sky130_ef_sc_hd__decap_12
XTAP_TAPCELL_ROW_90_1611 VGND VPWR sky130_fd_sc_hd__tapvpwrvgnd_1
X_08871_ _01334_ _01335_ _01336_ VGND VGND VPWR VPWR _01337_ sky130_fd_sc_hd__and3_4
XFILLER_97_775 VGND VGND VPWR VPWR sky130_fd_sc_hd__decap_8
XFILLER_97_764 VGND VGND VPWR VPWR sky130_fd_sc_hd__decap_4
X_07822_ net689 _00299_ VGND VGND VPWR VPWR _00300_ sky130_fd_sc_hd__and2_1
XFILLER_84_469 VGND VGND VPWR VPWR sky130_fd_sc_hd__decap_6
X_07753_ net460 net452 net662 VGND VGND VPWR VPWR _00232_ sky130_fd_sc_hd__o21ai_2
XTAP_TAPCELL_ROW_88_1573 VGND VPWR sky130_fd_sc_hd__tapvpwrvgnd_1
XFILLER_25_525 VGND VGND VPWR VPWR sky130_fd_sc_hd__decap_8
X_07684_ _00159_ _00162_ VGND VGND VPWR VPWR _00163_ sky130_fd_sc_hd__xnor2_1
X_09423_ _01768_ _01937_ VGND VGND VPWR VPWR _01938_ sky130_fd_sc_hd__xnor2_1
XFILLER_80_642 VGND VGND VPWR VPWR sky130_fd_sc_hd__fill_2
XFILLER_64_193 VGND VGND VPWR VPWR sky130_fd_sc_hd__decap_3
XFILLER_44_29 VPWR VGND VPWR VGND sky130_ef_sc_hd__decap_12
X_09354_ _01698_ _01717_ _01716_ VGND VGND VPWR VPWR _01863_ sky130_fd_sc_hd__o21a_1
XFILLER_52_377 VPWR VGND VPWR VGND sky130_ef_sc_hd__decap_12
XFILLER_13_709 VGND VGND VPWR VPWR sky130_fd_sc_hd__decap_4
X_08305_ _00620_ _00659_ _00658_ VGND VGND VPWR VPWR _00780_ sky130_fd_sc_hd__a21bo_1
XFILLER_138_405 VGND VGND VPWR VPWR sky130_fd_sc_hd__fill_2
X_09285_ _01786_ _01787_ VGND VGND VPWR VPWR _01788_ sky130_fd_sc_hd__xnor2_1
XFILLER_138_449 VGND VGND VPWR VPWR sky130_fd_sc_hd__fill_2
X_08236_ _00579_ _00582_ _00709_ VGND VGND VPWR VPWR _00711_ sky130_fd_sc_hd__and3_1
XFILLER_21_775 VGND VGND VPWR VPWR sky130_fd_sc_hd__decap_8
XFILLER_21_797 VGND VGND VPWR VPWR sky130_fd_sc_hd__decap_4
X_08167_ _00523_ _00531_ _00530_ VGND VGND VPWR VPWR _00643_ sky130_fd_sc_hd__a21o_1
XFILLER_4_407 VPWR VGND VPWR VGND sky130_ef_sc_hd__decap_12
XFILLER_119_685 VPWR VGND VPWR VGND sky130_ef_sc_hd__decap_12
XFILLER_118_173 VGND VGND VPWR VPWR sky130_fd_sc_hd__decap_3
XFILLER_114_7 VPWR VGND VPWR VGND sky130_ef_sc_hd__decap_12
XFILLER_109_55 VGND VGND VPWR VPWR sky130_fd_sc_hd__fill_1
X_07118_ _04591_ _04602_ _04580_ VGND VGND VPWR VPWR _04623_ sky130_fd_sc_hd__o21ai_1
XFILLER_118_195 VGND VGND VPWR VPWR sky130_fd_sc_hd__fill_1
XFILLER_109_77 VGND VGND VPWR VPWR sky130_fd_sc_hd__fill_1
X_08098_ _00573_ _00572_ VGND VGND VPWR VPWR _00574_ sky130_fd_sc_hd__and2b_1
XFILLER_134_699 VGND VGND VPWR VPWR sky130_fd_sc_hd__fill_1
XFILLER_121_305 VGND VGND VPWR VPWR sky130_fd_sc_hd__decap_4
XFILLER_88_720 VPWR VGND VPWR VGND sky130_ef_sc_hd__decap_12
X_07049_ _03751_ _03773_ _03806_ _03850_ VGND VGND VPWR VPWR _03872_ sky130_fd_sc_hd__o211a_1
X_10060_ _02629_ _02631_ VGND VGND VPWR VPWR _02633_ sky130_fd_sc_hd__xnor2_1
XFILLER_121_349 VGND VGND VPWR VPWR sky130_fd_sc_hd__decap_8
XFILLER_0_657 VGND VGND VPWR VPWR sky130_fd_sc_hd__decap_6
XTAP_TAPCELL_ROW_110_1891 VGND VPWR sky130_fd_sc_hd__tapvpwrvgnd_1
XFILLER_48_639 VGND VGND VPWR VPWR sky130_fd_sc_hd__decap_4
XFILLER_85_69 VGND VGND VPWR VPWR sky130_fd_sc_hd__decap_4
XFILLER_75_469 VPWR VGND VPWR VGND sky130_ef_sc_hd__decap_12
XFILLER_18_41 VPWR VGND VPWR VGND sky130_ef_sc_hd__decap_12
XFILLER_90_439 VPWR VGND VPWR VGND sky130_ef_sc_hd__decap_12
XFILLER_55_160 VGND VGND VPWR VPWR sky130_fd_sc_hd__decap_8
XTAP_TAPCELL_ROW_48_1001 VGND VPWR sky130_fd_sc_hd__tapvpwrvgnd_1
XFILLER_16_503 VGND VGND VPWR VPWR sky130_fd_sc_hd__decap_3
XFILLER_18_85 VPWR VGND VPWR VGND sky130_ef_sc_hd__decap_12
X_10962_ net281 net411 VGND VGND VPWR VPWR _03614_ sky130_fd_sc_hd__and2b_1
XTAP_TAPCELL_ROW_39_870 VGND VPWR sky130_fd_sc_hd__tapvpwrvgnd_1
X_12701_ _05506_ _05507_ _05490_ VGND VGND VPWR VPWR _05509_ sky130_fd_sc_hd__a21oi_1
XFILLER_71_664 VGND VGND VPWR VPWR sky130_fd_sc_hd__decap_8
XFILLER_70_141 VGND VGND VPWR VPWR sky130_fd_sc_hd__fill_1
X_10893_ _03536_ _03537_ VGND VGND VPWR VPWR _03538_ sky130_fd_sc_hd__nor2_1
X_13681_ clknet_3_0__leaf_clk _00016_ net715 VGND VGND VPWR VPWR net200 sky130_fd_sc_hd__dfrtp_1
XFILLER_16_569 VGND VGND VPWR VPWR sky130_fd_sc_hd__fill_1
X_12632_ _05430_ _05431_ VGND VGND VPWR VPWR _05433_ sky130_fd_sc_hd__xor2_1
XFILLER_71_697 VPWR VGND VPWR VGND sky130_ef_sc_hd__decap_12
XFILLER_70_174 VGND VGND VPWR VPWR sky130_fd_sc_hd__fill_1
XFILLER_31_539 VGND VGND VPWR VPWR sky130_fd_sc_hd__fill_1
XFILLER_129_416 VGND VGND VPWR VPWR sky130_fd_sc_hd__decap_8
X_12563_ _05178_ _05186_ _05185_ VGND VGND VPWR VPWR _05358_ sky130_fd_sc_hd__a21bo_1
XFILLER_129_449 VPWR VGND VPWR VGND sky130_ef_sc_hd__decap_12
X_12494_ net393 net412 VGND VGND VPWR VPWR _05282_ sky130_fd_sc_hd__and2b_1
XFILLER_11_263 VPWR VGND VPWR VGND sky130_ef_sc_hd__decap_12
X_11514_ _04215_ _04216_ VGND VGND VPWR VPWR _04217_ sky130_fd_sc_hd__xnor2_1
XFILLER_8_757 VPWR VGND VPWR VGND sky130_ef_sc_hd__decap_12
X_11445_ _04116_ _04140_ VGND VGND VPWR VPWR _04142_ sky130_fd_sc_hd__xnor2_1
XFILLER_50_83 VGND VGND VPWR VPWR sky130_fd_sc_hd__fill_1
XTAP_TAPCELL_ROW_59_1152 VGND VPWR sky130_fd_sc_hd__tapvpwrvgnd_1
X_11376_ _04027_ _04064_ VGND VGND VPWR VPWR _04066_ sky130_fd_sc_hd__xnor2_1
XFILLER_124_165 VGND VGND VPWR VPWR sky130_fd_sc_hd__decap_6
XFILLER_98_528 VGND VGND VPWR VPWR sky130_fd_sc_hd__decap_4
X_13115_ _05951_ _05959_ VGND VGND VPWR VPWR _05960_ sky130_fd_sc_hd__xnor2_1
X_10327_ _02913_ _02918_ VGND VGND VPWR VPWR _02919_ sky130_fd_sc_hd__and2_1
XFILLER_105_390 VGND VGND VPWR VPWR sky130_fd_sc_hd__fill_2
X_13046_ _05881_ _05883_ VGND VGND VPWR VPWR _05885_ sky130_fd_sc_hd__and2b_1
XFILLER_79_753 VGND VGND VPWR VPWR sky130_fd_sc_hd__fill_1
XTAP_TAPCELL_ROW_72_1341 VGND VPWR sky130_fd_sc_hd__tapvpwrvgnd_1
X_10258_ net468 net279 VGND VGND VPWR VPWR _02845_ sky130_fd_sc_hd__nand2_1
XFILLER_94_701 VPWR VGND VPWR VGND sky130_ef_sc_hd__decap_12
XFILLER_59_81 VPWR VGND VPWR VGND sky130_ef_sc_hd__decap_12
XFILLER_39_617 VPWR VGND VPWR VGND sky130_ef_sc_hd__decap_12
X_10189_ _02769_ _02772_ VGND VGND VPWR VPWR _02773_ sky130_fd_sc_hd__xnor2_1
XFILLER_120_360 VGND VGND VPWR VPWR sky130_fd_sc_hd__decap_4
XFILLER_94_745 VGND VGND VPWR VPWR sky130_fd_sc_hd__decap_3
XFILLER_66_436 VGND VGND VPWR VPWR sky130_fd_sc_hd__fill_1
XFILLER_93_255 VGND VGND VPWR VPWR sky130_fd_sc_hd__decap_4
XFILLER_93_277 VGND VGND VPWR VPWR sky130_fd_sc_hd__decap_3
XFILLER_81_439 VGND VGND VPWR VPWR sky130_fd_sc_hd__fill_1
XFILLER_53_119 VGND VGND VPWR VPWR sky130_fd_sc_hd__fill_1
XTAP_TAPCELL_ROW_37_829 VGND VPWR sky130_fd_sc_hd__tapvpwrvgnd_1
XFILLER_47_694 VGND VGND VPWR VPWR sky130_fd_sc_hd__decap_8
XFILLER_46_193 VGND VGND VPWR VPWR sky130_fd_sc_hd__decap_3
XFILLER_19_385 VGND VGND VPWR VPWR sky130_fd_sc_hd__decap_6
XFILLER_62_664 VGND VGND VPWR VPWR sky130_fd_sc_hd__decap_3
XTAP_TAPCELL_ROW_17_542 VGND VPWR sky130_fd_sc_hd__tapvpwrvgnd_1
X_09070_ _01552_ _01553_ VGND VGND VPWR VPWR _01554_ sky130_fd_sc_hd__nand2b_1
XFILLER_135_408 VPWR VGND VPWR VGND sky130_ef_sc_hd__decap_12
X_08021_ _00497_ _00471_ VGND VGND VPWR VPWR _00498_ sky130_fd_sc_hd__and2b_1
XFILLER_128_471 VGND VGND VPWR VPWR sky130_fd_sc_hd__fill_2
XPHY_EDGE_ROW_123_Right_123 VGND VGND VPWR VPWR sky130_fd_sc_hd__decap_3
X_09972_ _02415_ _02417_ _02414_ VGND VGND VPWR VPWR _02537_ sky130_fd_sc_hd__o21ba_1
X_08923_ _01391_ _01392_ VGND VGND VPWR VPWR _01393_ sky130_fd_sc_hd__nand2_1
XFILLER_131_669 VGND VGND VPWR VPWR sky130_fd_sc_hd__decap_3
X_08854_ net640 net37 VGND VGND VPWR VPWR _01320_ sky130_fd_sc_hd__nand2_1
XFILLER_69_285 VGND VGND VPWR VPWR sky130_fd_sc_hd__fill_1
X_08785_ _01094_ _01250_ VGND VGND VPWR VPWR _01251_ sky130_fd_sc_hd__nand2_1
XFILLER_111_393 VPWR VGND VPWR VGND sky130_ef_sc_hd__decap_12
XFILLER_85_778 VGND VGND VPWR VPWR sky130_fd_sc_hd__decap_6
X_07805_ _06733_ _00132_ _00131_ VGND VGND VPWR VPWR _00284_ sky130_fd_sc_hd__a21bo_1
XFILLER_45_609 VGND VGND VPWR VPWR sky130_fd_sc_hd__decap_6
X_07736_ _00208_ _00214_ VGND VGND VPWR VPWR _00215_ sky130_fd_sc_hd__xor2_1
XFILLER_53_653 VPWR VGND VPWR VGND sky130_ef_sc_hd__decap_12
XFILLER_52_141 VPWR VGND VPWR VGND sky130_ef_sc_hd__decap_12
XFILLER_25_344 VGND VGND VPWR VPWR sky130_fd_sc_hd__decap_8
X_07667_ _06740_ _06756_ _06754_ VGND VGND VPWR VPWR _00146_ sky130_fd_sc_hd__o21a_1
X_09406_ net345 _01919_ VGND VGND VPWR VPWR _01920_ sky130_fd_sc_hd__and2_1
X_07598_ net442 net665 _00076_ _00077_ VGND VGND VPWR VPWR _00078_ sky130_fd_sc_hd__a22o_1
XFILLER_52_174 VGND VGND VPWR VPWR sky130_fd_sc_hd__fill_1
XFILLER_13_528 VPWR VGND VPWR VGND sky130_ef_sc_hd__decap_12
X_09337_ _01743_ _01843_ _01844_ VGND VGND VPWR VPWR _01845_ sky130_fd_sc_hd__or3_1
X_09268_ _01767_ _01768_ VGND VGND VPWR VPWR _01770_ sky130_fd_sc_hd__xnor2_1
XFILLER_21_561 VGND VGND VPWR VPWR sky130_fd_sc_hd__decap_8
X_08219_ net536 net688 net263 net689 VGND VGND VPWR VPWR _00694_ sky130_fd_sc_hd__o2bb2a_1
X_09199_ net557 net361 _01531_ _01530_ VGND VGND VPWR VPWR _01694_ sky130_fd_sc_hd__a31oi_1
XFILLER_134_441 VPWR VGND VPWR VGND sky130_ef_sc_hd__decap_12
XFILLER_107_644 VGND VGND VPWR VPWR sky130_fd_sc_hd__decap_4
XFILLER_106_132 VGND VGND VPWR VPWR sky130_fd_sc_hd__decap_8
XFILLER_106_110 VGND VGND VPWR VPWR sky130_fd_sc_hd__decap_8
XFILLER_105_3 VPWR VGND VPWR VGND sky130_ef_sc_hd__decap_12
XFILLER_4_237 VGND VGND VPWR VPWR sky130_fd_sc_hd__decap_6
X_11230_ _03900_ _03906_ VGND VGND VPWR VPWR _03907_ sky130_fd_sc_hd__and2_1
XFILLER_136_53 VPWR VGND VPWR VGND sky130_ef_sc_hd__decap_12
XFILLER_122_603 VGND VGND VPWR VPWR sky130_fd_sc_hd__decap_3
XTAP_TAPCELL_ROW_112_1920 VGND VPWR sky130_fd_sc_hd__tapvpwrvgnd_1
XFILLER_106_154 VPWR VGND VPWR VGND sky130_ef_sc_hd__decap_12
XFILLER_20_53 VGND VGND VPWR VPWR sky130_fd_sc_hd__fill_1
X_11161_ net618 net317 net316 net627 VGND VGND VPWR VPWR _03832_ sky130_fd_sc_hd__a22oi_1
XFILLER_122_625 VGND VGND VPWR VPWR sky130_fd_sc_hd__decap_6
XFILLER_121_113 VGND VGND VPWR VPWR sky130_fd_sc_hd__decap_8
X_10112_ _02515_ _02688_ VGND VGND VPWR VPWR _02689_ sky130_fd_sc_hd__nand2b_1
XFILLER_0_421 VGND VGND VPWR VPWR sky130_fd_sc_hd__fill_2
XFILLER_136_97 VPWR VGND VPWR VGND sky130_ef_sc_hd__decap_12
XFILLER_88_561 VGND VGND VPWR VPWR sky130_fd_sc_hd__decap_6
XFILLER_76_701 VPWR VGND VPWR VGND sky130_ef_sc_hd__decap_12
X_11092_ _03752_ _03753_ VGND VGND VPWR VPWR _03756_ sky130_fd_sc_hd__xor2_1
XTAP_TAPCELL_ROW_128_2149 VGND VPWR sky130_fd_sc_hd__tapvpwrvgnd_1
X_10043_ _01768_ _02613_ VGND VGND VPWR VPWR _02614_ sky130_fd_sc_hd__xnor2_1
XFILLER_88_583 VGND VGND VPWR VPWR sky130_fd_sc_hd__decap_4
XFILLER_75_200 VGND VGND VPWR VPWR sky130_fd_sc_hd__decap_6
XTAP_TAPCELL_ROW_54_1082 VGND VPWR sky130_fd_sc_hd__tapvpwrvgnd_1
XFILLER_29_51 VGND VGND VPWR VPWR sky130_fd_sc_hd__decap_4
XFILLER_75_233 VGND VGND VPWR VPWR sky130_fd_sc_hd__decap_3
XFILLER_90_214 VPWR VGND VPWR VGND sky130_ef_sc_hd__decap_12
XFILLER_63_406 VGND VGND VPWR VPWR sky130_fd_sc_hd__decap_6
XFILLER_29_683 VGND VGND VPWR VPWR sky130_fd_sc_hd__fill_1
X_11994_ net594 net583 net695 net679 VGND VGND VPWR VPWR _04736_ sky130_fd_sc_hd__and4_1
XFILLER_44_642 VGND VGND VPWR VPWR sky130_fd_sc_hd__fill_2
XFILLER_44_653 VGND VGND VPWR VPWR sky130_fd_sc_hd__decap_3
X_10945_ net485 net476 net295 net293 VGND VGND VPWR VPWR _03595_ sky130_fd_sc_hd__and4_1
X_13664_ clknet_3_5__leaf_clk _00058_ net719 VGND VGND VPWR VPWR net183 sky130_fd_sc_hd__dfrtp_1
XTAP_TAPCELL_ROW_14_501 VGND VPWR sky130_fd_sc_hd__tapvpwrvgnd_1
X_10876_ _03247_ _03343_ _03342_ VGND VGND VPWR VPWR _03520_ sky130_fd_sc_hd__o21ba_1
X_12615_ net583 net423 _05241_ _05240_ VGND VGND VPWR VPWR _05414_ sky130_fd_sc_hd__a31o_1
X_13595_ _06482_ _06483_ VGND VGND VPWR VPWR _00032_ sky130_fd_sc_hd__xnor2_1
XFILLER_12_572 VGND VGND VPWR VPWR sky130_fd_sc_hd__fill_1
X_12546_ net639 net633 net6 net321 VGND VGND VPWR VPWR _05339_ sky130_fd_sc_hd__nand4_1
XFILLER_129_279 VGND VGND VPWR VPWR sky130_fd_sc_hd__fill_1
X_12477_ _05098_ _05262_ VGND VGND VPWR VPWR _05263_ sky130_fd_sc_hd__xor2_2
XFILLER_125_430 VGND VGND VPWR VPWR sky130_fd_sc_hd__fill_2
XANTENNA_4 net32 VGND VGND VPWR VPWR sky130_fd_sc_hd__diode_2
X_11428_ net314 _00259_ _03987_ _03669_ net636 VGND VGND VPWR VPWR _04124_ sky130_fd_sc_hd__a32o_1
XFILLER_98_314 VPWR VGND VPWR VGND sky130_ef_sc_hd__decap_12
XFILLER_6_77 VGND VGND VPWR VPWR sky130_fd_sc_hd__decap_6
X_11359_ _03925_ _03932_ _03931_ VGND VGND VPWR VPWR _04048_ sky130_fd_sc_hd__a21oi_1
XFILLER_113_625 VPWR VGND VPWR VGND sky130_ef_sc_hd__decap_12
XFILLER_4_793 VPWR VGND VPWR VGND sky130_ef_sc_hd__decap_12
XFILLER_101_809 VGND VGND VPWR VPWR sky130_fd_sc_hd__decap_8
X_13029_ _05863_ _05864_ VGND VGND VPWR VPWR _05867_ sky130_fd_sc_hd__xnor2_1
XPHY_EDGE_ROW_60_Left_199 VGND VGND VPWR VPWR sky130_fd_sc_hd__decap_3
XFILLER_20_3 VPWR VGND VPWR VGND sky130_ef_sc_hd__decap_12
XFILLER_27_609 VGND VGND VPWR VPWR sky130_fd_sc_hd__decap_3
XFILLER_39_436 VGND VGND VPWR VPWR sky130_fd_sc_hd__fill_1
X_08570_ net471 net336 VGND VGND VPWR VPWR _01038_ sky130_fd_sc_hd__nand2_1
XTAP_TAPCELL_ROW_85_1532 VGND VPWR sky130_fd_sc_hd__tapvpwrvgnd_1
XFILLER_81_225 VGND VGND VPWR VPWR sky130_fd_sc_hd__fill_1
XFILLER_47_491 VPWR VGND VPWR VGND sky130_ef_sc_hd__decap_12
XFILLER_35_642 VGND VGND VPWR VPWR sky130_fd_sc_hd__decap_6
X_07521_ _06748_ _06749_ VGND VGND VPWR VPWR _06750_ sky130_fd_sc_hd__nand2_1
XFILLER_62_450 VGND VGND VPWR VPWR sky130_fd_sc_hd__decap_3
XFILLER_19_193 VGND VGND VPWR VPWR sky130_fd_sc_hd__decap_4
XFILLER_90_781 VPWR VGND VPWR VGND sky130_ef_sc_hd__decap_12
X_07452_ net101 net622 _06679_ _06680_ VGND VGND VPWR VPWR _06682_ sky130_fd_sc_hd__nand4_1
XFILLER_34_185 VGND VGND VPWR VPWR sky130_fd_sc_hd__decap_3
XFILLER_50_645 VPWR VGND VPWR VGND sky130_ef_sc_hd__decap_12
X_07383_ _05832_ _06612_ VGND VGND VPWR VPWR _06613_ sky130_fd_sc_hd__xor2_2
X_09122_ net472 net329 VGND VGND VPWR VPWR _01610_ sky130_fd_sc_hd__and2_4
XFILLER_136_717 VPWR VGND VPWR VGND sky130_ef_sc_hd__decap_12
X_09053_ net595 net354 VGND VGND VPWR VPWR _01535_ sky130_fd_sc_hd__nand2_1
XFILLER_135_249 VGND VGND VPWR VPWR sky130_fd_sc_hd__fill_1
X_08004_ _00478_ _00480_ VGND VGND VPWR VPWR _00481_ sky130_fd_sc_hd__nor2_1
XTAP_TAPCELL_ROW_96_1694 VGND VPWR sky130_fd_sc_hd__tapvpwrvgnd_1
Xmax_cap240 _05286_ VGND VGND VPWR VPWR net240 sky130_fd_sc_hd__buf_1
X_09955_ _02511_ _02517_ VGND VGND VPWR VPWR _02518_ sky130_fd_sc_hd__xor2_1
XFILLER_104_669 VPWR VGND VPWR VGND sky130_ef_sc_hd__decap_12
XFILLER_58_701 VGND VGND VPWR VPWR sky130_fd_sc_hd__fill_2
X_08906_ _01247_ _01249_ _01246_ VGND VGND VPWR VPWR _01374_ sky130_fd_sc_hd__o21ba_1
X_09886_ _02028_ _02316_ _02314_ VGND VGND VPWR VPWR _02443_ sky130_fd_sc_hd__a21oi_1
XFILLER_131_488 VPWR VGND VPWR VGND sky130_ef_sc_hd__decap_12
XFILLER_66_27 VGND VGND VPWR VPWR sky130_fd_sc_hd__fill_1
X_08837_ _01300_ _01301_ _01299_ VGND VGND VPWR VPWR _01303_ sky130_fd_sc_hd__o21ai_1
XFILLER_57_233 VGND VGND VPWR VPWR sky130_fd_sc_hd__fill_1
XFILLER_73_726 VGND VGND VPWR VPWR sky130_fd_sc_hd__fill_2
XFILLER_58_789 VGND VGND VPWR VPWR sky130_fd_sc_hd__decap_3
X_08768_ _01233_ _01234_ VGND VGND VPWR VPWR _01235_ sky130_fd_sc_hd__nand2_1
XFILLER_45_439 VGND VGND VPWR VPWR sky130_fd_sc_hd__decap_8
XFILLER_26_620 VGND VGND VPWR VPWR sky130_fd_sc_hd__fill_2
XFILLER_38_491 VPWR VGND VPWR VGND sky130_ef_sc_hd__decap_12
XTAP_TAPCELL_ROW_123_2079 VGND VPWR sky130_fd_sc_hd__tapvpwrvgnd_1
XFILLER_122_77 VGND VGND VPWR VPWR sky130_fd_sc_hd__decap_6
X_08699_ net639 net374 VGND VGND VPWR VPWR _01166_ sky130_fd_sc_hd__and2_1
XFILLER_82_15 VPWR VGND VPWR VGND sky130_ef_sc_hd__decap_12
X_07719_ net513 net505 net678 net676 VGND VGND VPWR VPWR _00198_ sky130_fd_sc_hd__and4_1
XFILLER_53_461 VPWR VGND VPWR VGND sky130_ef_sc_hd__decap_12
XFILLER_41_601 VGND VGND VPWR VPWR sky130_fd_sc_hd__fill_1
XTAP_TAPCELL_ROW_0_284 VGND VPWR sky130_fd_sc_hd__tapvpwrvgnd_1
XTAP_TAPCELL_ROW_0_295 VGND VPWR sky130_fd_sc_hd__tapvpwrvgnd_1
XFILLER_13_303 VPWR VGND VPWR VGND sky130_ef_sc_hd__decap_12
X_10730_ _03208_ _03244_ _03246_ VGND VGND VPWR VPWR _03360_ sky130_fd_sc_hd__a21oi_1
X_10661_ net426 net281 net280 net435 VGND VGND VPWR VPWR _03285_ sky130_fd_sc_hd__a22o_1
X_12400_ net653 net645 net321 net303 VGND VGND VPWR VPWR _05180_ sky130_fd_sc_hd__and4_1
XFILLER_127_706 VGND VGND VPWR VPWR sky130_fd_sc_hd__decap_8
X_13380_ _06128_ _06134_ _06136_ VGND VGND VPWR VPWR _06250_ sky130_fd_sc_hd__a21o_1
X_10592_ net553 net309 VGND VGND VPWR VPWR _03209_ sky130_fd_sc_hd__nand2_1
XFILLER_126_216 VGND VGND VPWR VPWR sky130_fd_sc_hd__decap_3
X_12331_ _04812_ _04960_ _05103_ VGND VGND VPWR VPWR _05104_ sky130_fd_sc_hd__a21oi_1
X_12262_ _05026_ _05027_ _05025_ VGND VGND VPWR VPWR _05029_ sky130_fd_sc_hd__o21ai_1
XFILLER_135_783 VGND VGND VPWR VPWR sky130_fd_sc_hd__fill_1
XTAP_TAPCELL_ROW_56_1111 VGND VPWR sky130_fd_sc_hd__tapvpwrvgnd_1
XFILLER_5_557 VGND VGND VPWR VPWR sky130_fd_sc_hd__decap_3
X_11213_ _03722_ _03724_ _03721_ VGND VGND VPWR VPWR _03888_ sky130_fd_sc_hd__o21ba_1
XFILLER_134_293 VGND VGND VPWR VPWR sky130_fd_sc_hd__decap_6
X_12193_ _04951_ _04952_ VGND VGND VPWR VPWR _04953_ sky130_fd_sc_hd__and2b_1
XFILLER_1_741 VPWR VGND VPWR VGND sky130_ef_sc_hd__decap_12
X_11144_ _03811_ _03812_ VGND VGND VPWR VPWR _03813_ sky130_fd_sc_hd__or2_1
XFILLER_122_477 VGND VGND VPWR VPWR sky130_fd_sc_hd__decap_8
XFILLER_110_639 VGND VGND VPWR VPWR sky130_fd_sc_hd__decap_4
XFILLER_49_701 VGND VGND VPWR VPWR sky130_fd_sc_hd__fill_1
X_11075_ _03734_ _03735_ VGND VGND VPWR VPWR _03737_ sky130_fd_sc_hd__xor2_1
XFILLER_0_273 VGND VGND VPWR VPWR sky130_fd_sc_hd__decap_3
XFILLER_1_785 VPWR VGND VPWR VGND sky130_ef_sc_hd__decap_12
X_10026_ _02593_ _02594_ VGND VGND VPWR VPWR _02595_ sky130_fd_sc_hd__nor2_1
XFILLER_76_542 VGND VGND VPWR VPWR sky130_fd_sc_hd__decap_8
Xinput141 x1[3] VGND VGND VPWR VPWR net141 sky130_fd_sc_hd__buf_2
Xinput152 x2[6] VGND VGND VPWR VPWR net152 sky130_fd_sc_hd__clkbuf_1
Xinput130 x0[0] VGND VGND VPWR VPWR net130 sky130_fd_sc_hd__clkbuf_2
XFILLER_36_417 VGND VGND VPWR VPWR sky130_fd_sc_hd__decap_3
XFILLER_63_225 VGND VGND VPWR VPWR sky130_fd_sc_hd__decap_3
X_11977_ net462 net454 net26 net392 VGND VGND VPWR VPWR _04717_ sky130_fd_sc_hd__and4_1
XFILLER_63_269 VGND VGND VPWR VPWR sky130_fd_sc_hd__decap_8
XTAP_TAPCELL_ROW_47_979 VGND VPWR sky130_fd_sc_hd__tapvpwrvgnd_1
XFILLER_16_141 VGND VGND VPWR VPWR sky130_fd_sc_hd__decap_6
XFILLER_72_781 VPWR VGND VPWR VGND sky130_ef_sc_hd__decap_12
XTAP_TAPCELL_ROW_67_1273 VGND VPWR sky130_fd_sc_hd__tapvpwrvgnd_1
X_10928_ _03569_ _03574_ VGND VGND VPWR VPWR _03577_ sky130_fd_sc_hd__nand2b_1
XFILLER_16_174 VGND VGND VPWR VPWR sky130_fd_sc_hd__fill_1
XTAP_TAPCELL_ROW_27_692 VGND VPWR sky130_fd_sc_hd__tapvpwrvgnd_1
XFILLER_31_122 VPWR VGND VPWR VGND sky130_ef_sc_hd__decap_12
X_13647_ clknet_3_5__leaf_clk _00030_ net719 VGND VGND VPWR VPWR net166 sky130_fd_sc_hd__dfrtp_1
XTAP_TAPCELL_ROW_80_1462 VGND VPWR sky130_fd_sc_hd__tapvpwrvgnd_1
XFILLER_72_92 VPWR VGND VPWR VGND sky130_ef_sc_hd__decap_12
XFILLER_31_144 VPWR VGND VPWR VGND sky130_ef_sc_hd__decap_12
X_10859_ _03487_ _03501_ VGND VGND VPWR VPWR _03502_ sky130_fd_sc_hd__nor2_1
X_13578_ _06355_ _06357_ _06391_ VGND VGND VPWR VPWR _06466_ sky130_fd_sc_hd__o21a_1
XFILLER_31_188 VGND VGND VPWR VPWR sky130_fd_sc_hd__fill_1
XFILLER_117_216 VGND VGND VPWR VPWR sky130_fd_sc_hd__decap_8
X_12529_ _05316_ _05317_ _05320_ VGND VGND VPWR VPWR _05321_ sky130_fd_sc_hd__a21o_1
XFILLER_68_3 VPWR VGND VPWR VGND sky130_ef_sc_hd__decap_12
Xfanout308 net77 VGND VGND VPWR VPWR net308 sky130_fd_sc_hd__buf_2
Xfanout319 net70 VGND VGND VPWR VPWR net319 sky130_fd_sc_hd__clkbuf_4
X_09740_ net606 net370 VGND VGND VPWR VPWR _02285_ sky130_fd_sc_hd__nand2_1
XFILLER_98_166 VGND VGND VPWR VPWR sky130_fd_sc_hd__decap_8
XFILLER_86_328 VPWR VGND VPWR VGND sky130_ef_sc_hd__decap_12
X_06952_ _02684_ _02771_ VGND VGND VPWR VPWR _02812_ sky130_fd_sc_hd__xnor2_1
.ends
